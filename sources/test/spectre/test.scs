simulator lang=spectre

* Example test netlist

* Include external model files if needed
* include "../models/mydevices.scs"

* DC voltage source
V1 (n1 0) vsource dc=1.8

* Simple resistor
R1 (n1 n2) resistor 10k

* Two capacitors with different notations
C0 (n2 0) capacitor 5e-13f
C1 (n2 n3) capacitor 1e-12 2e-13 3e-14

* Example model assignment
model myCap capacitor tc1=0.025 m=2

* Transient analysis
tran stop=10ns
