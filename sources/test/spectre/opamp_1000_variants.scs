subckt OPAMP1_variant1 inn inp out pd xpd vdda vssa
	xd1 (vssa vdda) prim_nwd AREA=6.13907e-9 PJ=476.6e-6 m=1
	xi0 (vssa net69) prim_nd AREA=1e-12 PJ=4e-6 m=1
	xi3 (net51 vdda) prim_pd AREA=790e-15 PJ=3.3e-6 m=1
	xr0 (vssa vdda net51) prim_rdiffp l=1.3e-07 w=1.9e-06 m=1
	xr1 (vdda vdda net69) prim_rdiffp l=2.1e-6 w=700e-9 m=1
	xcc01 (net12 out) prim_cpoly c=1.7e-12p m=1
	mnm12 (net13 net56 vssa vssa) nmos1 l=180n w=1u m=1
	mnm11 (net56 net56 vssa vssa) nmos1 l=180n w=1u m=1
	mnb02 (net27 net27 net21 vssa) nmos1 l=180n w=1u m=1
	mnpd1 (net21 xpd vssa vssa) nmos1 l=1.9e-07n w=5.5e-07u m=1
	mn001 (out net13 vssa vssa) nmos1 l=180n w=1u m=1
	mnpd2 (net13 pd vssa vssa) nmos1 l=180n w=1u m=1
	mnc01 (net13 net69 net12 vssa) nmos1 l=180n w=1u m=1
	mpb02 (net27 net51 net158 vdda) pmos1 l=180n w=1u m=1
	mppd1 (net158 xpd vdda vdda) pmos1 l=180n w=1u m=1
	mps11 (net31 net158 vdda vdda) pmos1 l=180n w=1u m=1
	mpd11 (net56 inn net31 net31) pmos1 l=180n w=1u m=1
	mp001 (out net158 vdda vdda) pmos1 l=1.6e-07n w=1.3e-06u m=1
	mpd12 (net13 inp net31 net31) pmos1 l=180n w=1u m=1
	mpb01 (net158 net158 vdda vdda) pmos1 l=180n w=1u m=1
ends OPAMP1_variant1

subckt OPAMP1_variant2 inn inp out pd xpd vdda vssa
	xd1 (vssa vdda) prim_nwd AREA=6.0e-09 PJ=4.7e-05 m=1
	xi0 (vssa net69) prim_nd AREA=1e-12 PJ=4e-6 m=1
	xi3 (net51 vdda) prim_pd AREA=790e-15 PJ=3.3e-6 m=1
	xr0 (vssa vdda net51) prim_rdiffp l=2.1e-6 w=700e-9 m=1
	xr1 (vdda vdda net69) prim_rdiffp l=2.0e-07 w=1.2e-06 m=1
	xcc01 (net12 out) prim_cpoly c=1p m=1
	mnm12 (net13 net56 vssa vssa) nmos1 l=180n w=1u m=1
	mnm11 (net56 net56 vssa vssa) nmos1 l=180n w=1u m=1
	mnb02 (net27 net27 net21 vssa) nmos1 l=180n w=1u m=1
	mnpd1 (net21 xpd vssa vssa) nmos1 l=180n w=1u m=1
	mn001 (out net13 vssa vssa) nmos1 l=180n w=1u m=1
	mnpd2 (net13 pd vssa vssa) nmos1 l=180n w=1u m=1
	mnc01 (net13 net69 net12 vssa) nmos1 l=180n w=1u m=1
	mpb02 (net27 net51 net158 vdda) pmos1 l=180n w=1u m=1
	mppd1 (net158 xpd vdda vdda) pmos1 l=2.5e-07n w=5.1e-07u m=1
	mps11 (net31 net158 vdda vdda) pmos1 l=180n w=1u m=1
	mpd11 (net56 inn net31 net31) pmos1 l=180n w=1u m=1
	mp001 (out net158 vdda vdda) pmos1 l=180n w=1u m=1
	mpd12 (net13 inp net31 net31) pmos1 l=2.5e-07n w=6.8e-07u m=1
	mpb01 (net158 net158 vdda vdda) pmos1 l=1.4e-07n w=1.5e-06u m=1
ends OPAMP1_variant2

subckt OPAMP1_variant3 inn inp out pd xpd vdda vssa
	xd1 (vssa vdda) prim_nwd AREA=6.13907e-9 PJ=476.6e-6 m=1
	xi0 (vssa net69) prim_nd AREA=1e-12 PJ=4e-6 m=1
	xi3 (net51 vdda) prim_pd AREA=790e-15 PJ=3.3e-6 m=1
	xr0 (vssa vdda net51) prim_rdiffp l=1.1e-07 w=1.3e-06 m=1
	xr1 (vdda vdda net69) prim_rdiffp l=2.1e-6 w=700e-9 m=1
	xcc01 (net12 out) prim_cpoly c=1p m=1
	mnm12 (net13 net56 vssa vssa) nmos1 l=180n w=1u m=1
	mnm11 (net56 net56 vssa vssa) nmos1 l=180n w=1u m=1
	mnb02 (net27 net27 net21 vssa) nmos1 l=180n w=1u m=1
	mnpd1 (net21 xpd vssa vssa) nmos1 l=180n w=1u m=1
	mn001 (out net13 vssa vssa) nmos1 l=180n w=1u m=1
	mnpd2 (net13 pd vssa vssa) nmos1 l=180n w=1u m=1
	mnc01 (net13 net69 net12 vssa) nmos1 l=180n w=1u m=1
	mpb02 (net27 net51 net158 vdda) pmos1 l=180n w=1u m=1
	mppd1 (net158 xpd vdda vdda) pmos1 l=180n w=1u m=1
	mps11 (net31 net158 vdda vdda) pmos1 l=180n w=1u m=1
	mpd11 (net56 inn net31 net31) pmos1 l=180n w=1u m=1
	mp001 (out net158 vdda vdda) pmos1 l=180n w=1u m=1
	mpd12 (net13 inp net31 net31) pmos1 l=180n w=1u m=1
	mpb01 (net158 net158 vdda vdda) pmos1 l=2.9e-07n w=5.8e-07u m=1
ends OPAMP1_variant3

subckt OPAMP1_variant4 inn inp out pd xpd vdda vssa
	xd1 (vssa vdda) prim_nwd AREA=6.13907e-9 PJ=476.6e-6 m=1
	xi0 (vssa net69) prim_nd AREA=4.2e-09 PJ=9.5e-05 m=1
	xi3 (net51 vdda) prim_pd AREA=9.5e-09 PJ=2.9e-05 m=1
	xr0 (vssa vdda net51) prim_rdiffp l=2.1e-6 w=700e-9 m=1
	xr1 (vdda vdda net69) prim_rdiffp l=2.1e-6 w=700e-9 m=1
	xcc01 (net12 out) prim_cpoly c=1p m=1
	mnm12 (net13 net56 vssa vssa) nmos1 l=3.0e-07n w=7.2e-07u m=1
	mnm11 (net56 net56 vssa vssa) nmos1 l=180n w=1u m=1
	mnb02 (net27 net27 net21 vssa) nmos1 l=180n w=1u m=1
	mnpd1 (net21 xpd vssa vssa) nmos1 l=180n w=1u m=1
	mn001 (out net13 vssa vssa) nmos1 l=180n w=1u m=1
	mnpd2 (net13 pd vssa vssa) nmos1 l=180n w=1u m=1
	mnc01 (net13 net69 net12 vssa) nmos1 l=180n w=1u m=1
	mpb02 (net27 net51 net158 vdda) pmos1 l=180n w=1u m=1
	mppd1 (net158 xpd vdda vdda) pmos1 l=180n w=1u m=1
	mps11 (net31 net158 vdda vdda) pmos1 l=2.6e-07n w=5.3e-07u m=1
	mpd11 (net56 inn net31 net31) pmos1 l=2.5e-07n w=2.0e-06u m=1
	mp001 (out net158 vdda vdda) pmos1 l=180n w=1u m=1
	mpd12 (net13 inp net31 net31) pmos1 l=180n w=1u m=1
	mpb01 (net158 net158 vdda vdda) pmos1 l=180n w=1u m=1
ends OPAMP1_variant4

subckt OPAMP1_variant5 inn inp out pd xpd vdda vssa
	xd1 (vssa vdda) prim_nwd AREA=6.13907e-9 PJ=476.6e-6 m=1
	xi0 (vssa net69) prim_nd AREA=1e-12 PJ=4e-6 m=1
	xi3 (net51 vdda) prim_pd AREA=790e-15 PJ=3.3e-6 m=1
	xr0 (vssa vdda net51) prim_rdiffp l=2.0e-07 w=1.9e-06 m=1
	xr1 (vdda vdda net69) prim_rdiffp l=2.1e-6 w=700e-9 m=1
	xcc01 (net12 out) prim_cpoly c=1p m=1
	mnm12 (net13 net56 vssa vssa) nmos1 l=180n w=1u m=1
	mnm11 (net56 net56 vssa vssa) nmos1 l=2.8e-07n w=1.1e-06u m=1
	mnb02 (net27 net27 net21 vssa) nmos1 l=180n w=1u m=1
	mnpd1 (net21 xpd vssa vssa) nmos1 l=180n w=1u m=1
	mn001 (out net13 vssa vssa) nmos1 l=180n w=1u m=1
	mnpd2 (net13 pd vssa vssa) nmos1 l=180n w=1u m=1
	mnc01 (net13 net69 net12 vssa) nmos1 l=180n w=1u m=1
	mpb02 (net27 net51 net158 vdda) pmos1 l=1.3e-07n w=1.4e-06u m=1
	mppd1 (net158 xpd vdda vdda) pmos1 l=180n w=1u m=1
	mps11 (net31 net158 vdda vdda) pmos1 l=1.2e-07n w=6.5e-07u m=1
	mpd11 (net56 inn net31 net31) pmos1 l=180n w=1u m=1
	mp001 (out net158 vdda vdda) pmos1 l=180n w=1u m=1
	mpd12 (net13 inp net31 net31) pmos1 l=180n w=1u m=1
	mpb01 (net158 net158 vdda vdda) pmos1 l=3.0e-07n w=6.8e-07u m=1
ends OPAMP1_variant5

subckt OPAMP1_variant6 inn inp out pd xpd vdda vssa
	xd1 (vssa vdda) prim_nwd AREA=6.13907e-9 PJ=476.6e-6 m=1
	xi0 (vssa net69) prim_nd AREA=1e-12 PJ=4e-6 m=1
	xi3 (net51 vdda) prim_pd AREA=790e-15 PJ=3.3e-6 m=1
	xr0 (vssa vdda net51) prim_rdiffp l=2.1e-6 w=700e-9 m=1
	xr1 (vdda vdda net69) prim_rdiffp l=2.1e-6 w=700e-9 m=1
	xcc01 (net12 out) prim_cpoly c=1.0e-12p m=1
	mnm12 (net13 net56 vssa vssa) nmos1 l=180n w=1u m=1
	mnm11 (net56 net56 vssa vssa) nmos1 l=180n w=1u m=1
	mnb02 (net27 net27 net21 vssa) nmos1 l=2.7e-07n w=9.0e-07u m=1
	mnpd1 (net21 xpd vssa vssa) nmos1 l=180n w=1u m=1
	mn001 (out net13 vssa vssa) nmos1 l=180n w=1u m=1
	mnpd2 (net13 pd vssa vssa) nmos1 l=180n w=1u m=1
	mnc01 (net13 net69 net12 vssa) nmos1 l=2.5e-07n w=6.2e-07u m=1
	mpb02 (net27 net51 net158 vdda) pmos1 l=180n w=1u m=1
	mppd1 (net158 xpd vdda vdda) pmos1 l=180n w=1u m=1
	mps11 (net31 net158 vdda vdda) pmos1 l=180n w=1u m=1
	mpd11 (net56 inn net31 net31) pmos1 l=1.6e-07n w=1.1e-06u m=1
	mp001 (out net158 vdda vdda) pmos1 l=180n w=1u m=1
	mpd12 (net13 inp net31 net31) pmos1 l=180n w=1u m=1
	mpb01 (net158 net158 vdda vdda) pmos1 l=180n w=1u m=1
ends OPAMP1_variant6

subckt OPAMP1_variant7 inn inp out pd xpd vdda vssa
	xd1 (vssa vdda) prim_nwd AREA=6.13907e-9 PJ=476.6e-6 m=1
	xi0 (vssa net69) prim_nd AREA=8.1e-09 PJ=9.1e-05 m=1
	xi3 (net51 vdda) prim_pd AREA=790e-15 PJ=3.3e-6 m=1
	xr0 (vssa vdda net51) prim_rdiffp l=2.1e-6 w=700e-9 m=1
	xr1 (vdda vdda net69) prim_rdiffp l=2.1e-6 w=700e-9 m=1
	xcc01 (net12 out) prim_cpoly c=1.3e-12p m=1
	mnm12 (net13 net56 vssa vssa) nmos1 l=180n w=1u m=1
	mnm11 (net56 net56 vssa vssa) nmos1 l=180n w=1u m=1
	mnb02 (net27 net27 net21 vssa) nmos1 l=180n w=1u m=1
	mnpd1 (net21 xpd vssa vssa) nmos1 l=180n w=1u m=1
	mn001 (out net13 vssa vssa) nmos1 l=180n w=1u m=1
	mnpd2 (net13 pd vssa vssa) nmos1 l=180n w=1u m=1
	mnc01 (net13 net69 net12 vssa) nmos1 l=180n w=1u m=1
	mpb02 (net27 net51 net158 vdda) pmos1 l=180n w=1u m=1
	mppd1 (net158 xpd vdda vdda) pmos1 l=180n w=1u m=1
	mps11 (net31 net158 vdda vdda) pmos1 l=180n w=1u m=1
	mpd11 (net56 inn net31 net31) pmos1 l=180n w=1u m=1
	mp001 (out net158 vdda vdda) pmos1 l=180n w=1u m=1
	mpd12 (net13 inp net31 net31) pmos1 l=180n w=1u m=1
	mpb01 (net158 net158 vdda vdda) pmos1 l=180n w=1u m=1
ends OPAMP1_variant7

subckt OPAMP1_variant8 inn inp out pd xpd vdda vssa
	xd1 (vssa vdda) prim_nwd AREA=8.4e-09 PJ=1.7e-05 m=1
	xi0 (vssa net69) prim_nd AREA=1e-12 PJ=4e-6 m=1
	xi3 (net51 vdda) prim_pd AREA=790e-15 PJ=3.3e-6 m=1
	xr0 (vssa vdda net51) prim_rdiffp l=2.1e-6 w=700e-9 m=1
	xr1 (vdda vdda net69) prim_rdiffp l=2.1e-6 w=700e-9 m=1
	xcc01 (net12 out) prim_cpoly c=5.7e-13p m=1
	mnm12 (net13 net56 vssa vssa) nmos1 l=180n w=1u m=1
	mnm11 (net56 net56 vssa vssa) nmos1 l=180n w=1u m=1
	mnb02 (net27 net27 net21 vssa) nmos1 l=180n w=1u m=1
	mnpd1 (net21 xpd vssa vssa) nmos1 l=180n w=1u m=1
	mn001 (out net13 vssa vssa) nmos1 l=180n w=1u m=1
	mnpd2 (net13 pd vssa vssa) nmos1 l=180n w=1u m=1
	mnc01 (net13 net69 net12 vssa) nmos1 l=180n w=1u m=1
	mpb02 (net27 net51 net158 vdda) pmos1 l=180n w=1u m=1
	mppd1 (net158 xpd vdda vdda) pmos1 l=2.6e-07n w=1.5e-06u m=1
	mps11 (net31 net158 vdda vdda) pmos1 l=180n w=1u m=1
	mpd11 (net56 inn net31 net31) pmos1 l=180n w=1u m=1
	mp001 (out net158 vdda vdda) pmos1 l=180n w=1u m=1
	mpd12 (net13 inp net31 net31) pmos1 l=180n w=1u m=1
	mpb01 (net158 net158 vdda vdda) pmos1 l=180n w=1u m=1
ends OPAMP1_variant8

subckt OPAMP1_variant9 inn inp out pd xpd vdda vssa
	xd1 (vssa vdda) prim_nwd AREA=7.4e-09 PJ=3.3e-05 m=1
	xi0 (vssa net69) prim_nd AREA=1e-12 PJ=4e-6 m=1
	xi3 (net51 vdda) prim_pd AREA=2.5e-09 PJ=2.7e-05 m=1
	xr0 (vssa vdda net51) prim_rdiffp l=2.1e-6 w=700e-9 m=1
	xr1 (vdda vdda net69) prim_rdiffp l=2.1e-6 w=700e-9 m=1
	xcc01 (net12 out) prim_cpoly c=1p m=1
	mnm12 (net13 net56 vssa vssa) nmos1 l=1.0e-07n w=6.2e-07u m=1
	mnm11 (net56 net56 vssa vssa) nmos1 l=180n w=1u m=1
	mnb02 (net27 net27 net21 vssa) nmos1 l=180n w=1u m=1
	mnpd1 (net21 xpd vssa vssa) nmos1 l=180n w=1u m=1
	mn001 (out net13 vssa vssa) nmos1 l=180n w=1u m=1
	mnpd2 (net13 pd vssa vssa) nmos1 l=2.7e-07n w=1.5e-06u m=1
	mnc01 (net13 net69 net12 vssa) nmos1 l=180n w=1u m=1
	mpb02 (net27 net51 net158 vdda) pmos1 l=180n w=1u m=1
	mppd1 (net158 xpd vdda vdda) pmos1 l=180n w=1u m=1
	mps11 (net31 net158 vdda vdda) pmos1 l=180n w=1u m=1
	mpd11 (net56 inn net31 net31) pmos1 l=180n w=1u m=1
	mp001 (out net158 vdda vdda) pmos1 l=180n w=1u m=1
	mpd12 (net13 inp net31 net31) pmos1 l=180n w=1u m=1
	mpb01 (net158 net158 vdda vdda) pmos1 l=180n w=1u m=1
ends OPAMP1_variant9

subckt OPAMP1_variant10 inn inp out pd xpd vdda vssa
	xd1 (vssa vdda) prim_nwd AREA=6.13907e-9 PJ=476.6e-6 m=1
	xi0 (vssa net69) prim_nd AREA=1e-12 PJ=4e-6 m=1
	xi3 (net51 vdda) prim_pd AREA=1.0e-08 PJ=4.1e-05 m=1
	xr0 (vssa vdda net51) prim_rdiffp l=2.1e-6 w=700e-9 m=1
	xr1 (vdda vdda net69) prim_rdiffp l=2.1e-6 w=700e-9 m=1
	xcc01 (net12 out) prim_cpoly c=1p m=1
	mnm12 (net13 net56 vssa vssa) nmos1 l=180n w=1u m=1
	mnm11 (net56 net56 vssa vssa) nmos1 l=180n w=1u m=1
	mnb02 (net27 net27 net21 vssa) nmos1 l=180n w=1u m=1
	mnpd1 (net21 xpd vssa vssa) nmos1 l=180n w=1u m=1
	mn001 (out net13 vssa vssa) nmos1 l=180n w=1u m=1
	mnpd2 (net13 pd vssa vssa) nmos1 l=180n w=1u m=1
	mnc01 (net13 net69 net12 vssa) nmos1 l=2.8e-07n w=1.2e-06u m=1
	mpb02 (net27 net51 net158 vdda) pmos1 l=180n w=1u m=1
	mppd1 (net158 xpd vdda vdda) pmos1 l=180n w=1u m=1
	mps11 (net31 net158 vdda vdda) pmos1 l=1.5e-07n w=1.1e-06u m=1
	mpd11 (net56 inn net31 net31) pmos1 l=180n w=1u m=1
	mp001 (out net158 vdda vdda) pmos1 l=2.3e-07n w=1.3e-06u m=1
	mpd12 (net13 inp net31 net31) pmos1 l=180n w=1u m=1
	mpb01 (net158 net158 vdda vdda) pmos1 l=180n w=1u m=1
ends OPAMP1_variant10

subckt OPAMP1_variant11 inn inp out pd xpd vdda vssa
	xd1 (vssa vdda) prim_nwd AREA=6.13907e-9 PJ=476.6e-6 m=1
	xi0 (vssa net69) prim_nd AREA=1e-12 PJ=4e-6 m=1
	xi3 (net51 vdda) prim_pd AREA=790e-15 PJ=3.3e-6 m=1
	xr0 (vssa vdda net51) prim_rdiffp l=1.4e-07 w=6.3e-07 m=1
	xr1 (vdda vdda net69) prim_rdiffp l=2.1e-6 w=700e-9 m=1
	xcc01 (net12 out) prim_cpoly c=1p m=1
	mnm12 (net13 net56 vssa vssa) nmos1 l=180n w=1u m=1
	mnm11 (net56 net56 vssa vssa) nmos1 l=180n w=1u m=1
	mnb02 (net27 net27 net21 vssa) nmos1 l=180n w=1u m=1
	mnpd1 (net21 xpd vssa vssa) nmos1 l=180n w=1u m=1
	mn001 (out net13 vssa vssa) nmos1 l=180n w=1u m=1
	mnpd2 (net13 pd vssa vssa) nmos1 l=1.8e-07n w=1.1e-06u m=1
	mnc01 (net13 net69 net12 vssa) nmos1 l=180n w=1u m=1
	mpb02 (net27 net51 net158 vdda) pmos1 l=180n w=1u m=1
	mppd1 (net158 xpd vdda vdda) pmos1 l=180n w=1u m=1
	mps11 (net31 net158 vdda vdda) pmos1 l=180n w=1u m=1
	mpd11 (net56 inn net31 net31) pmos1 l=2.0e-07n w=1.6e-06u m=1
	mp001 (out net158 vdda vdda) pmos1 l=180n w=1u m=1
	mpd12 (net13 inp net31 net31) pmos1 l=180n w=1u m=1
	mpb01 (net158 net158 vdda vdda) pmos1 l=180n w=1u m=1
ends OPAMP1_variant11

subckt OPAMP1_variant12 inn inp out pd xpd vdda vssa
	xd1 (vssa vdda) prim_nwd AREA=6.13907e-9 PJ=476.6e-6 m=1
	xi0 (vssa net69) prim_nd AREA=1e-12 PJ=4e-6 m=1
	xi3 (net51 vdda) prim_pd AREA=790e-15 PJ=3.3e-6 m=1
	xr0 (vssa vdda net51) prim_rdiffp l=2.7e-07 w=1.0e-06 m=1
	xr1 (vdda vdda net69) prim_rdiffp l=1.3e-07 w=7.0e-07 m=1
	xcc01 (net12 out) prim_cpoly c=1p m=1
	mnm12 (net13 net56 vssa vssa) nmos1 l=180n w=1u m=1
	mnm11 (net56 net56 vssa vssa) nmos1 l=180n w=1u m=1
	mnb02 (net27 net27 net21 vssa) nmos1 l=180n w=1u m=1
	mnpd1 (net21 xpd vssa vssa) nmos1 l=180n w=1u m=1
	mn001 (out net13 vssa vssa) nmos1 l=180n w=1u m=1
	mnpd2 (net13 pd vssa vssa) nmos1 l=180n w=1u m=1
	mnc01 (net13 net69 net12 vssa) nmos1 l=180n w=1u m=1
	mpb02 (net27 net51 net158 vdda) pmos1 l=180n w=1u m=1
	mppd1 (net158 xpd vdda vdda) pmos1 l=180n w=1u m=1
	mps11 (net31 net158 vdda vdda) pmos1 l=1.6e-07n w=1.8e-06u m=1
	mpd11 (net56 inn net31 net31) pmos1 l=180n w=1u m=1
	mp001 (out net158 vdda vdda) pmos1 l=2.0e-07n w=5.1e-07u m=1
	mpd12 (net13 inp net31 net31) pmos1 l=180n w=1u m=1
	mpb01 (net158 net158 vdda vdda) pmos1 l=180n w=1u m=1
ends OPAMP1_variant12

subckt OPAMP1_variant13 inn inp out pd xpd vdda vssa
	xd1 (vssa vdda) prim_nwd AREA=6.13907e-9 PJ=476.6e-6 m=1
	xi0 (vssa net69) prim_nd AREA=1e-12 PJ=4e-6 m=1
	xi3 (net51 vdda) prim_pd AREA=790e-15 PJ=3.3e-6 m=1
	xr0 (vssa vdda net51) prim_rdiffp l=2.1e-6 w=700e-9 m=1
	xr1 (vdda vdda net69) prim_rdiffp l=2.1e-6 w=700e-9 m=1
	xcc01 (net12 out) prim_cpoly c=1p m=1
	mnm12 (net13 net56 vssa vssa) nmos1 l=1.7e-07n w=9.2e-07u m=1
	mnm11 (net56 net56 vssa vssa) nmos1 l=180n w=1u m=1
	mnb02 (net27 net27 net21 vssa) nmos1 l=180n w=1u m=1
	mnpd1 (net21 xpd vssa vssa) nmos1 l=180n w=1u m=1
	mn001 (out net13 vssa vssa) nmos1 l=180n w=1u m=1
	mnpd2 (net13 pd vssa vssa) nmos1 l=180n w=1u m=1
	mnc01 (net13 net69 net12 vssa) nmos1 l=2.1e-07n w=7.3e-07u m=1
	mpb02 (net27 net51 net158 vdda) pmos1 l=180n w=1u m=1
	mppd1 (net158 xpd vdda vdda) pmos1 l=1.5e-07n w=6.5e-07u m=1
	mps11 (net31 net158 vdda vdda) pmos1 l=180n w=1u m=1
	mpd11 (net56 inn net31 net31) pmos1 l=180n w=1u m=1
	mp001 (out net158 vdda vdda) pmos1 l=180n w=1u m=1
	mpd12 (net13 inp net31 net31) pmos1 l=180n w=1u m=1
	mpb01 (net158 net158 vdda vdda) pmos1 l=180n w=1u m=1
ends OPAMP1_variant13

subckt OPAMP1_variant14 inn inp out pd xpd vdda vssa
	xd1 (vssa vdda) prim_nwd AREA=6.13907e-9 PJ=476.6e-6 m=1
	xi0 (vssa net69) prim_nd AREA=1e-12 PJ=4e-6 m=1
	xi3 (net51 vdda) prim_pd AREA=790e-15 PJ=3.3e-6 m=1
	xr0 (vssa vdda net51) prim_rdiffp l=2.1e-6 w=700e-9 m=1
	xr1 (vdda vdda net69) prim_rdiffp l=2.1e-6 w=700e-9 m=1
	xcc01 (net12 out) prim_cpoly c=1p m=1
	mnm12 (net13 net56 vssa vssa) nmos1 l=180n w=1u m=1
	mnm11 (net56 net56 vssa vssa) nmos1 l=180n w=1u m=1
	mnb02 (net27 net27 net21 vssa) nmos1 l=180n w=1u m=1
	mnpd1 (net21 xpd vssa vssa) nmos1 l=180n w=1u m=1
	mn001 (out net13 vssa vssa) nmos1 l=1.1e-07n w=5.6e-07u m=1
	mnpd2 (net13 pd vssa vssa) nmos1 l=180n w=1u m=1
	mnc01 (net13 net69 net12 vssa) nmos1 l=1.1e-07n w=9.6e-07u m=1
	mpb02 (net27 net51 net158 vdda) pmos1 l=180n w=1u m=1
	mppd1 (net158 xpd vdda vdda) pmos1 l=180n w=1u m=1
	mps11 (net31 net158 vdda vdda) pmos1 l=1.1e-07n w=1.6e-06u m=1
	mpd11 (net56 inn net31 net31) pmos1 l=180n w=1u m=1
	mp001 (out net158 vdda vdda) pmos1 l=180n w=1u m=1
	mpd12 (net13 inp net31 net31) pmos1 l=180n w=1u m=1
	mpb01 (net158 net158 vdda vdda) pmos1 l=180n w=1u m=1
ends OPAMP1_variant14

subckt OPAMP1_variant15 inn inp out pd xpd vdda vssa
	xd1 (vssa vdda) prim_nwd AREA=6.13907e-9 PJ=476.6e-6 m=1
	xi0 (vssa net69) prim_nd AREA=1e-12 PJ=4e-6 m=1
	xi3 (net51 vdda) prim_pd AREA=790e-15 PJ=3.3e-6 m=1
	xr0 (vssa vdda net51) prim_rdiffp l=2.7e-07 w=2.0e-06 m=1
	xr1 (vdda vdda net69) prim_rdiffp l=2.1e-6 w=700e-9 m=1
	xcc01 (net12 out) prim_cpoly c=1.2e-12p m=1
	mnm12 (net13 net56 vssa vssa) nmos1 l=180n w=1u m=1
	mnm11 (net56 net56 vssa vssa) nmos1 l=180n w=1u m=1
	mnb02 (net27 net27 net21 vssa) nmos1 l=2.3e-07n w=1.0e-06u m=1
	mnpd1 (net21 xpd vssa vssa) nmos1 l=180n w=1u m=1
	mn001 (out net13 vssa vssa) nmos1 l=180n w=1u m=1
	mnpd2 (net13 pd vssa vssa) nmos1 l=180n w=1u m=1
	mnc01 (net13 net69 net12 vssa) nmos1 l=180n w=1u m=1
	mpb02 (net27 net51 net158 vdda) pmos1 l=180n w=1u m=1
	mppd1 (net158 xpd vdda vdda) pmos1 l=180n w=1u m=1
	mps11 (net31 net158 vdda vdda) pmos1 l=2.9e-07n w=1.9e-06u m=1
	mpd11 (net56 inn net31 net31) pmos1 l=180n w=1u m=1
	mp001 (out net158 vdda vdda) pmos1 l=1.6e-07n w=6.8e-07u m=1
	mpd12 (net13 inp net31 net31) pmos1 l=180n w=1u m=1
	mpb01 (net158 net158 vdda vdda) pmos1 l=180n w=1u m=1
ends OPAMP1_variant15

subckt OPAMP1_variant16 inn inp out pd xpd vdda vssa
	xd1 (vssa vdda) prim_nwd AREA=6.13907e-9 PJ=476.6e-6 m=1
	xi0 (vssa net69) prim_nd AREA=1e-12 PJ=4e-6 m=1
	xi3 (net51 vdda) prim_pd AREA=790e-15 PJ=3.3e-6 m=1
	xr0 (vssa vdda net51) prim_rdiffp l=2.1e-6 w=700e-9 m=1
	xr1 (vdda vdda net69) prim_rdiffp l=2.1e-6 w=700e-9 m=1
	xcc01 (net12 out) prim_cpoly c=1p m=1
	mnm12 (net13 net56 vssa vssa) nmos1 l=180n w=1u m=1
	mnm11 (net56 net56 vssa vssa) nmos1 l=180n w=1u m=1
	mnb02 (net27 net27 net21 vssa) nmos1 l=180n w=1u m=1
	mnpd1 (net21 xpd vssa vssa) nmos1 l=180n w=1u m=1
	mn001 (out net13 vssa vssa) nmos1 l=180n w=1u m=1
	mnpd2 (net13 pd vssa vssa) nmos1 l=2.1e-07n w=1.3e-06u m=1
	mnc01 (net13 net69 net12 vssa) nmos1 l=180n w=1u m=1
	mpb02 (net27 net51 net158 vdda) pmos1 l=180n w=1u m=1
	mppd1 (net158 xpd vdda vdda) pmos1 l=180n w=1u m=1
	mps11 (net31 net158 vdda vdda) pmos1 l=1.9e-07n w=1.3e-06u m=1
	mpd11 (net56 inn net31 net31) pmos1 l=180n w=1u m=1
	mp001 (out net158 vdda vdda) pmos1 l=180n w=1u m=1
	mpd12 (net13 inp net31 net31) pmos1 l=180n w=1u m=1
	mpb01 (net158 net158 vdda vdda) pmos1 l=180n w=1u m=1
ends OPAMP1_variant16

subckt OPAMP1_variant17 inn inp out pd xpd vdda vssa
	xd1 (vssa vdda) prim_nwd AREA=6.13907e-9 PJ=476.6e-6 m=1
	xi0 (vssa net69) prim_nd AREA=1e-12 PJ=4e-6 m=1
	xi3 (net51 vdda) prim_pd AREA=790e-15 PJ=3.3e-6 m=1
	xr0 (vssa vdda net51) prim_rdiffp l=2.1e-6 w=700e-9 m=1
	xr1 (vdda vdda net69) prim_rdiffp l=2.1e-6 w=700e-9 m=1
	xcc01 (net12 out) prim_cpoly c=1p m=1
	mnm12 (net13 net56 vssa vssa) nmos1 l=180n w=1u m=1
	mnm11 (net56 net56 vssa vssa) nmos1 l=180n w=1u m=1
	mnb02 (net27 net27 net21 vssa) nmos1 l=180n w=1u m=1
	mnpd1 (net21 xpd vssa vssa) nmos1 l=1.7e-07n w=1.2e-06u m=1
	mn001 (out net13 vssa vssa) nmos1 l=1.0e-07n w=6.6e-07u m=1
	mnpd2 (net13 pd vssa vssa) nmos1 l=180n w=1u m=1
	mnc01 (net13 net69 net12 vssa) nmos1 l=180n w=1u m=1
	mpb02 (net27 net51 net158 vdda) pmos1 l=180n w=1u m=1
	mppd1 (net158 xpd vdda vdda) pmos1 l=180n w=1u m=1
	mps11 (net31 net158 vdda vdda) pmos1 l=180n w=1u m=1
	mpd11 (net56 inn net31 net31) pmos1 l=180n w=1u m=1
	mp001 (out net158 vdda vdda) pmos1 l=180n w=1u m=1
	mpd12 (net13 inp net31 net31) pmos1 l=180n w=1u m=1
	mpb01 (net158 net158 vdda vdda) pmos1 l=2.7e-07n w=1.3e-06u m=1
ends OPAMP1_variant17

subckt OPAMP1_variant18 inn inp out pd xpd vdda vssa
	xd1 (vssa vdda) prim_nwd AREA=6.13907e-9 PJ=476.6e-6 m=1
	xi0 (vssa net69) prim_nd AREA=1e-12 PJ=4e-6 m=1
	xi3 (net51 vdda) prim_pd AREA=790e-15 PJ=3.3e-6 m=1
	xr0 (vssa vdda net51) prim_rdiffp l=2.1e-6 w=700e-9 m=1
	xr1 (vdda vdda net69) prim_rdiffp l=2.1e-6 w=700e-9 m=1
	xcc01 (net12 out) prim_cpoly c=1p m=1
	mnm12 (net13 net56 vssa vssa) nmos1 l=180n w=1u m=1
	mnm11 (net56 net56 vssa vssa) nmos1 l=180n w=1u m=1
	mnb02 (net27 net27 net21 vssa) nmos1 l=2.9e-07n w=5.7e-07u m=1
	mnpd1 (net21 xpd vssa vssa) nmos1 l=180n w=1u m=1
	mn001 (out net13 vssa vssa) nmos1 l=180n w=1u m=1
	mnpd2 (net13 pd vssa vssa) nmos1 l=1.5e-07n w=1.3e-06u m=1
	mnc01 (net13 net69 net12 vssa) nmos1 l=180n w=1u m=1
	mpb02 (net27 net51 net158 vdda) pmos1 l=2.9e-07n w=1.8e-06u m=1
	mppd1 (net158 xpd vdda vdda) pmos1 l=180n w=1u m=1
	mps11 (net31 net158 vdda vdda) pmos1 l=180n w=1u m=1
	mpd11 (net56 inn net31 net31) pmos1 l=180n w=1u m=1
	mp001 (out net158 vdda vdda) pmos1 l=180n w=1u m=1
	mpd12 (net13 inp net31 net31) pmos1 l=180n w=1u m=1
	mpb01 (net158 net158 vdda vdda) pmos1 l=180n w=1u m=1
ends OPAMP1_variant18

subckt OPAMP1_variant19 inn inp out pd xpd vdda vssa
	xd1 (vssa vdda) prim_nwd AREA=6.13907e-9 PJ=476.6e-6 m=1
	xi0 (vssa net69) prim_nd AREA=1e-12 PJ=4e-6 m=1
	xi3 (net51 vdda) prim_pd AREA=790e-15 PJ=3.3e-6 m=1
	xr0 (vssa vdda net51) prim_rdiffp l=2.8e-07 w=1.4e-06 m=1
	xr1 (vdda vdda net69) prim_rdiffp l=2.1e-6 w=700e-9 m=1
	xcc01 (net12 out) prim_cpoly c=1p m=1
	mnm12 (net13 net56 vssa vssa) nmos1 l=180n w=1u m=1
	mnm11 (net56 net56 vssa vssa) nmos1 l=180n w=1u m=1
	mnb02 (net27 net27 net21 vssa) nmos1 l=180n w=1u m=1
	mnpd1 (net21 xpd vssa vssa) nmos1 l=180n w=1u m=1
	mn001 (out net13 vssa vssa) nmos1 l=180n w=1u m=1
	mnpd2 (net13 pd vssa vssa) nmos1 l=180n w=1u m=1
	mnc01 (net13 net69 net12 vssa) nmos1 l=180n w=1u m=1
	mpb02 (net27 net51 net158 vdda) pmos1 l=1.8e-07n w=1.2e-06u m=1
	mppd1 (net158 xpd vdda vdda) pmos1 l=180n w=1u m=1
	mps11 (net31 net158 vdda vdda) pmos1 l=180n w=1u m=1
	mpd11 (net56 inn net31 net31) pmos1 l=180n w=1u m=1
	mp001 (out net158 vdda vdda) pmos1 l=180n w=1u m=1
	mpd12 (net13 inp net31 net31) pmos1 l=180n w=1u m=1
	mpb01 (net158 net158 vdda vdda) pmos1 l=180n w=1u m=1
ends OPAMP1_variant19

subckt OPAMP1_variant20 inn inp out pd xpd vdda vssa
	xd1 (vssa vdda) prim_nwd AREA=6.13907e-9 PJ=476.6e-6 m=1
	xi0 (vssa net69) prim_nd AREA=1e-12 PJ=4e-6 m=1
	xi3 (net51 vdda) prim_pd AREA=790e-15 PJ=3.3e-6 m=1
	xr0 (vssa vdda net51) prim_rdiffp l=2.1e-6 w=700e-9 m=1
	xr1 (vdda vdda net69) prim_rdiffp l=2.1e-6 w=700e-9 m=1
	xcc01 (net12 out) prim_cpoly c=1.1e-12p m=1
	mnm12 (net13 net56 vssa vssa) nmos1 l=180n w=1u m=1
	mnm11 (net56 net56 vssa vssa) nmos1 l=180n w=1u m=1
	mnb02 (net27 net27 net21 vssa) nmos1 l=180n w=1u m=1
	mnpd1 (net21 xpd vssa vssa) nmos1 l=180n w=1u m=1
	mn001 (out net13 vssa vssa) nmos1 l=1.4e-07n w=1.8e-06u m=1
	mnpd2 (net13 pd vssa vssa) nmos1 l=180n w=1u m=1
	mnc01 (net13 net69 net12 vssa) nmos1 l=180n w=1u m=1
	mpb02 (net27 net51 net158 vdda) pmos1 l=180n w=1u m=1
	mppd1 (net158 xpd vdda vdda) pmos1 l=180n w=1u m=1
	mps11 (net31 net158 vdda vdda) pmos1 l=180n w=1u m=1
	mpd11 (net56 inn net31 net31) pmos1 l=180n w=1u m=1
	mp001 (out net158 vdda vdda) pmos1 l=180n w=1u m=1
	mpd12 (net13 inp net31 net31) pmos1 l=180n w=1u m=1
	mpb01 (net158 net158 vdda vdda) pmos1 l=180n w=1u m=1
ends OPAMP1_variant20

subckt OPAMP1_variant21 inn inp out pd xpd vdda vssa
	xd1 (vssa vdda) prim_nwd AREA=6.13907e-9 PJ=476.6e-6 m=1
	xi0 (vssa net69) prim_nd AREA=1e-12 PJ=4e-6 m=1
	xi3 (net51 vdda) prim_pd AREA=790e-15 PJ=3.3e-6 m=1
	xr0 (vssa vdda net51) prim_rdiffp l=2.1e-6 w=700e-9 m=1
	xr1 (vdda vdda net69) prim_rdiffp l=2.1e-6 w=700e-9 m=1
	xcc01 (net12 out) prim_cpoly c=1.2e-12p m=1
	mnm12 (net13 net56 vssa vssa) nmos1 l=2.6e-07n w=8.9e-07u m=1
	mnm11 (net56 net56 vssa vssa) nmos1 l=180n w=1u m=1
	mnb02 (net27 net27 net21 vssa) nmos1 l=180n w=1u m=1
	mnpd1 (net21 xpd vssa vssa) nmos1 l=180n w=1u m=1
	mn001 (out net13 vssa vssa) nmos1 l=180n w=1u m=1
	mnpd2 (net13 pd vssa vssa) nmos1 l=180n w=1u m=1
	mnc01 (net13 net69 net12 vssa) nmos1 l=2.9e-07n w=1.4e-06u m=1
	mpb02 (net27 net51 net158 vdda) pmos1 l=180n w=1u m=1
	mppd1 (net158 xpd vdda vdda) pmos1 l=180n w=1u m=1
	mps11 (net31 net158 vdda vdda) pmos1 l=180n w=1u m=1
	mpd11 (net56 inn net31 net31) pmos1 l=180n w=1u m=1
	mp001 (out net158 vdda vdda) pmos1 l=180n w=1u m=1
	mpd12 (net13 inp net31 net31) pmos1 l=180n w=1u m=1
	mpb01 (net158 net158 vdda vdda) pmos1 l=180n w=1u m=1
ends OPAMP1_variant21

subckt OPAMP1_variant22 inn inp out pd xpd vdda vssa
	xd1 (vssa vdda) prim_nwd AREA=6.13907e-9 PJ=476.6e-6 m=1
	xi0 (vssa net69) prim_nd AREA=1e-12 PJ=4e-6 m=1
	xi3 (net51 vdda) prim_pd AREA=6.8e-09 PJ=7.9e-05 m=1
	xr0 (vssa vdda net51) prim_rdiffp l=2.5e-07 w=1.6e-06 m=1
	xr1 (vdda vdda net69) prim_rdiffp l=2.1e-6 w=700e-9 m=1
	xcc01 (net12 out) prim_cpoly c=1p m=1
	mnm12 (net13 net56 vssa vssa) nmos1 l=1.3e-07n w=1.6e-06u m=1
	mnm11 (net56 net56 vssa vssa) nmos1 l=180n w=1u m=1
	mnb02 (net27 net27 net21 vssa) nmos1 l=180n w=1u m=1
	mnpd1 (net21 xpd vssa vssa) nmos1 l=2.2e-07n w=5.6e-07u m=1
	mn001 (out net13 vssa vssa) nmos1 l=180n w=1u m=1
	mnpd2 (net13 pd vssa vssa) nmos1 l=180n w=1u m=1
	mnc01 (net13 net69 net12 vssa) nmos1 l=180n w=1u m=1
	mpb02 (net27 net51 net158 vdda) pmos1 l=180n w=1u m=1
	mppd1 (net158 xpd vdda vdda) pmos1 l=180n w=1u m=1
	mps11 (net31 net158 vdda vdda) pmos1 l=180n w=1u m=1
	mpd11 (net56 inn net31 net31) pmos1 l=180n w=1u m=1
	mp001 (out net158 vdda vdda) pmos1 l=180n w=1u m=1
	mpd12 (net13 inp net31 net31) pmos1 l=180n w=1u m=1
	mpb01 (net158 net158 vdda vdda) pmos1 l=180n w=1u m=1
ends OPAMP1_variant22

subckt OPAMP1_variant23 inn inp out pd xpd vdda vssa
	xd1 (vssa vdda) prim_nwd AREA=6.13907e-9 PJ=476.6e-6 m=1
	xi0 (vssa net69) prim_nd AREA=1e-12 PJ=4e-6 m=1
	xi3 (net51 vdda) prim_pd AREA=790e-15 PJ=3.3e-6 m=1
	xr0 (vssa vdda net51) prim_rdiffp l=2.1e-6 w=700e-9 m=1
	xr1 (vdda vdda net69) prim_rdiffp l=2.1e-6 w=700e-9 m=1
	xcc01 (net12 out) prim_cpoly c=1p m=1
	mnm12 (net13 net56 vssa vssa) nmos1 l=180n w=1u m=1
	mnm11 (net56 net56 vssa vssa) nmos1 l=180n w=1u m=1
	mnb02 (net27 net27 net21 vssa) nmos1 l=180n w=1u m=1
	mnpd1 (net21 xpd vssa vssa) nmos1 l=180n w=1u m=1
	mn001 (out net13 vssa vssa) nmos1 l=1.9e-07n w=7.8e-07u m=1
	mnpd2 (net13 pd vssa vssa) nmos1 l=2.3e-07n w=1.2e-06u m=1
	mnc01 (net13 net69 net12 vssa) nmos1 l=180n w=1u m=1
	mpb02 (net27 net51 net158 vdda) pmos1 l=2.9e-07n w=1.9e-06u m=1
	mppd1 (net158 xpd vdda vdda) pmos1 l=180n w=1u m=1
	mps11 (net31 net158 vdda vdda) pmos1 l=180n w=1u m=1
	mpd11 (net56 inn net31 net31) pmos1 l=180n w=1u m=1
	mp001 (out net158 vdda vdda) pmos1 l=180n w=1u m=1
	mpd12 (net13 inp net31 net31) pmos1 l=180n w=1u m=1
	mpb01 (net158 net158 vdda vdda) pmos1 l=180n w=1u m=1
ends OPAMP1_variant23

subckt OPAMP1_variant24 inn inp out pd xpd vdda vssa
	xd1 (vssa vdda) prim_nwd AREA=6.13907e-9 PJ=476.6e-6 m=1
	xi0 (vssa net69) prim_nd AREA=1.6e-09 PJ=6.1e-05 m=1
	xi3 (net51 vdda) prim_pd AREA=790e-15 PJ=3.3e-6 m=1
	xr0 (vssa vdda net51) prim_rdiffp l=2.1e-6 w=700e-9 m=1
	xr1 (vdda vdda net69) prim_rdiffp l=2.1e-6 w=700e-9 m=1
	xcc01 (net12 out) prim_cpoly c=1p m=1
	mnm12 (net13 net56 vssa vssa) nmos1 l=1.4e-07n w=1.9e-06u m=1
	mnm11 (net56 net56 vssa vssa) nmos1 l=180n w=1u m=1
	mnb02 (net27 net27 net21 vssa) nmos1 l=180n w=1u m=1
	mnpd1 (net21 xpd vssa vssa) nmos1 l=180n w=1u m=1
	mn001 (out net13 vssa vssa) nmos1 l=180n w=1u m=1
	mnpd2 (net13 pd vssa vssa) nmos1 l=180n w=1u m=1
	mnc01 (net13 net69 net12 vssa) nmos1 l=180n w=1u m=1
	mpb02 (net27 net51 net158 vdda) pmos1 l=1.3e-07n w=5.8e-07u m=1
	mppd1 (net158 xpd vdda vdda) pmos1 l=180n w=1u m=1
	mps11 (net31 net158 vdda vdda) pmos1 l=180n w=1u m=1
	mpd11 (net56 inn net31 net31) pmos1 l=180n w=1u m=1
	mp001 (out net158 vdda vdda) pmos1 l=180n w=1u m=1
	mpd12 (net13 inp net31 net31) pmos1 l=180n w=1u m=1
	mpb01 (net158 net158 vdda vdda) pmos1 l=180n w=1u m=1
ends OPAMP1_variant24

subckt OPAMP1_variant25 inn inp out pd xpd vdda vssa
	xd1 (vssa vdda) prim_nwd AREA=6.13907e-9 PJ=476.6e-6 m=1
	xi0 (vssa net69) prim_nd AREA=1e-12 PJ=4e-6 m=1
	xi3 (net51 vdda) prim_pd AREA=7.3e-09 PJ=6.5e-05 m=1
	xr0 (vssa vdda net51) prim_rdiffp l=2.5e-07 w=9.2e-07 m=1
	xr1 (vdda vdda net69) prim_rdiffp l=2.1e-6 w=700e-9 m=1
	xcc01 (net12 out) prim_cpoly c=1p m=1
	mnm12 (net13 net56 vssa vssa) nmos1 l=180n w=1u m=1
	mnm11 (net56 net56 vssa vssa) nmos1 l=180n w=1u m=1
	mnb02 (net27 net27 net21 vssa) nmos1 l=180n w=1u m=1
	mnpd1 (net21 xpd vssa vssa) nmos1 l=180n w=1u m=1
	mn001 (out net13 vssa vssa) nmos1 l=1.9e-07n w=1.5e-06u m=1
	mnpd2 (net13 pd vssa vssa) nmos1 l=1.8e-07n w=1.7e-06u m=1
	mnc01 (net13 net69 net12 vssa) nmos1 l=180n w=1u m=1
	mpb02 (net27 net51 net158 vdda) pmos1 l=180n w=1u m=1
	mppd1 (net158 xpd vdda vdda) pmos1 l=180n w=1u m=1
	mps11 (net31 net158 vdda vdda) pmos1 l=180n w=1u m=1
	mpd11 (net56 inn net31 net31) pmos1 l=180n w=1u m=1
	mp001 (out net158 vdda vdda) pmos1 l=2.7e-07n w=1.4e-06u m=1
	mpd12 (net13 inp net31 net31) pmos1 l=180n w=1u m=1
	mpb01 (net158 net158 vdda vdda) pmos1 l=180n w=1u m=1
ends OPAMP1_variant25

subckt OPAMP1_variant26 inn inp out pd xpd vdda vssa
	xd1 (vssa vdda) prim_nwd AREA=6.13907e-9 PJ=476.6e-6 m=1
	xi0 (vssa net69) prim_nd AREA=1e-12 PJ=4e-6 m=1
	xi3 (net51 vdda) prim_pd AREA=790e-15 PJ=3.3e-6 m=1
	xr0 (vssa vdda net51) prim_rdiffp l=2.1e-6 w=700e-9 m=1
	xr1 (vdda vdda net69) prim_rdiffp l=2.1e-6 w=700e-9 m=1
	xcc01 (net12 out) prim_cpoly c=1.0e-12p m=1
	mnm12 (net13 net56 vssa vssa) nmos1 l=180n w=1u m=1
	mnm11 (net56 net56 vssa vssa) nmos1 l=180n w=1u m=1
	mnb02 (net27 net27 net21 vssa) nmos1 l=180n w=1u m=1
	mnpd1 (net21 xpd vssa vssa) nmos1 l=2.1e-07n w=1.8e-06u m=1
	mn001 (out net13 vssa vssa) nmos1 l=180n w=1u m=1
	mnpd2 (net13 pd vssa vssa) nmos1 l=180n w=1u m=1
	mnc01 (net13 net69 net12 vssa) nmos1 l=180n w=1u m=1
	mpb02 (net27 net51 net158 vdda) pmos1 l=2.8e-07n w=9.6e-07u m=1
	mppd1 (net158 xpd vdda vdda) pmos1 l=180n w=1u m=1
	mps11 (net31 net158 vdda vdda) pmos1 l=2.4e-07n w=9.3e-07u m=1
	mpd11 (net56 inn net31 net31) pmos1 l=180n w=1u m=1
	mp001 (out net158 vdda vdda) pmos1 l=2.4e-07n w=1.1e-06u m=1
	mpd12 (net13 inp net31 net31) pmos1 l=180n w=1u m=1
	mpb01 (net158 net158 vdda vdda) pmos1 l=180n w=1u m=1
ends OPAMP1_variant26

subckt OPAMP1_variant27 inn inp out pd xpd vdda vssa
	xd1 (vssa vdda) prim_nwd AREA=6.13907e-9 PJ=476.6e-6 m=1
	xi0 (vssa net69) prim_nd AREA=1e-12 PJ=4e-6 m=1
	xi3 (net51 vdda) prim_pd AREA=790e-15 PJ=3.3e-6 m=1
	xr0 (vssa vdda net51) prim_rdiffp l=2.1e-6 w=700e-9 m=1
	xr1 (vdda vdda net69) prim_rdiffp l=2.1e-6 w=700e-9 m=1
	xcc01 (net12 out) prim_cpoly c=1.9e-12p m=1
	mnm12 (net13 net56 vssa vssa) nmos1 l=180n w=1u m=1
	mnm11 (net56 net56 vssa vssa) nmos1 l=180n w=1u m=1
	mnb02 (net27 net27 net21 vssa) nmos1 l=180n w=1u m=1
	mnpd1 (net21 xpd vssa vssa) nmos1 l=180n w=1u m=1
	mn001 (out net13 vssa vssa) nmos1 l=180n w=1u m=1
	mnpd2 (net13 pd vssa vssa) nmos1 l=180n w=1u m=1
	mnc01 (net13 net69 net12 vssa) nmos1 l=180n w=1u m=1
	mpb02 (net27 net51 net158 vdda) pmos1 l=180n w=1u m=1
	mppd1 (net158 xpd vdda vdda) pmos1 l=2.0e-07n w=1.4e-06u m=1
	mps11 (net31 net158 vdda vdda) pmos1 l=180n w=1u m=1
	mpd11 (net56 inn net31 net31) pmos1 l=180n w=1u m=1
	mp001 (out net158 vdda vdda) pmos1 l=180n w=1u m=1
	mpd12 (net13 inp net31 net31) pmos1 l=180n w=1u m=1
	mpb01 (net158 net158 vdda vdda) pmos1 l=180n w=1u m=1
ends OPAMP1_variant27

subckt OPAMP1_variant28 inn inp out pd xpd vdda vssa
	xd1 (vssa vdda) prim_nwd AREA=6.13907e-9 PJ=476.6e-6 m=1
	xi0 (vssa net69) prim_nd AREA=1e-12 PJ=4e-6 m=1
	xi3 (net51 vdda) prim_pd AREA=790e-15 PJ=3.3e-6 m=1
	xr0 (vssa vdda net51) prim_rdiffp l=1.6e-07 w=1.4e-06 m=1
	xr1 (vdda vdda net69) prim_rdiffp l=2.1e-6 w=700e-9 m=1
	xcc01 (net12 out) prim_cpoly c=1p m=1
	mnm12 (net13 net56 vssa vssa) nmos1 l=180n w=1u m=1
	mnm11 (net56 net56 vssa vssa) nmos1 l=2.2e-07n w=1.4e-06u m=1
	mnb02 (net27 net27 net21 vssa) nmos1 l=180n w=1u m=1
	mnpd1 (net21 xpd vssa vssa) nmos1 l=180n w=1u m=1
	mn001 (out net13 vssa vssa) nmos1 l=180n w=1u m=1
	mnpd2 (net13 pd vssa vssa) nmos1 l=180n w=1u m=1
	mnc01 (net13 net69 net12 vssa) nmos1 l=2.3e-07n w=6.1e-07u m=1
	mpb02 (net27 net51 net158 vdda) pmos1 l=1.7e-07n w=6.9e-07u m=1
	mppd1 (net158 xpd vdda vdda) pmos1 l=180n w=1u m=1
	mps11 (net31 net158 vdda vdda) pmos1 l=180n w=1u m=1
	mpd11 (net56 inn net31 net31) pmos1 l=180n w=1u m=1
	mp001 (out net158 vdda vdda) pmos1 l=180n w=1u m=1
	mpd12 (net13 inp net31 net31) pmos1 l=180n w=1u m=1
	mpb01 (net158 net158 vdda vdda) pmos1 l=3.0e-07n w=1.9e-06u m=1
ends OPAMP1_variant28

subckt OPAMP1_variant29 inn inp out pd xpd vdda vssa
	xd1 (vssa vdda) prim_nwd AREA=6.13907e-9 PJ=476.6e-6 m=1
	xi0 (vssa net69) prim_nd AREA=1e-12 PJ=4e-6 m=1
	xi3 (net51 vdda) prim_pd AREA=790e-15 PJ=3.3e-6 m=1
	xr0 (vssa vdda net51) prim_rdiffp l=2.1e-6 w=700e-9 m=1
	xr1 (vdda vdda net69) prim_rdiffp l=2.1e-07 w=5.8e-07 m=1
	xcc01 (net12 out) prim_cpoly c=1p m=1
	mnm12 (net13 net56 vssa vssa) nmos1 l=180n w=1u m=1
	mnm11 (net56 net56 vssa vssa) nmos1 l=180n w=1u m=1
	mnb02 (net27 net27 net21 vssa) nmos1 l=180n w=1u m=1
	mnpd1 (net21 xpd vssa vssa) nmos1 l=180n w=1u m=1
	mn001 (out net13 vssa vssa) nmos1 l=180n w=1u m=1
	mnpd2 (net13 pd vssa vssa) nmos1 l=180n w=1u m=1
	mnc01 (net13 net69 net12 vssa) nmos1 l=1.7e-07n w=1.2e-06u m=1
	mpb02 (net27 net51 net158 vdda) pmos1 l=180n w=1u m=1
	mppd1 (net158 xpd vdda vdda) pmos1 l=2.3e-07n w=1.3e-06u m=1
	mps11 (net31 net158 vdda vdda) pmos1 l=180n w=1u m=1
	mpd11 (net56 inn net31 net31) pmos1 l=180n w=1u m=1
	mp001 (out net158 vdda vdda) pmos1 l=2.2e-07n w=7.5e-07u m=1
	mpd12 (net13 inp net31 net31) pmos1 l=1.9e-07n w=1.3e-06u m=1
	mpb01 (net158 net158 vdda vdda) pmos1 l=180n w=1u m=1
ends OPAMP1_variant29

subckt OPAMP1_variant30 inn inp out pd xpd vdda vssa
	xd1 (vssa vdda) prim_nwd AREA=6.13907e-9 PJ=476.6e-6 m=1
	xi0 (vssa net69) prim_nd AREA=1e-12 PJ=4e-6 m=1
	xi3 (net51 vdda) prim_pd AREA=790e-15 PJ=3.3e-6 m=1
	xr0 (vssa vdda net51) prim_rdiffp l=2.1e-6 w=700e-9 m=1
	xr1 (vdda vdda net69) prim_rdiffp l=1.8e-07 w=8.8e-07 m=1
	xcc01 (net12 out) prim_cpoly c=1p m=1
	mnm12 (net13 net56 vssa vssa) nmos1 l=180n w=1u m=1
	mnm11 (net56 net56 vssa vssa) nmos1 l=180n w=1u m=1
	mnb02 (net27 net27 net21 vssa) nmos1 l=180n w=1u m=1
	mnpd1 (net21 xpd vssa vssa) nmos1 l=180n w=1u m=1
	mn001 (out net13 vssa vssa) nmos1 l=2.2e-07n w=1.2e-06u m=1
	mnpd2 (net13 pd vssa vssa) nmos1 l=1.5e-07n w=9.3e-07u m=1
	mnc01 (net13 net69 net12 vssa) nmos1 l=1.2e-07n w=9.6e-07u m=1
	mpb02 (net27 net51 net158 vdda) pmos1 l=180n w=1u m=1
	mppd1 (net158 xpd vdda vdda) pmos1 l=180n w=1u m=1
	mps11 (net31 net158 vdda vdda) pmos1 l=180n w=1u m=1
	mpd11 (net56 inn net31 net31) pmos1 l=180n w=1u m=1
	mp001 (out net158 vdda vdda) pmos1 l=180n w=1u m=1
	mpd12 (net13 inp net31 net31) pmos1 l=2.7e-07n w=1.6e-06u m=1
	mpb01 (net158 net158 vdda vdda) pmos1 l=180n w=1u m=1
ends OPAMP1_variant30

subckt OPAMP1_variant31 inn inp out pd xpd vdda vssa
	xd1 (vssa vdda) prim_nwd AREA=6.13907e-9 PJ=476.6e-6 m=1
	xi0 (vssa net69) prim_nd AREA=1e-12 PJ=4e-6 m=1
	xi3 (net51 vdda) prim_pd AREA=1.3e-09 PJ=1.1e-05 m=1
	xr0 (vssa vdda net51) prim_rdiffp l=2.1e-6 w=700e-9 m=1
	xr1 (vdda vdda net69) prim_rdiffp l=2.1e-6 w=700e-9 m=1
	xcc01 (net12 out) prim_cpoly c=1p m=1
	mnm12 (net13 net56 vssa vssa) nmos1 l=180n w=1u m=1
	mnm11 (net56 net56 vssa vssa) nmos1 l=2.5e-07n w=1.9e-06u m=1
	mnb02 (net27 net27 net21 vssa) nmos1 l=180n w=1u m=1
	mnpd1 (net21 xpd vssa vssa) nmos1 l=180n w=1u m=1
	mn001 (out net13 vssa vssa) nmos1 l=1.3e-07n w=1.9e-06u m=1
	mnpd2 (net13 pd vssa vssa) nmos1 l=180n w=1u m=1
	mnc01 (net13 net69 net12 vssa) nmos1 l=2.3e-07n w=1.3e-06u m=1
	mpb02 (net27 net51 net158 vdda) pmos1 l=180n w=1u m=1
	mppd1 (net158 xpd vdda vdda) pmos1 l=180n w=1u m=1
	mps11 (net31 net158 vdda vdda) pmos1 l=180n w=1u m=1
	mpd11 (net56 inn net31 net31) pmos1 l=180n w=1u m=1
	mp001 (out net158 vdda vdda) pmos1 l=2.3e-07n w=1.6e-06u m=1
	mpd12 (net13 inp net31 net31) pmos1 l=180n w=1u m=1
	mpb01 (net158 net158 vdda vdda) pmos1 l=180n w=1u m=1
ends OPAMP1_variant31

subckt OPAMP1_variant32 inn inp out pd xpd vdda vssa
	xd1 (vssa vdda) prim_nwd AREA=6.13907e-9 PJ=476.6e-6 m=1
	xi0 (vssa net69) prim_nd AREA=1e-12 PJ=4e-6 m=1
	xi3 (net51 vdda) prim_pd AREA=790e-15 PJ=3.3e-6 m=1
	xr0 (vssa vdda net51) prim_rdiffp l=2.9e-07 w=9.8e-07 m=1
	xr1 (vdda vdda net69) prim_rdiffp l=2.1e-6 w=700e-9 m=1
	xcc01 (net12 out) prim_cpoly c=9.3e-13p m=1
	mnm12 (net13 net56 vssa vssa) nmos1 l=180n w=1u m=1
	mnm11 (net56 net56 vssa vssa) nmos1 l=180n w=1u m=1
	mnb02 (net27 net27 net21 vssa) nmos1 l=180n w=1u m=1
	mnpd1 (net21 xpd vssa vssa) nmos1 l=180n w=1u m=1
	mn001 (out net13 vssa vssa) nmos1 l=180n w=1u m=1
	mnpd2 (net13 pd vssa vssa) nmos1 l=180n w=1u m=1
	mnc01 (net13 net69 net12 vssa) nmos1 l=180n w=1u m=1
	mpb02 (net27 net51 net158 vdda) pmos1 l=180n w=1u m=1
	mppd1 (net158 xpd vdda vdda) pmos1 l=2.0e-07n w=1.3e-06u m=1
	mps11 (net31 net158 vdda vdda) pmos1 l=180n w=1u m=1
	mpd11 (net56 inn net31 net31) pmos1 l=180n w=1u m=1
	mp001 (out net158 vdda vdda) pmos1 l=180n w=1u m=1
	mpd12 (net13 inp net31 net31) pmos1 l=180n w=1u m=1
	mpb01 (net158 net158 vdda vdda) pmos1 l=180n w=1u m=1
ends OPAMP1_variant32

subckt OPAMP1_variant33 inn inp out pd xpd vdda vssa
	xd1 (vssa vdda) prim_nwd AREA=9.2e-09 PJ=5.2e-05 m=1
	xi0 (vssa net69) prim_nd AREA=1e-12 PJ=4e-6 m=1
	xi3 (net51 vdda) prim_pd AREA=790e-15 PJ=3.3e-6 m=1
	xr0 (vssa vdda net51) prim_rdiffp l=1.2e-07 w=6.6e-07 m=1
	xr1 (vdda vdda net69) prim_rdiffp l=2.1e-6 w=700e-9 m=1
	xcc01 (net12 out) prim_cpoly c=1p m=1
	mnm12 (net13 net56 vssa vssa) nmos1 l=180n w=1u m=1
	mnm11 (net56 net56 vssa vssa) nmos1 l=180n w=1u m=1
	mnb02 (net27 net27 net21 vssa) nmos1 l=180n w=1u m=1
	mnpd1 (net21 xpd vssa vssa) nmos1 l=180n w=1u m=1
	mn001 (out net13 vssa vssa) nmos1 l=180n w=1u m=1
	mnpd2 (net13 pd vssa vssa) nmos1 l=180n w=1u m=1
	mnc01 (net13 net69 net12 vssa) nmos1 l=180n w=1u m=1
	mpb02 (net27 net51 net158 vdda) pmos1 l=180n w=1u m=1
	mppd1 (net158 xpd vdda vdda) pmos1 l=180n w=1u m=1
	mps11 (net31 net158 vdda vdda) pmos1 l=180n w=1u m=1
	mpd11 (net56 inn net31 net31) pmos1 l=180n w=1u m=1
	mp001 (out net158 vdda vdda) pmos1 l=180n w=1u m=1
	mpd12 (net13 inp net31 net31) pmos1 l=180n w=1u m=1
	mpb01 (net158 net158 vdda vdda) pmos1 l=180n w=1u m=1
ends OPAMP1_variant33

subckt OPAMP1_variant34 inn inp out pd xpd vdda vssa
	xd1 (vssa vdda) prim_nwd AREA=3.7e-09 PJ=4.7e-05 m=1
	xi0 (vssa net69) prim_nd AREA=1e-12 PJ=4e-6 m=1
	xi3 (net51 vdda) prim_pd AREA=790e-15 PJ=3.3e-6 m=1
	xr0 (vssa vdda net51) prim_rdiffp l=1.0e-07 w=1.6e-06 m=1
	xr1 (vdda vdda net69) prim_rdiffp l=2.1e-6 w=700e-9 m=1
	xcc01 (net12 out) prim_cpoly c=1p m=1
	mnm12 (net13 net56 vssa vssa) nmos1 l=1.3e-07n w=5.7e-07u m=1
	mnm11 (net56 net56 vssa vssa) nmos1 l=1.5e-07n w=1.5e-06u m=1
	mnb02 (net27 net27 net21 vssa) nmos1 l=1.6e-07n w=1.4e-06u m=1
	mnpd1 (net21 xpd vssa vssa) nmos1 l=180n w=1u m=1
	mn001 (out net13 vssa vssa) nmos1 l=180n w=1u m=1
	mnpd2 (net13 pd vssa vssa) nmos1 l=180n w=1u m=1
	mnc01 (net13 net69 net12 vssa) nmos1 l=180n w=1u m=1
	mpb02 (net27 net51 net158 vdda) pmos1 l=180n w=1u m=1
	mppd1 (net158 xpd vdda vdda) pmos1 l=180n w=1u m=1
	mps11 (net31 net158 vdda vdda) pmos1 l=180n w=1u m=1
	mpd11 (net56 inn net31 net31) pmos1 l=180n w=1u m=1
	mp001 (out net158 vdda vdda) pmos1 l=180n w=1u m=1
	mpd12 (net13 inp net31 net31) pmos1 l=180n w=1u m=1
	mpb01 (net158 net158 vdda vdda) pmos1 l=180n w=1u m=1
ends OPAMP1_variant34

subckt OPAMP1_variant35 inn inp out pd xpd vdda vssa
	xd1 (vssa vdda) prim_nwd AREA=6.13907e-9 PJ=476.6e-6 m=1
	xi0 (vssa net69) prim_nd AREA=1e-12 PJ=4e-6 m=1
	xi3 (net51 vdda) prim_pd AREA=790e-15 PJ=3.3e-6 m=1
	xr0 (vssa vdda net51) prim_rdiffp l=2.1e-6 w=700e-9 m=1
	xr1 (vdda vdda net69) prim_rdiffp l=2.2e-07 w=1.9e-06 m=1
	xcc01 (net12 out) prim_cpoly c=1p m=1
	mnm12 (net13 net56 vssa vssa) nmos1 l=180n w=1u m=1
	mnm11 (net56 net56 vssa vssa) nmos1 l=2.6e-07n w=9.1e-07u m=1
	mnb02 (net27 net27 net21 vssa) nmos1 l=180n w=1u m=1
	mnpd1 (net21 xpd vssa vssa) nmos1 l=180n w=1u m=1
	mn001 (out net13 vssa vssa) nmos1 l=180n w=1u m=1
	mnpd2 (net13 pd vssa vssa) nmos1 l=180n w=1u m=1
	mnc01 (net13 net69 net12 vssa) nmos1 l=180n w=1u m=1
	mpb02 (net27 net51 net158 vdda) pmos1 l=180n w=1u m=1
	mppd1 (net158 xpd vdda vdda) pmos1 l=180n w=1u m=1
	mps11 (net31 net158 vdda vdda) pmos1 l=180n w=1u m=1
	mpd11 (net56 inn net31 net31) pmos1 l=180n w=1u m=1
	mp001 (out net158 vdda vdda) pmos1 l=180n w=1u m=1
	mpd12 (net13 inp net31 net31) pmos1 l=180n w=1u m=1
	mpb01 (net158 net158 vdda vdda) pmos1 l=180n w=1u m=1
ends OPAMP1_variant35

subckt OPAMP1_variant36 inn inp out pd xpd vdda vssa
	xd1 (vssa vdda) prim_nwd AREA=6.13907e-9 PJ=476.6e-6 m=1
	xi0 (vssa net69) prim_nd AREA=1e-12 PJ=4e-6 m=1
	xi3 (net51 vdda) prim_pd AREA=790e-15 PJ=3.3e-6 m=1
	xr0 (vssa vdda net51) prim_rdiffp l=1.1e-07 w=1.1e-06 m=1
	xr1 (vdda vdda net69) prim_rdiffp l=1.3e-07 w=8.8e-07 m=1
	xcc01 (net12 out) prim_cpoly c=1p m=1
	mnm12 (net13 net56 vssa vssa) nmos1 l=180n w=1u m=1
	mnm11 (net56 net56 vssa vssa) nmos1 l=180n w=1u m=1
	mnb02 (net27 net27 net21 vssa) nmos1 l=180n w=1u m=1
	mnpd1 (net21 xpd vssa vssa) nmos1 l=180n w=1u m=1
	mn001 (out net13 vssa vssa) nmos1 l=2.7e-07n w=1.9e-06u m=1
	mnpd2 (net13 pd vssa vssa) nmos1 l=180n w=1u m=1
	mnc01 (net13 net69 net12 vssa) nmos1 l=180n w=1u m=1
	mpb02 (net27 net51 net158 vdda) pmos1 l=180n w=1u m=1
	mppd1 (net158 xpd vdda vdda) pmos1 l=180n w=1u m=1
	mps11 (net31 net158 vdda vdda) pmos1 l=180n w=1u m=1
	mpd11 (net56 inn net31 net31) pmos1 l=180n w=1u m=1
	mp001 (out net158 vdda vdda) pmos1 l=180n w=1u m=1
	mpd12 (net13 inp net31 net31) pmos1 l=1.2e-07n w=7.2e-07u m=1
	mpb01 (net158 net158 vdda vdda) pmos1 l=180n w=1u m=1
ends OPAMP1_variant36

subckt OPAMP1_variant37 inn inp out pd xpd vdda vssa
	xd1 (vssa vdda) prim_nwd AREA=6.13907e-9 PJ=476.6e-6 m=1
	xi0 (vssa net69) prim_nd AREA=6.8e-09 PJ=4.1e-05 m=1
	xi3 (net51 vdda) prim_pd AREA=790e-15 PJ=3.3e-6 m=1
	xr0 (vssa vdda net51) prim_rdiffp l=2.1e-6 w=700e-9 m=1
	xr1 (vdda vdda net69) prim_rdiffp l=1.4e-07 w=1.3e-06 m=1
	xcc01 (net12 out) prim_cpoly c=2.0e-12p m=1
	mnm12 (net13 net56 vssa vssa) nmos1 l=180n w=1u m=1
	mnm11 (net56 net56 vssa vssa) nmos1 l=180n w=1u m=1
	mnb02 (net27 net27 net21 vssa) nmos1 l=2.4e-07n w=1.7e-06u m=1
	mnpd1 (net21 xpd vssa vssa) nmos1 l=180n w=1u m=1
	mn001 (out net13 vssa vssa) nmos1 l=180n w=1u m=1
	mnpd2 (net13 pd vssa vssa) nmos1 l=180n w=1u m=1
	mnc01 (net13 net69 net12 vssa) nmos1 l=180n w=1u m=1
	mpb02 (net27 net51 net158 vdda) pmos1 l=180n w=1u m=1
	mppd1 (net158 xpd vdda vdda) pmos1 l=180n w=1u m=1
	mps11 (net31 net158 vdda vdda) pmos1 l=180n w=1u m=1
	mpd11 (net56 inn net31 net31) pmos1 l=180n w=1u m=1
	mp001 (out net158 vdda vdda) pmos1 l=180n w=1u m=1
	mpd12 (net13 inp net31 net31) pmos1 l=2.6e-07n w=1.1e-06u m=1
	mpb01 (net158 net158 vdda vdda) pmos1 l=180n w=1u m=1
ends OPAMP1_variant37

subckt OPAMP1_variant38 inn inp out pd xpd vdda vssa
	xd1 (vssa vdda) prim_nwd AREA=6.13907e-9 PJ=476.6e-6 m=1
	xi0 (vssa net69) prim_nd AREA=1e-12 PJ=4e-6 m=1
	xi3 (net51 vdda) prim_pd AREA=790e-15 PJ=3.3e-6 m=1
	xr0 (vssa vdda net51) prim_rdiffp l=2.1e-6 w=700e-9 m=1
	xr1 (vdda vdda net69) prim_rdiffp l=2.1e-6 w=700e-9 m=1
	xcc01 (net12 out) prim_cpoly c=1p m=1
	mnm12 (net13 net56 vssa vssa) nmos1 l=180n w=1u m=1
	mnm11 (net56 net56 vssa vssa) nmos1 l=180n w=1u m=1
	mnb02 (net27 net27 net21 vssa) nmos1 l=2.7e-07n w=1.1e-06u m=1
	mnpd1 (net21 xpd vssa vssa) nmos1 l=180n w=1u m=1
	mn001 (out net13 vssa vssa) nmos1 l=1.5e-07n w=1.3e-06u m=1
	mnpd2 (net13 pd vssa vssa) nmos1 l=180n w=1u m=1
	mnc01 (net13 net69 net12 vssa) nmos1 l=180n w=1u m=1
	mpb02 (net27 net51 net158 vdda) pmos1 l=180n w=1u m=1
	mppd1 (net158 xpd vdda vdda) pmos1 l=2.7e-07n w=1.2e-06u m=1
	mps11 (net31 net158 vdda vdda) pmos1 l=180n w=1u m=1
	mpd11 (net56 inn net31 net31) pmos1 l=180n w=1u m=1
	mp001 (out net158 vdda vdda) pmos1 l=180n w=1u m=1
	mpd12 (net13 inp net31 net31) pmos1 l=180n w=1u m=1
	mpb01 (net158 net158 vdda vdda) pmos1 l=180n w=1u m=1
ends OPAMP1_variant38

subckt OPAMP1_variant39 inn inp out pd xpd vdda vssa
	xd1 (vssa vdda) prim_nwd AREA=6.13907e-9 PJ=476.6e-6 m=1
	xi0 (vssa net69) prim_nd AREA=1e-12 PJ=4e-6 m=1
	xi3 (net51 vdda) prim_pd AREA=790e-15 PJ=3.3e-6 m=1
	xr0 (vssa vdda net51) prim_rdiffp l=2.1e-6 w=700e-9 m=1
	xr1 (vdda vdda net69) prim_rdiffp l=2.1e-6 w=700e-9 m=1
	xcc01 (net12 out) prim_cpoly c=1p m=1
	mnm12 (net13 net56 vssa vssa) nmos1 l=180n w=1u m=1
	mnm11 (net56 net56 vssa vssa) nmos1 l=180n w=1u m=1
	mnb02 (net27 net27 net21 vssa) nmos1 l=2.5e-07n w=5.9e-07u m=1
	mnpd1 (net21 xpd vssa vssa) nmos1 l=180n w=1u m=1
	mn001 (out net13 vssa vssa) nmos1 l=180n w=1u m=1
	mnpd2 (net13 pd vssa vssa) nmos1 l=180n w=1u m=1
	mnc01 (net13 net69 net12 vssa) nmos1 l=180n w=1u m=1
	mpb02 (net27 net51 net158 vdda) pmos1 l=180n w=1u m=1
	mppd1 (net158 xpd vdda vdda) pmos1 l=180n w=1u m=1
	mps11 (net31 net158 vdda vdda) pmos1 l=180n w=1u m=1
	mpd11 (net56 inn net31 net31) pmos1 l=2.3e-07n w=1.5e-06u m=1
	mp001 (out net158 vdda vdda) pmos1 l=180n w=1u m=1
	mpd12 (net13 inp net31 net31) pmos1 l=180n w=1u m=1
	mpb01 (net158 net158 vdda vdda) pmos1 l=180n w=1u m=1
ends OPAMP1_variant39

subckt OPAMP1_variant40 inn inp out pd xpd vdda vssa
	xd1 (vssa vdda) prim_nwd AREA=6.13907e-9 PJ=476.6e-6 m=1
	xi0 (vssa net69) prim_nd AREA=1e-12 PJ=4e-6 m=1
	xi3 (net51 vdda) prim_pd AREA=790e-15 PJ=3.3e-6 m=1
	xr0 (vssa vdda net51) prim_rdiffp l=2.5e-07 w=8.3e-07 m=1
	xr1 (vdda vdda net69) prim_rdiffp l=2.1e-6 w=700e-9 m=1
	xcc01 (net12 out) prim_cpoly c=1.2e-12p m=1
	mnm12 (net13 net56 vssa vssa) nmos1 l=180n w=1u m=1
	mnm11 (net56 net56 vssa vssa) nmos1 l=180n w=1u m=1
	mnb02 (net27 net27 net21 vssa) nmos1 l=180n w=1u m=1
	mnpd1 (net21 xpd vssa vssa) nmos1 l=180n w=1u m=1
	mn001 (out net13 vssa vssa) nmos1 l=180n w=1u m=1
	mnpd2 (net13 pd vssa vssa) nmos1 l=180n w=1u m=1
	mnc01 (net13 net69 net12 vssa) nmos1 l=2.9e-07n w=5.7e-07u m=1
	mpb02 (net27 net51 net158 vdda) pmos1 l=180n w=1u m=1
	mppd1 (net158 xpd vdda vdda) pmos1 l=180n w=1u m=1
	mps11 (net31 net158 vdda vdda) pmos1 l=1.3e-07n w=1.5e-06u m=1
	mpd11 (net56 inn net31 net31) pmos1 l=1.9e-07n w=1.3e-06u m=1
	mp001 (out net158 vdda vdda) pmos1 l=180n w=1u m=1
	mpd12 (net13 inp net31 net31) pmos1 l=180n w=1u m=1
	mpb01 (net158 net158 vdda vdda) pmos1 l=180n w=1u m=1
ends OPAMP1_variant40

subckt OPAMP1_variant41 inn inp out pd xpd vdda vssa
	xd1 (vssa vdda) prim_nwd AREA=6.13907e-9 PJ=476.6e-6 m=1
	xi0 (vssa net69) prim_nd AREA=1e-12 PJ=4e-6 m=1
	xi3 (net51 vdda) prim_pd AREA=790e-15 PJ=3.3e-6 m=1
	xr0 (vssa vdda net51) prim_rdiffp l=1.4e-07 w=1.8e-06 m=1
	xr1 (vdda vdda net69) prim_rdiffp l=2.1e-6 w=700e-9 m=1
	xcc01 (net12 out) prim_cpoly c=1p m=1
	mnm12 (net13 net56 vssa vssa) nmos1 l=180n w=1u m=1
	mnm11 (net56 net56 vssa vssa) nmos1 l=2.9e-07n w=1.4e-06u m=1
	mnb02 (net27 net27 net21 vssa) nmos1 l=180n w=1u m=1
	mnpd1 (net21 xpd vssa vssa) nmos1 l=180n w=1u m=1
	mn001 (out net13 vssa vssa) nmos1 l=180n w=1u m=1
	mnpd2 (net13 pd vssa vssa) nmos1 l=2.9e-07n w=1.8e-06u m=1
	mnc01 (net13 net69 net12 vssa) nmos1 l=2.1e-07n w=5.9e-07u m=1
	mpb02 (net27 net51 net158 vdda) pmos1 l=180n w=1u m=1
	mppd1 (net158 xpd vdda vdda) pmos1 l=180n w=1u m=1
	mps11 (net31 net158 vdda vdda) pmos1 l=180n w=1u m=1
	mpd11 (net56 inn net31 net31) pmos1 l=180n w=1u m=1
	mp001 (out net158 vdda vdda) pmos1 l=180n w=1u m=1
	mpd12 (net13 inp net31 net31) pmos1 l=180n w=1u m=1
	mpb01 (net158 net158 vdda vdda) pmos1 l=180n w=1u m=1
ends OPAMP1_variant41

subckt OPAMP1_variant42 inn inp out pd xpd vdda vssa
	xd1 (vssa vdda) prim_nwd AREA=6.13907e-9 PJ=476.6e-6 m=1
	xi0 (vssa net69) prim_nd AREA=1e-12 PJ=4e-6 m=1
	xi3 (net51 vdda) prim_pd AREA=1.6e-09 PJ=6.2e-05 m=1
	xr0 (vssa vdda net51) prim_rdiffp l=2.1e-6 w=700e-9 m=1
	xr1 (vdda vdda net69) prim_rdiffp l=2.1e-6 w=700e-9 m=1
	xcc01 (net12 out) prim_cpoly c=1p m=1
	mnm12 (net13 net56 vssa vssa) nmos1 l=180n w=1u m=1
	mnm11 (net56 net56 vssa vssa) nmos1 l=180n w=1u m=1
	mnb02 (net27 net27 net21 vssa) nmos1 l=180n w=1u m=1
	mnpd1 (net21 xpd vssa vssa) nmos1 l=180n w=1u m=1
	mn001 (out net13 vssa vssa) nmos1 l=1.9e-07n w=5.9e-07u m=1
	mnpd2 (net13 pd vssa vssa) nmos1 l=180n w=1u m=1
	mnc01 (net13 net69 net12 vssa) nmos1 l=180n w=1u m=1
	mpb02 (net27 net51 net158 vdda) pmos1 l=180n w=1u m=1
	mppd1 (net158 xpd vdda vdda) pmos1 l=180n w=1u m=1
	mps11 (net31 net158 vdda vdda) pmos1 l=180n w=1u m=1
	mpd11 (net56 inn net31 net31) pmos1 l=180n w=1u m=1
	mp001 (out net158 vdda vdda) pmos1 l=180n w=1u m=1
	mpd12 (net13 inp net31 net31) pmos1 l=180n w=1u m=1
	mpb01 (net158 net158 vdda vdda) pmos1 l=180n w=1u m=1
ends OPAMP1_variant42

subckt OPAMP1_variant43 inn inp out pd xpd vdda vssa
	xd1 (vssa vdda) prim_nwd AREA=6.13907e-9 PJ=476.6e-6 m=1
	xi0 (vssa net69) prim_nd AREA=1e-12 PJ=4e-6 m=1
	xi3 (net51 vdda) prim_pd AREA=790e-15 PJ=3.3e-6 m=1
	xr0 (vssa vdda net51) prim_rdiffp l=2.1e-6 w=700e-9 m=1
	xr1 (vdda vdda net69) prim_rdiffp l=2.1e-6 w=700e-9 m=1
	xcc01 (net12 out) prim_cpoly c=1p m=1
	mnm12 (net13 net56 vssa vssa) nmos1 l=1.6e-07n w=1.8e-06u m=1
	mnm11 (net56 net56 vssa vssa) nmos1 l=180n w=1u m=1
	mnb02 (net27 net27 net21 vssa) nmos1 l=2.6e-07n w=1.5e-06u m=1
	mnpd1 (net21 xpd vssa vssa) nmos1 l=180n w=1u m=1
	mn001 (out net13 vssa vssa) nmos1 l=180n w=1u m=1
	mnpd2 (net13 pd vssa vssa) nmos1 l=1.6e-07n w=7.8e-07u m=1
	mnc01 (net13 net69 net12 vssa) nmos1 l=180n w=1u m=1
	mpb02 (net27 net51 net158 vdda) pmos1 l=180n w=1u m=1
	mppd1 (net158 xpd vdda vdda) pmos1 l=2.4e-07n w=1.8e-06u m=1
	mps11 (net31 net158 vdda vdda) pmos1 l=180n w=1u m=1
	mpd11 (net56 inn net31 net31) pmos1 l=2.9e-07n w=7.3e-07u m=1
	mp001 (out net158 vdda vdda) pmos1 l=180n w=1u m=1
	mpd12 (net13 inp net31 net31) pmos1 l=180n w=1u m=1
	mpb01 (net158 net158 vdda vdda) pmos1 l=180n w=1u m=1
ends OPAMP1_variant43

subckt OPAMP1_variant44 inn inp out pd xpd vdda vssa
	xd1 (vssa vdda) prim_nwd AREA=6.13907e-9 PJ=476.6e-6 m=1
	xi0 (vssa net69) prim_nd AREA=1e-12 PJ=4e-6 m=1
	xi3 (net51 vdda) prim_pd AREA=4.5e-09 PJ=4.5e-05 m=1
	xr0 (vssa vdda net51) prim_rdiffp l=1.4e-07 w=1.1e-06 m=1
	xr1 (vdda vdda net69) prim_rdiffp l=2.1e-6 w=700e-9 m=1
	xcc01 (net12 out) prim_cpoly c=1p m=1
	mnm12 (net13 net56 vssa vssa) nmos1 l=180n w=1u m=1
	mnm11 (net56 net56 vssa vssa) nmos1 l=180n w=1u m=1
	mnb02 (net27 net27 net21 vssa) nmos1 l=180n w=1u m=1
	mnpd1 (net21 xpd vssa vssa) nmos1 l=180n w=1u m=1
	mn001 (out net13 vssa vssa) nmos1 l=180n w=1u m=1
	mnpd2 (net13 pd vssa vssa) nmos1 l=180n w=1u m=1
	mnc01 (net13 net69 net12 vssa) nmos1 l=180n w=1u m=1
	mpb02 (net27 net51 net158 vdda) pmos1 l=180n w=1u m=1
	mppd1 (net158 xpd vdda vdda) pmos1 l=180n w=1u m=1
	mps11 (net31 net158 vdda vdda) pmos1 l=180n w=1u m=1
	mpd11 (net56 inn net31 net31) pmos1 l=180n w=1u m=1
	mp001 (out net158 vdda vdda) pmos1 l=180n w=1u m=1
	mpd12 (net13 inp net31 net31) pmos1 l=180n w=1u m=1
	mpb01 (net158 net158 vdda vdda) pmos1 l=180n w=1u m=1
ends OPAMP1_variant44

subckt OPAMP1_variant45 inn inp out pd xpd vdda vssa
	xd1 (vssa vdda) prim_nwd AREA=6.13907e-9 PJ=476.6e-6 m=1
	xi0 (vssa net69) prim_nd AREA=4.1e-09 PJ=3.8e-05 m=1
	xi3 (net51 vdda) prim_pd AREA=790e-15 PJ=3.3e-6 m=1
	xr0 (vssa vdda net51) prim_rdiffp l=2.7e-07 w=5.3e-07 m=1
	xr1 (vdda vdda net69) prim_rdiffp l=2.1e-6 w=700e-9 m=1
	xcc01 (net12 out) prim_cpoly c=1p m=1
	mnm12 (net13 net56 vssa vssa) nmos1 l=180n w=1u m=1
	mnm11 (net56 net56 vssa vssa) nmos1 l=180n w=1u m=1
	mnb02 (net27 net27 net21 vssa) nmos1 l=180n w=1u m=1
	mnpd1 (net21 xpd vssa vssa) nmos1 l=180n w=1u m=1
	mn001 (out net13 vssa vssa) nmos1 l=180n w=1u m=1
	mnpd2 (net13 pd vssa vssa) nmos1 l=180n w=1u m=1
	mnc01 (net13 net69 net12 vssa) nmos1 l=180n w=1u m=1
	mpb02 (net27 net51 net158 vdda) pmos1 l=180n w=1u m=1
	mppd1 (net158 xpd vdda vdda) pmos1 l=180n w=1u m=1
	mps11 (net31 net158 vdda vdda) pmos1 l=180n w=1u m=1
	mpd11 (net56 inn net31 net31) pmos1 l=180n w=1u m=1
	mp001 (out net158 vdda vdda) pmos1 l=180n w=1u m=1
	mpd12 (net13 inp net31 net31) pmos1 l=180n w=1u m=1
	mpb01 (net158 net158 vdda vdda) pmos1 l=180n w=1u m=1
ends OPAMP1_variant45

subckt OPAMP1_variant46 inn inp out pd xpd vdda vssa
	xd1 (vssa vdda) prim_nwd AREA=6.13907e-9 PJ=476.6e-6 m=1
	xi0 (vssa net69) prim_nd AREA=2.1e-09 PJ=9.3e-05 m=1
	xi3 (net51 vdda) prim_pd AREA=790e-15 PJ=3.3e-6 m=1
	xr0 (vssa vdda net51) prim_rdiffp l=2.1e-6 w=700e-9 m=1
	xr1 (vdda vdda net69) prim_rdiffp l=1.3e-07 w=9.7e-07 m=1
	xcc01 (net12 out) prim_cpoly c=1p m=1
	mnm12 (net13 net56 vssa vssa) nmos1 l=180n w=1u m=1
	mnm11 (net56 net56 vssa vssa) nmos1 l=2.0e-07n w=2.0e-06u m=1
	mnb02 (net27 net27 net21 vssa) nmos1 l=180n w=1u m=1
	mnpd1 (net21 xpd vssa vssa) nmos1 l=180n w=1u m=1
	mn001 (out net13 vssa vssa) nmos1 l=1.0e-07n w=9.8e-07u m=1
	mnpd2 (net13 pd vssa vssa) nmos1 l=180n w=1u m=1
	mnc01 (net13 net69 net12 vssa) nmos1 l=180n w=1u m=1
	mpb02 (net27 net51 net158 vdda) pmos1 l=180n w=1u m=1
	mppd1 (net158 xpd vdda vdda) pmos1 l=2.4e-07n w=9.8e-07u m=1
	mps11 (net31 net158 vdda vdda) pmos1 l=180n w=1u m=1
	mpd11 (net56 inn net31 net31) pmos1 l=180n w=1u m=1
	mp001 (out net158 vdda vdda) pmos1 l=180n w=1u m=1
	mpd12 (net13 inp net31 net31) pmos1 l=180n w=1u m=1
	mpb01 (net158 net158 vdda vdda) pmos1 l=180n w=1u m=1
ends OPAMP1_variant46

subckt OPAMP1_variant47 inn inp out pd xpd vdda vssa
	xd1 (vssa vdda) prim_nwd AREA=6.13907e-9 PJ=476.6e-6 m=1
	xi0 (vssa net69) prim_nd AREA=1e-12 PJ=4e-6 m=1
	xi3 (net51 vdda) prim_pd AREA=790e-15 PJ=3.3e-6 m=1
	xr0 (vssa vdda net51) prim_rdiffp l=2.1e-6 w=700e-9 m=1
	xr1 (vdda vdda net69) prim_rdiffp l=2.3e-07 w=1.5e-06 m=1
	xcc01 (net12 out) prim_cpoly c=1p m=1
	mnm12 (net13 net56 vssa vssa) nmos1 l=180n w=1u m=1
	mnm11 (net56 net56 vssa vssa) nmos1 l=2.2e-07n w=1.7e-06u m=1
	mnb02 (net27 net27 net21 vssa) nmos1 l=180n w=1u m=1
	mnpd1 (net21 xpd vssa vssa) nmos1 l=180n w=1u m=1
	mn001 (out net13 vssa vssa) nmos1 l=180n w=1u m=1
	mnpd2 (net13 pd vssa vssa) nmos1 l=180n w=1u m=1
	mnc01 (net13 net69 net12 vssa) nmos1 l=2.7e-07n w=1.9e-06u m=1
	mpb02 (net27 net51 net158 vdda) pmos1 l=1.5e-07n w=1.7e-06u m=1
	mppd1 (net158 xpd vdda vdda) pmos1 l=180n w=1u m=1
	mps11 (net31 net158 vdda vdda) pmos1 l=180n w=1u m=1
	mpd11 (net56 inn net31 net31) pmos1 l=180n w=1u m=1
	mp001 (out net158 vdda vdda) pmos1 l=180n w=1u m=1
	mpd12 (net13 inp net31 net31) pmos1 l=1.7e-07n w=5.7e-07u m=1
	mpb01 (net158 net158 vdda vdda) pmos1 l=180n w=1u m=1
ends OPAMP1_variant47

subckt OPAMP1_variant48 inn inp out pd xpd vdda vssa
	xd1 (vssa vdda) prim_nwd AREA=6.13907e-9 PJ=476.6e-6 m=1
	xi0 (vssa net69) prim_nd AREA=1e-12 PJ=4e-6 m=1
	xi3 (net51 vdda) prim_pd AREA=790e-15 PJ=3.3e-6 m=1
	xr0 (vssa vdda net51) prim_rdiffp l=1.2e-07 w=1.4e-06 m=1
	xr1 (vdda vdda net69) prim_rdiffp l=2.1e-6 w=700e-9 m=1
	xcc01 (net12 out) prim_cpoly c=1p m=1
	mnm12 (net13 net56 vssa vssa) nmos1 l=180n w=1u m=1
	mnm11 (net56 net56 vssa vssa) nmos1 l=180n w=1u m=1
	mnb02 (net27 net27 net21 vssa) nmos1 l=180n w=1u m=1
	mnpd1 (net21 xpd vssa vssa) nmos1 l=180n w=1u m=1
	mn001 (out net13 vssa vssa) nmos1 l=2.9e-07n w=1.3e-06u m=1
	mnpd2 (net13 pd vssa vssa) nmos1 l=180n w=1u m=1
	mnc01 (net13 net69 net12 vssa) nmos1 l=180n w=1u m=1
	mpb02 (net27 net51 net158 vdda) pmos1 l=180n w=1u m=1
	mppd1 (net158 xpd vdda vdda) pmos1 l=180n w=1u m=1
	mps11 (net31 net158 vdda vdda) pmos1 l=180n w=1u m=1
	mpd11 (net56 inn net31 net31) pmos1 l=180n w=1u m=1
	mp001 (out net158 vdda vdda) pmos1 l=1.5e-07n w=1.7e-06u m=1
	mpd12 (net13 inp net31 net31) pmos1 l=180n w=1u m=1
	mpb01 (net158 net158 vdda vdda) pmos1 l=180n w=1u m=1
ends OPAMP1_variant48

subckt OPAMP1_variant49 inn inp out pd xpd vdda vssa
	xd1 (vssa vdda) prim_nwd AREA=6.13907e-9 PJ=476.6e-6 m=1
	xi0 (vssa net69) prim_nd AREA=1e-12 PJ=4e-6 m=1
	xi3 (net51 vdda) prim_pd AREA=790e-15 PJ=3.3e-6 m=1
	xr0 (vssa vdda net51) prim_rdiffp l=2.1e-6 w=700e-9 m=1
	xr1 (vdda vdda net69) prim_rdiffp l=1.8e-07 w=6.2e-07 m=1
	xcc01 (net12 out) prim_cpoly c=1p m=1
	mnm12 (net13 net56 vssa vssa) nmos1 l=2.1e-07n w=1.7e-06u m=1
	mnm11 (net56 net56 vssa vssa) nmos1 l=180n w=1u m=1
	mnb02 (net27 net27 net21 vssa) nmos1 l=180n w=1u m=1
	mnpd1 (net21 xpd vssa vssa) nmos1 l=180n w=1u m=1
	mn001 (out net13 vssa vssa) nmos1 l=180n w=1u m=1
	mnpd2 (net13 pd vssa vssa) nmos1 l=180n w=1u m=1
	mnc01 (net13 net69 net12 vssa) nmos1 l=180n w=1u m=1
	mpb02 (net27 net51 net158 vdda) pmos1 l=180n w=1u m=1
	mppd1 (net158 xpd vdda vdda) pmos1 l=180n w=1u m=1
	mps11 (net31 net158 vdda vdda) pmos1 l=180n w=1u m=1
	mpd11 (net56 inn net31 net31) pmos1 l=180n w=1u m=1
	mp001 (out net158 vdda vdda) pmos1 l=180n w=1u m=1
	mpd12 (net13 inp net31 net31) pmos1 l=180n w=1u m=1
	mpb01 (net158 net158 vdda vdda) pmos1 l=180n w=1u m=1
ends OPAMP1_variant49

subckt OPAMP1_variant50 inn inp out pd xpd vdda vssa
	xd1 (vssa vdda) prim_nwd AREA=6.13907e-9 PJ=476.6e-6 m=1
	xi0 (vssa net69) prim_nd AREA=1e-12 PJ=4e-6 m=1
	xi3 (net51 vdda) prim_pd AREA=790e-15 PJ=3.3e-6 m=1
	xr0 (vssa vdda net51) prim_rdiffp l=2.1e-6 w=700e-9 m=1
	xr1 (vdda vdda net69) prim_rdiffp l=2.1e-6 w=700e-9 m=1
	xcc01 (net12 out) prim_cpoly c=1p m=1
	mnm12 (net13 net56 vssa vssa) nmos1 l=180n w=1u m=1
	mnm11 (net56 net56 vssa vssa) nmos1 l=180n w=1u m=1
	mnb02 (net27 net27 net21 vssa) nmos1 l=2.0e-07n w=1.0e-06u m=1
	mnpd1 (net21 xpd vssa vssa) nmos1 l=180n w=1u m=1
	mn001 (out net13 vssa vssa) nmos1 l=180n w=1u m=1
	mnpd2 (net13 pd vssa vssa) nmos1 l=180n w=1u m=1
	mnc01 (net13 net69 net12 vssa) nmos1 l=2.3e-07n w=1.0e-06u m=1
	mpb02 (net27 net51 net158 vdda) pmos1 l=180n w=1u m=1
	mppd1 (net158 xpd vdda vdda) pmos1 l=180n w=1u m=1
	mps11 (net31 net158 vdda vdda) pmos1 l=180n w=1u m=1
	mpd11 (net56 inn net31 net31) pmos1 l=1.3e-07n w=6.5e-07u m=1
	mp001 (out net158 vdda vdda) pmos1 l=180n w=1u m=1
	mpd12 (net13 inp net31 net31) pmos1 l=180n w=1u m=1
	mpb01 (net158 net158 vdda vdda) pmos1 l=180n w=1u m=1
ends OPAMP1_variant50

subckt OPAMP1_variant51 inn inp out pd xpd vdda vssa
	xd1 (vssa vdda) prim_nwd AREA=6.13907e-9 PJ=476.6e-6 m=1
	xi0 (vssa net69) prim_nd AREA=1e-12 PJ=4e-6 m=1
	xi3 (net51 vdda) prim_pd AREA=790e-15 PJ=3.3e-6 m=1
	xr0 (vssa vdda net51) prim_rdiffp l=2.1e-6 w=700e-9 m=1
	xr1 (vdda vdda net69) prim_rdiffp l=2.1e-6 w=700e-9 m=1
	xcc01 (net12 out) prim_cpoly c=1p m=1
	mnm12 (net13 net56 vssa vssa) nmos1 l=180n w=1u m=1
	mnm11 (net56 net56 vssa vssa) nmos1 l=180n w=1u m=1
	mnb02 (net27 net27 net21 vssa) nmos1 l=1.3e-07n w=8.6e-07u m=1
	mnpd1 (net21 xpd vssa vssa) nmos1 l=180n w=1u m=1
	mn001 (out net13 vssa vssa) nmos1 l=180n w=1u m=1
	mnpd2 (net13 pd vssa vssa) nmos1 l=180n w=1u m=1
	mnc01 (net13 net69 net12 vssa) nmos1 l=180n w=1u m=1
	mpb02 (net27 net51 net158 vdda) pmos1 l=180n w=1u m=1
	mppd1 (net158 xpd vdda vdda) pmos1 l=180n w=1u m=1
	mps11 (net31 net158 vdda vdda) pmos1 l=180n w=1u m=1
	mpd11 (net56 inn net31 net31) pmos1 l=2.2e-07n w=1.9e-06u m=1
	mp001 (out net158 vdda vdda) pmos1 l=2.2e-07n w=1.5e-06u m=1
	mpd12 (net13 inp net31 net31) pmos1 l=180n w=1u m=1
	mpb01 (net158 net158 vdda vdda) pmos1 l=180n w=1u m=1
ends OPAMP1_variant51

subckt OPAMP1_variant52 inn inp out pd xpd vdda vssa
	xd1 (vssa vdda) prim_nwd AREA=6.13907e-9 PJ=476.6e-6 m=1
	xi0 (vssa net69) prim_nd AREA=7.9e-11 PJ=3.9e-06 m=1
	xi3 (net51 vdda) prim_pd AREA=790e-15 PJ=3.3e-6 m=1
	xr0 (vssa vdda net51) prim_rdiffp l=2.1e-6 w=700e-9 m=1
	xr1 (vdda vdda net69) prim_rdiffp l=2.1e-6 w=700e-9 m=1
	xcc01 (net12 out) prim_cpoly c=1p m=1
	mnm12 (net13 net56 vssa vssa) nmos1 l=180n w=1u m=1
	mnm11 (net56 net56 vssa vssa) nmos1 l=180n w=1u m=1
	mnb02 (net27 net27 net21 vssa) nmos1 l=180n w=1u m=1
	mnpd1 (net21 xpd vssa vssa) nmos1 l=1.1e-07n w=7.1e-07u m=1
	mn001 (out net13 vssa vssa) nmos1 l=180n w=1u m=1
	mnpd2 (net13 pd vssa vssa) nmos1 l=180n w=1u m=1
	mnc01 (net13 net69 net12 vssa) nmos1 l=180n w=1u m=1
	mpb02 (net27 net51 net158 vdda) pmos1 l=180n w=1u m=1
	mppd1 (net158 xpd vdda vdda) pmos1 l=180n w=1u m=1
	mps11 (net31 net158 vdda vdda) pmos1 l=180n w=1u m=1
	mpd11 (net56 inn net31 net31) pmos1 l=180n w=1u m=1
	mp001 (out net158 vdda vdda) pmos1 l=180n w=1u m=1
	mpd12 (net13 inp net31 net31) pmos1 l=180n w=1u m=1
	mpb01 (net158 net158 vdda vdda) pmos1 l=180n w=1u m=1
ends OPAMP1_variant52

subckt OPAMP1_variant53 inn inp out pd xpd vdda vssa
	xd1 (vssa vdda) prim_nwd AREA=6.13907e-9 PJ=476.6e-6 m=1
	xi0 (vssa net69) prim_nd AREA=1e-12 PJ=4e-6 m=1
	xi3 (net51 vdda) prim_pd AREA=790e-15 PJ=3.3e-6 m=1
	xr0 (vssa vdda net51) prim_rdiffp l=2.1e-6 w=700e-9 m=1
	xr1 (vdda vdda net69) prim_rdiffp l=1.4e-07 w=6.1e-07 m=1
	xcc01 (net12 out) prim_cpoly c=1p m=1
	mnm12 (net13 net56 vssa vssa) nmos1 l=180n w=1u m=1
	mnm11 (net56 net56 vssa vssa) nmos1 l=180n w=1u m=1
	mnb02 (net27 net27 net21 vssa) nmos1 l=180n w=1u m=1
	mnpd1 (net21 xpd vssa vssa) nmos1 l=180n w=1u m=1
	mn001 (out net13 vssa vssa) nmos1 l=180n w=1u m=1
	mnpd2 (net13 pd vssa vssa) nmos1 l=180n w=1u m=1
	mnc01 (net13 net69 net12 vssa) nmos1 l=1.9e-07n w=1.6e-06u m=1
	mpb02 (net27 net51 net158 vdda) pmos1 l=1.2e-07n w=1.4e-06u m=1
	mppd1 (net158 xpd vdda vdda) pmos1 l=2.2e-07n w=8.9e-07u m=1
	mps11 (net31 net158 vdda vdda) pmos1 l=180n w=1u m=1
	mpd11 (net56 inn net31 net31) pmos1 l=180n w=1u m=1
	mp001 (out net158 vdda vdda) pmos1 l=180n w=1u m=1
	mpd12 (net13 inp net31 net31) pmos1 l=180n w=1u m=1
	mpb01 (net158 net158 vdda vdda) pmos1 l=180n w=1u m=1
ends OPAMP1_variant53

subckt OPAMP1_variant54 inn inp out pd xpd vdda vssa
	xd1 (vssa vdda) prim_nwd AREA=6.7e-09 PJ=3.5e-05 m=1
	xi0 (vssa net69) prim_nd AREA=1e-12 PJ=4e-6 m=1
	xi3 (net51 vdda) prim_pd AREA=790e-15 PJ=3.3e-6 m=1
	xr0 (vssa vdda net51) prim_rdiffp l=2.1e-6 w=700e-9 m=1
	xr1 (vdda vdda net69) prim_rdiffp l=1.8e-07 w=1.8e-06 m=1
	xcc01 (net12 out) prim_cpoly c=1p m=1
	mnm12 (net13 net56 vssa vssa) nmos1 l=180n w=1u m=1
	mnm11 (net56 net56 vssa vssa) nmos1 l=180n w=1u m=1
	mnb02 (net27 net27 net21 vssa) nmos1 l=180n w=1u m=1
	mnpd1 (net21 xpd vssa vssa) nmos1 l=180n w=1u m=1
	mn001 (out net13 vssa vssa) nmos1 l=180n w=1u m=1
	mnpd2 (net13 pd vssa vssa) nmos1 l=2.9e-07n w=1.9e-06u m=1
	mnc01 (net13 net69 net12 vssa) nmos1 l=180n w=1u m=1
	mpb02 (net27 net51 net158 vdda) pmos1 l=180n w=1u m=1
	mppd1 (net158 xpd vdda vdda) pmos1 l=180n w=1u m=1
	mps11 (net31 net158 vdda vdda) pmos1 l=180n w=1u m=1
	mpd11 (net56 inn net31 net31) pmos1 l=1.2e-07n w=1.1e-06u m=1
	mp001 (out net158 vdda vdda) pmos1 l=180n w=1u m=1
	mpd12 (net13 inp net31 net31) pmos1 l=180n w=1u m=1
	mpb01 (net158 net158 vdda vdda) pmos1 l=180n w=1u m=1
ends OPAMP1_variant54

subckt OPAMP1_variant55 inn inp out pd xpd vdda vssa
	xd1 (vssa vdda) prim_nwd AREA=6.13907e-9 PJ=476.6e-6 m=1
	xi0 (vssa net69) prim_nd AREA=9.1e-09 PJ=7.0e-05 m=1
	xi3 (net51 vdda) prim_pd AREA=790e-15 PJ=3.3e-6 m=1
	xr0 (vssa vdda net51) prim_rdiffp l=2.1e-6 w=700e-9 m=1
	xr1 (vdda vdda net69) prim_rdiffp l=2.1e-6 w=700e-9 m=1
	xcc01 (net12 out) prim_cpoly c=1p m=1
	mnm12 (net13 net56 vssa vssa) nmos1 l=2.5e-07n w=1.6e-06u m=1
	mnm11 (net56 net56 vssa vssa) nmos1 l=180n w=1u m=1
	mnb02 (net27 net27 net21 vssa) nmos1 l=180n w=1u m=1
	mnpd1 (net21 xpd vssa vssa) nmos1 l=1.1e-07n w=1.4e-06u m=1
	mn001 (out net13 vssa vssa) nmos1 l=180n w=1u m=1
	mnpd2 (net13 pd vssa vssa) nmos1 l=180n w=1u m=1
	mnc01 (net13 net69 net12 vssa) nmos1 l=180n w=1u m=1
	mpb02 (net27 net51 net158 vdda) pmos1 l=180n w=1u m=1
	mppd1 (net158 xpd vdda vdda) pmos1 l=180n w=1u m=1
	mps11 (net31 net158 vdda vdda) pmos1 l=1.4e-07n w=7.6e-07u m=1
	mpd11 (net56 inn net31 net31) pmos1 l=180n w=1u m=1
	mp001 (out net158 vdda vdda) pmos1 l=2.9e-07n w=1.2e-06u m=1
	mpd12 (net13 inp net31 net31) pmos1 l=180n w=1u m=1
	mpb01 (net158 net158 vdda vdda) pmos1 l=180n w=1u m=1
ends OPAMP1_variant55

subckt OPAMP1_variant56 inn inp out pd xpd vdda vssa
	xd1 (vssa vdda) prim_nwd AREA=6.13907e-9 PJ=476.6e-6 m=1
	xi0 (vssa net69) prim_nd AREA=1e-12 PJ=4e-6 m=1
	xi3 (net51 vdda) prim_pd AREA=790e-15 PJ=3.3e-6 m=1
	xr0 (vssa vdda net51) prim_rdiffp l=1.7e-07 w=8.4e-07 m=1
	xr1 (vdda vdda net69) prim_rdiffp l=2.1e-6 w=700e-9 m=1
	xcc01 (net12 out) prim_cpoly c=1p m=1
	mnm12 (net13 net56 vssa vssa) nmos1 l=2.4e-07n w=1.9e-06u m=1
	mnm11 (net56 net56 vssa vssa) nmos1 l=180n w=1u m=1
	mnb02 (net27 net27 net21 vssa) nmos1 l=180n w=1u m=1
	mnpd1 (net21 xpd vssa vssa) nmos1 l=180n w=1u m=1
	mn001 (out net13 vssa vssa) nmos1 l=180n w=1u m=1
	mnpd2 (net13 pd vssa vssa) nmos1 l=1.6e-07n w=9.1e-07u m=1
	mnc01 (net13 net69 net12 vssa) nmos1 l=180n w=1u m=1
	mpb02 (net27 net51 net158 vdda) pmos1 l=180n w=1u m=1
	mppd1 (net158 xpd vdda vdda) pmos1 l=180n w=1u m=1
	mps11 (net31 net158 vdda vdda) pmos1 l=180n w=1u m=1
	mpd11 (net56 inn net31 net31) pmos1 l=180n w=1u m=1
	mp001 (out net158 vdda vdda) pmos1 l=2.3e-07n w=1.4e-06u m=1
	mpd12 (net13 inp net31 net31) pmos1 l=2.8e-07n w=8.5e-07u m=1
	mpb01 (net158 net158 vdda vdda) pmos1 l=180n w=1u m=1
ends OPAMP1_variant56

subckt OPAMP1_variant57 inn inp out pd xpd vdda vssa
	xd1 (vssa vdda) prim_nwd AREA=6.13907e-9 PJ=476.6e-6 m=1
	xi0 (vssa net69) prim_nd AREA=1e-12 PJ=4e-6 m=1
	xi3 (net51 vdda) prim_pd AREA=790e-15 PJ=3.3e-6 m=1
	xr0 (vssa vdda net51) prim_rdiffp l=2.1e-6 w=700e-9 m=1
	xr1 (vdda vdda net69) prim_rdiffp l=2.1e-6 w=700e-9 m=1
	xcc01 (net12 out) prim_cpoly c=1.1e-12p m=1
	mnm12 (net13 net56 vssa vssa) nmos1 l=180n w=1u m=1
	mnm11 (net56 net56 vssa vssa) nmos1 l=2.5e-07n w=1.0e-06u m=1
	mnb02 (net27 net27 net21 vssa) nmos1 l=180n w=1u m=1
	mnpd1 (net21 xpd vssa vssa) nmos1 l=2.2e-07n w=1.3e-06u m=1
	mn001 (out net13 vssa vssa) nmos1 l=180n w=1u m=1
	mnpd2 (net13 pd vssa vssa) nmos1 l=180n w=1u m=1
	mnc01 (net13 net69 net12 vssa) nmos1 l=180n w=1u m=1
	mpb02 (net27 net51 net158 vdda) pmos1 l=180n w=1u m=1
	mppd1 (net158 xpd vdda vdda) pmos1 l=2.4e-07n w=8.0e-07u m=1
	mps11 (net31 net158 vdda vdda) pmos1 l=180n w=1u m=1
	mpd11 (net56 inn net31 net31) pmos1 l=180n w=1u m=1
	mp001 (out net158 vdda vdda) pmos1 l=180n w=1u m=1
	mpd12 (net13 inp net31 net31) pmos1 l=180n w=1u m=1
	mpb01 (net158 net158 vdda vdda) pmos1 l=180n w=1u m=1
ends OPAMP1_variant57

subckt OPAMP1_variant58 inn inp out pd xpd vdda vssa
	xd1 (vssa vdda) prim_nwd AREA=6.13907e-9 PJ=476.6e-6 m=1
	xi0 (vssa net69) prim_nd AREA=1e-12 PJ=4e-6 m=1
	xi3 (net51 vdda) prim_pd AREA=790e-15 PJ=3.3e-6 m=1
	xr0 (vssa vdda net51) prim_rdiffp l=2.1e-6 w=700e-9 m=1
	xr1 (vdda vdda net69) prim_rdiffp l=2.1e-6 w=700e-9 m=1
	xcc01 (net12 out) prim_cpoly c=1p m=1
	mnm12 (net13 net56 vssa vssa) nmos1 l=180n w=1u m=1
	mnm11 (net56 net56 vssa vssa) nmos1 l=180n w=1u m=1
	mnb02 (net27 net27 net21 vssa) nmos1 l=180n w=1u m=1
	mnpd1 (net21 xpd vssa vssa) nmos1 l=180n w=1u m=1
	mn001 (out net13 vssa vssa) nmos1 l=180n w=1u m=1
	mnpd2 (net13 pd vssa vssa) nmos1 l=180n w=1u m=1
	mnc01 (net13 net69 net12 vssa) nmos1 l=1.1e-07n w=2.0e-06u m=1
	mpb02 (net27 net51 net158 vdda) pmos1 l=180n w=1u m=1
	mppd1 (net158 xpd vdda vdda) pmos1 l=180n w=1u m=1
	mps11 (net31 net158 vdda vdda) pmos1 l=3.0e-07n w=1.6e-06u m=1
	mpd11 (net56 inn net31 net31) pmos1 l=180n w=1u m=1
	mp001 (out net158 vdda vdda) pmos1 l=1.0e-07n w=7.2e-07u m=1
	mpd12 (net13 inp net31 net31) pmos1 l=180n w=1u m=1
	mpb01 (net158 net158 vdda vdda) pmos1 l=180n w=1u m=1
ends OPAMP1_variant58

subckt OPAMP1_variant59 inn inp out pd xpd vdda vssa
	xd1 (vssa vdda) prim_nwd AREA=6.13907e-9 PJ=476.6e-6 m=1
	xi0 (vssa net69) prim_nd AREA=1e-12 PJ=4e-6 m=1
	xi3 (net51 vdda) prim_pd AREA=5.1e-09 PJ=9.3e-05 m=1
	xr0 (vssa vdda net51) prim_rdiffp l=2.3e-07 w=6.6e-07 m=1
	xr1 (vdda vdda net69) prim_rdiffp l=2.1e-6 w=700e-9 m=1
	xcc01 (net12 out) prim_cpoly c=1p m=1
	mnm12 (net13 net56 vssa vssa) nmos1 l=180n w=1u m=1
	mnm11 (net56 net56 vssa vssa) nmos1 l=180n w=1u m=1
	mnb02 (net27 net27 net21 vssa) nmos1 l=2.7e-07n w=6.8e-07u m=1
	mnpd1 (net21 xpd vssa vssa) nmos1 l=180n w=1u m=1
	mn001 (out net13 vssa vssa) nmos1 l=180n w=1u m=1
	mnpd2 (net13 pd vssa vssa) nmos1 l=180n w=1u m=1
	mnc01 (net13 net69 net12 vssa) nmos1 l=180n w=1u m=1
	mpb02 (net27 net51 net158 vdda) pmos1 l=180n w=1u m=1
	mppd1 (net158 xpd vdda vdda) pmos1 l=180n w=1u m=1
	mps11 (net31 net158 vdda vdda) pmos1 l=180n w=1u m=1
	mpd11 (net56 inn net31 net31) pmos1 l=1.7e-07n w=1.9e-06u m=1
	mp001 (out net158 vdda vdda) pmos1 l=180n w=1u m=1
	mpd12 (net13 inp net31 net31) pmos1 l=180n w=1u m=1
	mpb01 (net158 net158 vdda vdda) pmos1 l=180n w=1u m=1
ends OPAMP1_variant59

subckt OPAMP1_variant60 inn inp out pd xpd vdda vssa
	xd1 (vssa vdda) prim_nwd AREA=6.13907e-9 PJ=476.6e-6 m=1
	xi0 (vssa net69) prim_nd AREA=4.0e-09 PJ=7.0e-05 m=1
	xi3 (net51 vdda) prim_pd AREA=790e-15 PJ=3.3e-6 m=1
	xr0 (vssa vdda net51) prim_rdiffp l=2.1e-6 w=700e-9 m=1
	xr1 (vdda vdda net69) prim_rdiffp l=2.1e-6 w=700e-9 m=1
	xcc01 (net12 out) prim_cpoly c=1p m=1
	mnm12 (net13 net56 vssa vssa) nmos1 l=180n w=1u m=1
	mnm11 (net56 net56 vssa vssa) nmos1 l=180n w=1u m=1
	mnb02 (net27 net27 net21 vssa) nmos1 l=180n w=1u m=1
	mnpd1 (net21 xpd vssa vssa) nmos1 l=180n w=1u m=1
	mn001 (out net13 vssa vssa) nmos1 l=180n w=1u m=1
	mnpd2 (net13 pd vssa vssa) nmos1 l=180n w=1u m=1
	mnc01 (net13 net69 net12 vssa) nmos1 l=180n w=1u m=1
	mpb02 (net27 net51 net158 vdda) pmos1 l=180n w=1u m=1
	mppd1 (net158 xpd vdda vdda) pmos1 l=180n w=1u m=1
	mps11 (net31 net158 vdda vdda) pmos1 l=180n w=1u m=1
	mpd11 (net56 inn net31 net31) pmos1 l=180n w=1u m=1
	mp001 (out net158 vdda vdda) pmos1 l=180n w=1u m=1
	mpd12 (net13 inp net31 net31) pmos1 l=1.8e-07n w=1.6e-06u m=1
	mpb01 (net158 net158 vdda vdda) pmos1 l=180n w=1u m=1
ends OPAMP1_variant60

subckt OPAMP1_variant61 inn inp out pd xpd vdda vssa
	xd1 (vssa vdda) prim_nwd AREA=6.13907e-9 PJ=476.6e-6 m=1
	xi0 (vssa net69) prim_nd AREA=1e-12 PJ=4e-6 m=1
	xi3 (net51 vdda) prim_pd AREA=790e-15 PJ=3.3e-6 m=1
	xr0 (vssa vdda net51) prim_rdiffp l=2.1e-6 w=700e-9 m=1
	xr1 (vdda vdda net69) prim_rdiffp l=2.1e-6 w=700e-9 m=1
	xcc01 (net12 out) prim_cpoly c=1p m=1
	mnm12 (net13 net56 vssa vssa) nmos1 l=180n w=1u m=1
	mnm11 (net56 net56 vssa vssa) nmos1 l=180n w=1u m=1
	mnb02 (net27 net27 net21 vssa) nmos1 l=180n w=1u m=1
	mnpd1 (net21 xpd vssa vssa) nmos1 l=180n w=1u m=1
	mn001 (out net13 vssa vssa) nmos1 l=180n w=1u m=1
	mnpd2 (net13 pd vssa vssa) nmos1 l=180n w=1u m=1
	mnc01 (net13 net69 net12 vssa) nmos1 l=1.5e-07n w=8.0e-07u m=1
	mpb02 (net27 net51 net158 vdda) pmos1 l=180n w=1u m=1
	mppd1 (net158 xpd vdda vdda) pmos1 l=2.5e-07n w=1.7e-06u m=1
	mps11 (net31 net158 vdda vdda) pmos1 l=180n w=1u m=1
	mpd11 (net56 inn net31 net31) pmos1 l=1.4e-07n w=9.0e-07u m=1
	mp001 (out net158 vdda vdda) pmos1 l=180n w=1u m=1
	mpd12 (net13 inp net31 net31) pmos1 l=180n w=1u m=1
	mpb01 (net158 net158 vdda vdda) pmos1 l=180n w=1u m=1
ends OPAMP1_variant61

subckt OPAMP1_variant62 inn inp out pd xpd vdda vssa
	xd1 (vssa vdda) prim_nwd AREA=6.13907e-9 PJ=476.6e-6 m=1
	xi0 (vssa net69) prim_nd AREA=7.3e-09 PJ=8.2e-05 m=1
	xi3 (net51 vdda) prim_pd AREA=790e-15 PJ=3.3e-6 m=1
	xr0 (vssa vdda net51) prim_rdiffp l=2.1e-6 w=700e-9 m=1
	xr1 (vdda vdda net69) prim_rdiffp l=2.1e-6 w=700e-9 m=1
	xcc01 (net12 out) prim_cpoly c=1p m=1
	mnm12 (net13 net56 vssa vssa) nmos1 l=180n w=1u m=1
	mnm11 (net56 net56 vssa vssa) nmos1 l=180n w=1u m=1
	mnb02 (net27 net27 net21 vssa) nmos1 l=180n w=1u m=1
	mnpd1 (net21 xpd vssa vssa) nmos1 l=180n w=1u m=1
	mn001 (out net13 vssa vssa) nmos1 l=2.6e-07n w=6.9e-07u m=1
	mnpd2 (net13 pd vssa vssa) nmos1 l=180n w=1u m=1
	mnc01 (net13 net69 net12 vssa) nmos1 l=180n w=1u m=1
	mpb02 (net27 net51 net158 vdda) pmos1 l=180n w=1u m=1
	mppd1 (net158 xpd vdda vdda) pmos1 l=180n w=1u m=1
	mps11 (net31 net158 vdda vdda) pmos1 l=1.7e-07n w=1.5e-06u m=1
	mpd11 (net56 inn net31 net31) pmos1 l=180n w=1u m=1
	mp001 (out net158 vdda vdda) pmos1 l=180n w=1u m=1
	mpd12 (net13 inp net31 net31) pmos1 l=180n w=1u m=1
	mpb01 (net158 net158 vdda vdda) pmos1 l=180n w=1u m=1
ends OPAMP1_variant62

subckt OPAMP1_variant63 inn inp out pd xpd vdda vssa
	xd1 (vssa vdda) prim_nwd AREA=6.13907e-9 PJ=476.6e-6 m=1
	xi0 (vssa net69) prim_nd AREA=1.1e-09 PJ=4.3e-05 m=1
	xi3 (net51 vdda) prim_pd AREA=790e-15 PJ=3.3e-6 m=1
	xr0 (vssa vdda net51) prim_rdiffp l=2.1e-6 w=700e-9 m=1
	xr1 (vdda vdda net69) prim_rdiffp l=2.1e-6 w=700e-9 m=1
	xcc01 (net12 out) prim_cpoly c=1p m=1
	mnm12 (net13 net56 vssa vssa) nmos1 l=180n w=1u m=1
	mnm11 (net56 net56 vssa vssa) nmos1 l=180n w=1u m=1
	mnb02 (net27 net27 net21 vssa) nmos1 l=180n w=1u m=1
	mnpd1 (net21 xpd vssa vssa) nmos1 l=180n w=1u m=1
	mn001 (out net13 vssa vssa) nmos1 l=2.5e-07n w=1.5e-06u m=1
	mnpd2 (net13 pd vssa vssa) nmos1 l=180n w=1u m=1
	mnc01 (net13 net69 net12 vssa) nmos1 l=180n w=1u m=1
	mpb02 (net27 net51 net158 vdda) pmos1 l=180n w=1u m=1
	mppd1 (net158 xpd vdda vdda) pmos1 l=180n w=1u m=1
	mps11 (net31 net158 vdda vdda) pmos1 l=180n w=1u m=1
	mpd11 (net56 inn net31 net31) pmos1 l=180n w=1u m=1
	mp001 (out net158 vdda vdda) pmos1 l=180n w=1u m=1
	mpd12 (net13 inp net31 net31) pmos1 l=180n w=1u m=1
	mpb01 (net158 net158 vdda vdda) pmos1 l=180n w=1u m=1
ends OPAMP1_variant63

subckt OPAMP1_variant64 inn inp out pd xpd vdda vssa
	xd1 (vssa vdda) prim_nwd AREA=6.13907e-9 PJ=476.6e-6 m=1
	xi0 (vssa net69) prim_nd AREA=1e-12 PJ=4e-6 m=1
	xi3 (net51 vdda) prim_pd AREA=790e-15 PJ=3.3e-6 m=1
	xr0 (vssa vdda net51) prim_rdiffp l=2.1e-6 w=700e-9 m=1
	xr1 (vdda vdda net69) prim_rdiffp l=2.1e-6 w=700e-9 m=1
	xcc01 (net12 out) prim_cpoly c=1.2e-12p m=1
	mnm12 (net13 net56 vssa vssa) nmos1 l=180n w=1u m=1
	mnm11 (net56 net56 vssa vssa) nmos1 l=1.0e-07n w=6.7e-07u m=1
	mnb02 (net27 net27 net21 vssa) nmos1 l=180n w=1u m=1
	mnpd1 (net21 xpd vssa vssa) nmos1 l=180n w=1u m=1
	mn001 (out net13 vssa vssa) nmos1 l=180n w=1u m=1
	mnpd2 (net13 pd vssa vssa) nmos1 l=180n w=1u m=1
	mnc01 (net13 net69 net12 vssa) nmos1 l=180n w=1u m=1
	mpb02 (net27 net51 net158 vdda) pmos1 l=2.0e-07n w=1.9e-06u m=1
	mppd1 (net158 xpd vdda vdda) pmos1 l=180n w=1u m=1
	mps11 (net31 net158 vdda vdda) pmos1 l=180n w=1u m=1
	mpd11 (net56 inn net31 net31) pmos1 l=2.6e-07n w=1.1e-06u m=1
	mp001 (out net158 vdda vdda) pmos1 l=2.5e-07n w=1.3e-06u m=1
	mpd12 (net13 inp net31 net31) pmos1 l=180n w=1u m=1
	mpb01 (net158 net158 vdda vdda) pmos1 l=180n w=1u m=1
ends OPAMP1_variant64

subckt OPAMP1_variant65 inn inp out pd xpd vdda vssa
	xd1 (vssa vdda) prim_nwd AREA=7.9e-10 PJ=9.3e-05 m=1
	xi0 (vssa net69) prim_nd AREA=1.8e-10 PJ=2.6e-05 m=1
	xi3 (net51 vdda) prim_pd AREA=8.6e-09 PJ=2.1e-05 m=1
	xr0 (vssa vdda net51) prim_rdiffp l=2.1e-6 w=700e-9 m=1
	xr1 (vdda vdda net69) prim_rdiffp l=2.1e-6 w=700e-9 m=1
	xcc01 (net12 out) prim_cpoly c=1p m=1
	mnm12 (net13 net56 vssa vssa) nmos1 l=180n w=1u m=1
	mnm11 (net56 net56 vssa vssa) nmos1 l=180n w=1u m=1
	mnb02 (net27 net27 net21 vssa) nmos1 l=180n w=1u m=1
	mnpd1 (net21 xpd vssa vssa) nmos1 l=180n w=1u m=1
	mn001 (out net13 vssa vssa) nmos1 l=180n w=1u m=1
	mnpd2 (net13 pd vssa vssa) nmos1 l=180n w=1u m=1
	mnc01 (net13 net69 net12 vssa) nmos1 l=180n w=1u m=1
	mpb02 (net27 net51 net158 vdda) pmos1 l=180n w=1u m=1
	mppd1 (net158 xpd vdda vdda) pmos1 l=180n w=1u m=1
	mps11 (net31 net158 vdda vdda) pmos1 l=180n w=1u m=1
	mpd11 (net56 inn net31 net31) pmos1 l=1.4e-07n w=1.3e-06u m=1
	mp001 (out net158 vdda vdda) pmos1 l=180n w=1u m=1
	mpd12 (net13 inp net31 net31) pmos1 l=180n w=1u m=1
	mpb01 (net158 net158 vdda vdda) pmos1 l=2.4e-07n w=1.6e-06u m=1
ends OPAMP1_variant65

subckt OPAMP1_variant66 inn inp out pd xpd vdda vssa
	xd1 (vssa vdda) prim_nwd AREA=6.13907e-9 PJ=476.6e-6 m=1
	xi0 (vssa net69) prim_nd AREA=1e-12 PJ=4e-6 m=1
	xi3 (net51 vdda) prim_pd AREA=790e-15 PJ=3.3e-6 m=1
	xr0 (vssa vdda net51) prim_rdiffp l=2.1e-6 w=700e-9 m=1
	xr1 (vdda vdda net69) prim_rdiffp l=2.6e-07 w=1.2e-06 m=1
	xcc01 (net12 out) prim_cpoly c=1p m=1
	mnm12 (net13 net56 vssa vssa) nmos1 l=2.4e-07n w=1.0e-06u m=1
	mnm11 (net56 net56 vssa vssa) nmos1 l=180n w=1u m=1
	mnb02 (net27 net27 net21 vssa) nmos1 l=180n w=1u m=1
	mnpd1 (net21 xpd vssa vssa) nmos1 l=180n w=1u m=1
	mn001 (out net13 vssa vssa) nmos1 l=180n w=1u m=1
	mnpd2 (net13 pd vssa vssa) nmos1 l=180n w=1u m=1
	mnc01 (net13 net69 net12 vssa) nmos1 l=180n w=1u m=1
	mpb02 (net27 net51 net158 vdda) pmos1 l=180n w=1u m=1
	mppd1 (net158 xpd vdda vdda) pmos1 l=1.5e-07n w=1.7e-06u m=1
	mps11 (net31 net158 vdda vdda) pmos1 l=180n w=1u m=1
	mpd11 (net56 inn net31 net31) pmos1 l=180n w=1u m=1
	mp001 (out net158 vdda vdda) pmos1 l=2.8e-07n w=1.7e-06u m=1
	mpd12 (net13 inp net31 net31) pmos1 l=180n w=1u m=1
	mpb01 (net158 net158 vdda vdda) pmos1 l=1.6e-07n w=1.5e-06u m=1
ends OPAMP1_variant66

subckt OPAMP1_variant67 inn inp out pd xpd vdda vssa
	xd1 (vssa vdda) prim_nwd AREA=6.3e-09 PJ=9.0e-05 m=1
	xi0 (vssa net69) prim_nd AREA=1e-12 PJ=4e-6 m=1
	xi3 (net51 vdda) prim_pd AREA=790e-15 PJ=3.3e-6 m=1
	xr0 (vssa vdda net51) prim_rdiffp l=2.1e-6 w=700e-9 m=1
	xr1 (vdda vdda net69) prim_rdiffp l=3.0e-07 w=1.8e-06 m=1
	xcc01 (net12 out) prim_cpoly c=1p m=1
	mnm12 (net13 net56 vssa vssa) nmos1 l=180n w=1u m=1
	mnm11 (net56 net56 vssa vssa) nmos1 l=1.5e-07n w=9.0e-07u m=1
	mnb02 (net27 net27 net21 vssa) nmos1 l=180n w=1u m=1
	mnpd1 (net21 xpd vssa vssa) nmos1 l=180n w=1u m=1
	mn001 (out net13 vssa vssa) nmos1 l=180n w=1u m=1
	mnpd2 (net13 pd vssa vssa) nmos1 l=180n w=1u m=1
	mnc01 (net13 net69 net12 vssa) nmos1 l=180n w=1u m=1
	mpb02 (net27 net51 net158 vdda) pmos1 l=180n w=1u m=1
	mppd1 (net158 xpd vdda vdda) pmos1 l=1.1e-07n w=1.6e-06u m=1
	mps11 (net31 net158 vdda vdda) pmos1 l=180n w=1u m=1
	mpd11 (net56 inn net31 net31) pmos1 l=180n w=1u m=1
	mp001 (out net158 vdda vdda) pmos1 l=180n w=1u m=1
	mpd12 (net13 inp net31 net31) pmos1 l=2.6e-07n w=1.2e-06u m=1
	mpb01 (net158 net158 vdda vdda) pmos1 l=180n w=1u m=1
ends OPAMP1_variant67

subckt OPAMP1_variant68 inn inp out pd xpd vdda vssa
	xd1 (vssa vdda) prim_nwd AREA=6.13907e-9 PJ=476.6e-6 m=1
	xi0 (vssa net69) prim_nd AREA=1e-12 PJ=4e-6 m=1
	xi3 (net51 vdda) prim_pd AREA=790e-15 PJ=3.3e-6 m=1
	xr0 (vssa vdda net51) prim_rdiffp l=2.3e-07 w=1.2e-06 m=1
	xr1 (vdda vdda net69) prim_rdiffp l=2.1e-6 w=700e-9 m=1
	xcc01 (net12 out) prim_cpoly c=1p m=1
	mnm12 (net13 net56 vssa vssa) nmos1 l=180n w=1u m=1
	mnm11 (net56 net56 vssa vssa) nmos1 l=180n w=1u m=1
	mnb02 (net27 net27 net21 vssa) nmos1 l=2.7e-07n w=1.2e-06u m=1
	mnpd1 (net21 xpd vssa vssa) nmos1 l=180n w=1u m=1
	mn001 (out net13 vssa vssa) nmos1 l=180n w=1u m=1
	mnpd2 (net13 pd vssa vssa) nmos1 l=180n w=1u m=1
	mnc01 (net13 net69 net12 vssa) nmos1 l=180n w=1u m=1
	mpb02 (net27 net51 net158 vdda) pmos1 l=180n w=1u m=1
	mppd1 (net158 xpd vdda vdda) pmos1 l=180n w=1u m=1
	mps11 (net31 net158 vdda vdda) pmos1 l=180n w=1u m=1
	mpd11 (net56 inn net31 net31) pmos1 l=180n w=1u m=1
	mp001 (out net158 vdda vdda) pmos1 l=180n w=1u m=1
	mpd12 (net13 inp net31 net31) pmos1 l=180n w=1u m=1
	mpb01 (net158 net158 vdda vdda) pmos1 l=180n w=1u m=1
ends OPAMP1_variant68

subckt OPAMP1_variant69 inn inp out pd xpd vdda vssa
	xd1 (vssa vdda) prim_nwd AREA=6.13907e-9 PJ=476.6e-6 m=1
	xi0 (vssa net69) prim_nd AREA=1e-12 PJ=4e-6 m=1
	xi3 (net51 vdda) prim_pd AREA=790e-15 PJ=3.3e-6 m=1
	xr0 (vssa vdda net51) prim_rdiffp l=2.1e-6 w=700e-9 m=1
	xr1 (vdda vdda net69) prim_rdiffp l=2.1e-6 w=700e-9 m=1
	xcc01 (net12 out) prim_cpoly c=1.7e-12p m=1
	mnm12 (net13 net56 vssa vssa) nmos1 l=180n w=1u m=1
	mnm11 (net56 net56 vssa vssa) nmos1 l=180n w=1u m=1
	mnb02 (net27 net27 net21 vssa) nmos1 l=180n w=1u m=1
	mnpd1 (net21 xpd vssa vssa) nmos1 l=180n w=1u m=1
	mn001 (out net13 vssa vssa) nmos1 l=180n w=1u m=1
	mnpd2 (net13 pd vssa vssa) nmos1 l=1.7e-07n w=7.6e-07u m=1
	mnc01 (net13 net69 net12 vssa) nmos1 l=180n w=1u m=1
	mpb02 (net27 net51 net158 vdda) pmos1 l=180n w=1u m=1
	mppd1 (net158 xpd vdda vdda) pmos1 l=180n w=1u m=1
	mps11 (net31 net158 vdda vdda) pmos1 l=180n w=1u m=1
	mpd11 (net56 inn net31 net31) pmos1 l=180n w=1u m=1
	mp001 (out net158 vdda vdda) pmos1 l=180n w=1u m=1
	mpd12 (net13 inp net31 net31) pmos1 l=180n w=1u m=1
	mpb01 (net158 net158 vdda vdda) pmos1 l=180n w=1u m=1
ends OPAMP1_variant69

subckt OPAMP1_variant70 inn inp out pd xpd vdda vssa
	xd1 (vssa vdda) prim_nwd AREA=6.13907e-9 PJ=476.6e-6 m=1
	xi0 (vssa net69) prim_nd AREA=1e-12 PJ=4e-6 m=1
	xi3 (net51 vdda) prim_pd AREA=790e-15 PJ=3.3e-6 m=1
	xr0 (vssa vdda net51) prim_rdiffp l=2.1e-6 w=700e-9 m=1
	xr1 (vdda vdda net69) prim_rdiffp l=2.1e-6 w=700e-9 m=1
	xcc01 (net12 out) prim_cpoly c=1p m=1
	mnm12 (net13 net56 vssa vssa) nmos1 l=180n w=1u m=1
	mnm11 (net56 net56 vssa vssa) nmos1 l=1.1e-07n w=1.1e-06u m=1
	mnb02 (net27 net27 net21 vssa) nmos1 l=180n w=1u m=1
	mnpd1 (net21 xpd vssa vssa) nmos1 l=180n w=1u m=1
	mn001 (out net13 vssa vssa) nmos1 l=2.5e-07n w=1.1e-06u m=1
	mnpd2 (net13 pd vssa vssa) nmos1 l=180n w=1u m=1
	mnc01 (net13 net69 net12 vssa) nmos1 l=1.1e-07n w=1.8e-06u m=1
	mpb02 (net27 net51 net158 vdda) pmos1 l=180n w=1u m=1
	mppd1 (net158 xpd vdda vdda) pmos1 l=180n w=1u m=1
	mps11 (net31 net158 vdda vdda) pmos1 l=2.8e-07n w=1.2e-06u m=1
	mpd11 (net56 inn net31 net31) pmos1 l=180n w=1u m=1
	mp001 (out net158 vdda vdda) pmos1 l=1.7e-07n w=1.2e-06u m=1
	mpd12 (net13 inp net31 net31) pmos1 l=180n w=1u m=1
	mpb01 (net158 net158 vdda vdda) pmos1 l=180n w=1u m=1
ends OPAMP1_variant70

subckt OPAMP1_variant71 inn inp out pd xpd vdda vssa
	xd1 (vssa vdda) prim_nwd AREA=6.13907e-9 PJ=476.6e-6 m=1
	xi0 (vssa net69) prim_nd AREA=1e-12 PJ=4e-6 m=1
	xi3 (net51 vdda) prim_pd AREA=790e-15 PJ=3.3e-6 m=1
	xr0 (vssa vdda net51) prim_rdiffp l=2.7e-07 w=2.0e-06 m=1
	xr1 (vdda vdda net69) prim_rdiffp l=2.1e-6 w=700e-9 m=1
	xcc01 (net12 out) prim_cpoly c=1p m=1
	mnm12 (net13 net56 vssa vssa) nmos1 l=2.4e-07n w=1.4e-06u m=1
	mnm11 (net56 net56 vssa vssa) nmos1 l=180n w=1u m=1
	mnb02 (net27 net27 net21 vssa) nmos1 l=180n w=1u m=1
	mnpd1 (net21 xpd vssa vssa) nmos1 l=180n w=1u m=1
	mn001 (out net13 vssa vssa) nmos1 l=2.0e-07n w=9.8e-07u m=1
	mnpd2 (net13 pd vssa vssa) nmos1 l=180n w=1u m=1
	mnc01 (net13 net69 net12 vssa) nmos1 l=180n w=1u m=1
	mpb02 (net27 net51 net158 vdda) pmos1 l=180n w=1u m=1
	mppd1 (net158 xpd vdda vdda) pmos1 l=2.5e-07n w=1.9e-06u m=1
	mps11 (net31 net158 vdda vdda) pmos1 l=180n w=1u m=1
	mpd11 (net56 inn net31 net31) pmos1 l=1.3e-07n w=1.7e-06u m=1
	mp001 (out net158 vdda vdda) pmos1 l=180n w=1u m=1
	mpd12 (net13 inp net31 net31) pmos1 l=180n w=1u m=1
	mpb01 (net158 net158 vdda vdda) pmos1 l=180n w=1u m=1
ends OPAMP1_variant71

subckt OPAMP1_variant72 inn inp out pd xpd vdda vssa
	xd1 (vssa vdda) prim_nwd AREA=6.13907e-9 PJ=476.6e-6 m=1
	xi0 (vssa net69) prim_nd AREA=1e-12 PJ=4e-6 m=1
	xi3 (net51 vdda) prim_pd AREA=790e-15 PJ=3.3e-6 m=1
	xr0 (vssa vdda net51) prim_rdiffp l=2.1e-6 w=700e-9 m=1
	xr1 (vdda vdda net69) prim_rdiffp l=2.1e-6 w=700e-9 m=1
	xcc01 (net12 out) prim_cpoly c=1p m=1
	mnm12 (net13 net56 vssa vssa) nmos1 l=2.1e-07n w=7.5e-07u m=1
	mnm11 (net56 net56 vssa vssa) nmos1 l=180n w=1u m=1
	mnb02 (net27 net27 net21 vssa) nmos1 l=180n w=1u m=1
	mnpd1 (net21 xpd vssa vssa) nmos1 l=180n w=1u m=1
	mn001 (out net13 vssa vssa) nmos1 l=180n w=1u m=1
	mnpd2 (net13 pd vssa vssa) nmos1 l=2.1e-07n w=1.6e-06u m=1
	mnc01 (net13 net69 net12 vssa) nmos1 l=180n w=1u m=1
	mpb02 (net27 net51 net158 vdda) pmos1 l=180n w=1u m=1
	mppd1 (net158 xpd vdda vdda) pmos1 l=180n w=1u m=1
	mps11 (net31 net158 vdda vdda) pmos1 l=180n w=1u m=1
	mpd11 (net56 inn net31 net31) pmos1 l=1.3e-07n w=7.6e-07u m=1
	mp001 (out net158 vdda vdda) pmos1 l=1.1e-07n w=8.8e-07u m=1
	mpd12 (net13 inp net31 net31) pmos1 l=180n w=1u m=1
	mpb01 (net158 net158 vdda vdda) pmos1 l=180n w=1u m=1
ends OPAMP1_variant72

subckt OPAMP1_variant73 inn inp out pd xpd vdda vssa
	xd1 (vssa vdda) prim_nwd AREA=6.13907e-9 PJ=476.6e-6 m=1
	xi0 (vssa net69) prim_nd AREA=1e-12 PJ=4e-6 m=1
	xi3 (net51 vdda) prim_pd AREA=790e-15 PJ=3.3e-6 m=1
	xr0 (vssa vdda net51) prim_rdiffp l=2.1e-6 w=700e-9 m=1
	xr1 (vdda vdda net69) prim_rdiffp l=2.1e-6 w=700e-9 m=1
	xcc01 (net12 out) prim_cpoly c=1.4e-12p m=1
	mnm12 (net13 net56 vssa vssa) nmos1 l=180n w=1u m=1
	mnm11 (net56 net56 vssa vssa) nmos1 l=180n w=1u m=1
	mnb02 (net27 net27 net21 vssa) nmos1 l=2.1e-07n w=6.3e-07u m=1
	mnpd1 (net21 xpd vssa vssa) nmos1 l=180n w=1u m=1
	mn001 (out net13 vssa vssa) nmos1 l=180n w=1u m=1
	mnpd2 (net13 pd vssa vssa) nmos1 l=180n w=1u m=1
	mnc01 (net13 net69 net12 vssa) nmos1 l=180n w=1u m=1
	mpb02 (net27 net51 net158 vdda) pmos1 l=180n w=1u m=1
	mppd1 (net158 xpd vdda vdda) pmos1 l=180n w=1u m=1
	mps11 (net31 net158 vdda vdda) pmos1 l=2.1e-07n w=1.3e-06u m=1
	mpd11 (net56 inn net31 net31) pmos1 l=180n w=1u m=1
	mp001 (out net158 vdda vdda) pmos1 l=180n w=1u m=1
	mpd12 (net13 inp net31 net31) pmos1 l=180n w=1u m=1
	mpb01 (net158 net158 vdda vdda) pmos1 l=180n w=1u m=1
ends OPAMP1_variant73

subckt OPAMP1_variant74 inn inp out pd xpd vdda vssa
	xd1 (vssa vdda) prim_nwd AREA=6.13907e-9 PJ=476.6e-6 m=1
	xi0 (vssa net69) prim_nd AREA=1e-12 PJ=4e-6 m=1
	xi3 (net51 vdda) prim_pd AREA=790e-15 PJ=3.3e-6 m=1
	xr0 (vssa vdda net51) prim_rdiffp l=2.1e-6 w=700e-9 m=1
	xr1 (vdda vdda net69) prim_rdiffp l=2.1e-6 w=700e-9 m=1
	xcc01 (net12 out) prim_cpoly c=1.7e-12p m=1
	mnm12 (net13 net56 vssa vssa) nmos1 l=1.3e-07n w=6.2e-07u m=1
	mnm11 (net56 net56 vssa vssa) nmos1 l=180n w=1u m=1
	mnb02 (net27 net27 net21 vssa) nmos1 l=2.6e-07n w=1.5e-06u m=1
	mnpd1 (net21 xpd vssa vssa) nmos1 l=180n w=1u m=1
	mn001 (out net13 vssa vssa) nmos1 l=180n w=1u m=1
	mnpd2 (net13 pd vssa vssa) nmos1 l=180n w=1u m=1
	mnc01 (net13 net69 net12 vssa) nmos1 l=180n w=1u m=1
	mpb02 (net27 net51 net158 vdda) pmos1 l=180n w=1u m=1
	mppd1 (net158 xpd vdda vdda) pmos1 l=180n w=1u m=1
	mps11 (net31 net158 vdda vdda) pmos1 l=180n w=1u m=1
	mpd11 (net56 inn net31 net31) pmos1 l=180n w=1u m=1
	mp001 (out net158 vdda vdda) pmos1 l=180n w=1u m=1
	mpd12 (net13 inp net31 net31) pmos1 l=180n w=1u m=1
	mpb01 (net158 net158 vdda vdda) pmos1 l=180n w=1u m=1
ends OPAMP1_variant74

subckt OPAMP1_variant75 inn inp out pd xpd vdda vssa
	xd1 (vssa vdda) prim_nwd AREA=7.7e-09 PJ=9.1e-05 m=1
	xi0 (vssa net69) prim_nd AREA=1e-12 PJ=4e-6 m=1
	xi3 (net51 vdda) prim_pd AREA=8.6e-09 PJ=4.9e-05 m=1
	xr0 (vssa vdda net51) prim_rdiffp l=2.1e-6 w=700e-9 m=1
	xr1 (vdda vdda net69) prim_rdiffp l=2.1e-6 w=700e-9 m=1
	xcc01 (net12 out) prim_cpoly c=7.4e-13p m=1
	mnm12 (net13 net56 vssa vssa) nmos1 l=180n w=1u m=1
	mnm11 (net56 net56 vssa vssa) nmos1 l=180n w=1u m=1
	mnb02 (net27 net27 net21 vssa) nmos1 l=180n w=1u m=1
	mnpd1 (net21 xpd vssa vssa) nmos1 l=180n w=1u m=1
	mn001 (out net13 vssa vssa) nmos1 l=1.9e-07n w=1.7e-06u m=1
	mnpd2 (net13 pd vssa vssa) nmos1 l=180n w=1u m=1
	mnc01 (net13 net69 net12 vssa) nmos1 l=180n w=1u m=1
	mpb02 (net27 net51 net158 vdda) pmos1 l=180n w=1u m=1
	mppd1 (net158 xpd vdda vdda) pmos1 l=180n w=1u m=1
	mps11 (net31 net158 vdda vdda) pmos1 l=180n w=1u m=1
	mpd11 (net56 inn net31 net31) pmos1 l=180n w=1u m=1
	mp001 (out net158 vdda vdda) pmos1 l=180n w=1u m=1
	mpd12 (net13 inp net31 net31) pmos1 l=180n w=1u m=1
	mpb01 (net158 net158 vdda vdda) pmos1 l=180n w=1u m=1
ends OPAMP1_variant75

subckt OPAMP1_variant76 inn inp out pd xpd vdda vssa
	xd1 (vssa vdda) prim_nwd AREA=6.13907e-9 PJ=476.6e-6 m=1
	xi0 (vssa net69) prim_nd AREA=1e-12 PJ=4e-6 m=1
	xi3 (net51 vdda) prim_pd AREA=790e-15 PJ=3.3e-6 m=1
	xr0 (vssa vdda net51) prim_rdiffp l=1.8e-07 w=1.9e-06 m=1
	xr1 (vdda vdda net69) prim_rdiffp l=2.6e-07 w=1.7e-06 m=1
	xcc01 (net12 out) prim_cpoly c=1p m=1
	mnm12 (net13 net56 vssa vssa) nmos1 l=180n w=1u m=1
	mnm11 (net56 net56 vssa vssa) nmos1 l=180n w=1u m=1
	mnb02 (net27 net27 net21 vssa) nmos1 l=180n w=1u m=1
	mnpd1 (net21 xpd vssa vssa) nmos1 l=180n w=1u m=1
	mn001 (out net13 vssa vssa) nmos1 l=180n w=1u m=1
	mnpd2 (net13 pd vssa vssa) nmos1 l=180n w=1u m=1
	mnc01 (net13 net69 net12 vssa) nmos1 l=180n w=1u m=1
	mpb02 (net27 net51 net158 vdda) pmos1 l=180n w=1u m=1
	mppd1 (net158 xpd vdda vdda) pmos1 l=180n w=1u m=1
	mps11 (net31 net158 vdda vdda) pmos1 l=180n w=1u m=1
	mpd11 (net56 inn net31 net31) pmos1 l=180n w=1u m=1
	mp001 (out net158 vdda vdda) pmos1 l=180n w=1u m=1
	mpd12 (net13 inp net31 net31) pmos1 l=180n w=1u m=1
	mpb01 (net158 net158 vdda vdda) pmos1 l=180n w=1u m=1
ends OPAMP1_variant76

subckt OPAMP1_variant77 inn inp out pd xpd vdda vssa
	xd1 (vssa vdda) prim_nwd AREA=6.13907e-9 PJ=476.6e-6 m=1
	xi0 (vssa net69) prim_nd AREA=1e-12 PJ=4e-6 m=1
	xi3 (net51 vdda) prim_pd AREA=790e-15 PJ=3.3e-6 m=1
	xr0 (vssa vdda net51) prim_rdiffp l=2.1e-6 w=700e-9 m=1
	xr1 (vdda vdda net69) prim_rdiffp l=2.1e-6 w=700e-9 m=1
	xcc01 (net12 out) prim_cpoly c=1p m=1
	mnm12 (net13 net56 vssa vssa) nmos1 l=180n w=1u m=1
	mnm11 (net56 net56 vssa vssa) nmos1 l=180n w=1u m=1
	mnb02 (net27 net27 net21 vssa) nmos1 l=180n w=1u m=1
	mnpd1 (net21 xpd vssa vssa) nmos1 l=2.2e-07n w=8.7e-07u m=1
	mn001 (out net13 vssa vssa) nmos1 l=180n w=1u m=1
	mnpd2 (net13 pd vssa vssa) nmos1 l=180n w=1u m=1
	mnc01 (net13 net69 net12 vssa) nmos1 l=180n w=1u m=1
	mpb02 (net27 net51 net158 vdda) pmos1 l=180n w=1u m=1
	mppd1 (net158 xpd vdda vdda) pmos1 l=180n w=1u m=1
	mps11 (net31 net158 vdda vdda) pmos1 l=180n w=1u m=1
	mpd11 (net56 inn net31 net31) pmos1 l=180n w=1u m=1
	mp001 (out net158 vdda vdda) pmos1 l=180n w=1u m=1
	mpd12 (net13 inp net31 net31) pmos1 l=1.9e-07n w=7.0e-07u m=1
	mpb01 (net158 net158 vdda vdda) pmos1 l=180n w=1u m=1
ends OPAMP1_variant77

subckt OPAMP1_variant78 inn inp out pd xpd vdda vssa
	xd1 (vssa vdda) prim_nwd AREA=9.9e-09 PJ=9.6e-05 m=1
	xi0 (vssa net69) prim_nd AREA=1e-12 PJ=4e-6 m=1
	xi3 (net51 vdda) prim_pd AREA=790e-15 PJ=3.3e-6 m=1
	xr0 (vssa vdda net51) prim_rdiffp l=2.1e-6 w=700e-9 m=1
	xr1 (vdda vdda net69) prim_rdiffp l=2.1e-6 w=700e-9 m=1
	xcc01 (net12 out) prim_cpoly c=1p m=1
	mnm12 (net13 net56 vssa vssa) nmos1 l=180n w=1u m=1
	mnm11 (net56 net56 vssa vssa) nmos1 l=180n w=1u m=1
	mnb02 (net27 net27 net21 vssa) nmos1 l=180n w=1u m=1
	mnpd1 (net21 xpd vssa vssa) nmos1 l=180n w=1u m=1
	mn001 (out net13 vssa vssa) nmos1 l=180n w=1u m=1
	mnpd2 (net13 pd vssa vssa) nmos1 l=180n w=1u m=1
	mnc01 (net13 net69 net12 vssa) nmos1 l=180n w=1u m=1
	mpb02 (net27 net51 net158 vdda) pmos1 l=180n w=1u m=1
	mppd1 (net158 xpd vdda vdda) pmos1 l=180n w=1u m=1
	mps11 (net31 net158 vdda vdda) pmos1 l=180n w=1u m=1
	mpd11 (net56 inn net31 net31) pmos1 l=180n w=1u m=1
	mp001 (out net158 vdda vdda) pmos1 l=180n w=1u m=1
	mpd12 (net13 inp net31 net31) pmos1 l=180n w=1u m=1
	mpb01 (net158 net158 vdda vdda) pmos1 l=2.5e-07n w=1.6e-06u m=1
ends OPAMP1_variant78

subckt OPAMP1_variant79 inn inp out pd xpd vdda vssa
	xd1 (vssa vdda) prim_nwd AREA=6.13907e-9 PJ=476.6e-6 m=1
	xi0 (vssa net69) prim_nd AREA=4.3e-09 PJ=1.5e-05 m=1
	xi3 (net51 vdda) prim_pd AREA=790e-15 PJ=3.3e-6 m=1
	xr0 (vssa vdda net51) prim_rdiffp l=2.1e-07 w=1.0e-06 m=1
	xr1 (vdda vdda net69) prim_rdiffp l=2.1e-6 w=700e-9 m=1
	xcc01 (net12 out) prim_cpoly c=1p m=1
	mnm12 (net13 net56 vssa vssa) nmos1 l=180n w=1u m=1
	mnm11 (net56 net56 vssa vssa) nmos1 l=180n w=1u m=1
	mnb02 (net27 net27 net21 vssa) nmos1 l=2.4e-07n w=1.7e-06u m=1
	mnpd1 (net21 xpd vssa vssa) nmos1 l=180n w=1u m=1
	mn001 (out net13 vssa vssa) nmos1 l=180n w=1u m=1
	mnpd2 (net13 pd vssa vssa) nmos1 l=2.8e-07n w=1.9e-06u m=1
	mnc01 (net13 net69 net12 vssa) nmos1 l=180n w=1u m=1
	mpb02 (net27 net51 net158 vdda) pmos1 l=180n w=1u m=1
	mppd1 (net158 xpd vdda vdda) pmos1 l=2.9e-07n w=6.6e-07u m=1
	mps11 (net31 net158 vdda vdda) pmos1 l=180n w=1u m=1
	mpd11 (net56 inn net31 net31) pmos1 l=180n w=1u m=1
	mp001 (out net158 vdda vdda) pmos1 l=180n w=1u m=1
	mpd12 (net13 inp net31 net31) pmos1 l=180n w=1u m=1
	mpb01 (net158 net158 vdda vdda) pmos1 l=180n w=1u m=1
ends OPAMP1_variant79

subckt OPAMP1_variant80 inn inp out pd xpd vdda vssa
	xd1 (vssa vdda) prim_nwd AREA=6.13907e-9 PJ=476.6e-6 m=1
	xi0 (vssa net69) prim_nd AREA=1e-12 PJ=4e-6 m=1
	xi3 (net51 vdda) prim_pd AREA=790e-15 PJ=3.3e-6 m=1
	xr0 (vssa vdda net51) prim_rdiffp l=1.9e-07 w=1.7e-06 m=1
	xr1 (vdda vdda net69) prim_rdiffp l=2.1e-6 w=700e-9 m=1
	xcc01 (net12 out) prim_cpoly c=1p m=1
	mnm12 (net13 net56 vssa vssa) nmos1 l=180n w=1u m=1
	mnm11 (net56 net56 vssa vssa) nmos1 l=180n w=1u m=1
	mnb02 (net27 net27 net21 vssa) nmos1 l=180n w=1u m=1
	mnpd1 (net21 xpd vssa vssa) nmos1 l=1.9e-07n w=9.7e-07u m=1
	mn001 (out net13 vssa vssa) nmos1 l=180n w=1u m=1
	mnpd2 (net13 pd vssa vssa) nmos1 l=2.2e-07n w=7.5e-07u m=1
	mnc01 (net13 net69 net12 vssa) nmos1 l=180n w=1u m=1
	mpb02 (net27 net51 net158 vdda) pmos1 l=180n w=1u m=1
	mppd1 (net158 xpd vdda vdda) pmos1 l=180n w=1u m=1
	mps11 (net31 net158 vdda vdda) pmos1 l=180n w=1u m=1
	mpd11 (net56 inn net31 net31) pmos1 l=180n w=1u m=1
	mp001 (out net158 vdda vdda) pmos1 l=180n w=1u m=1
	mpd12 (net13 inp net31 net31) pmos1 l=180n w=1u m=1
	mpb01 (net158 net158 vdda vdda) pmos1 l=180n w=1u m=1
ends OPAMP1_variant80

subckt OPAMP1_variant81 inn inp out pd xpd vdda vssa
	xd1 (vssa vdda) prim_nwd AREA=1.1e-09 PJ=2.3e-05 m=1
	xi0 (vssa net69) prim_nd AREA=1e-12 PJ=4e-6 m=1
	xi3 (net51 vdda) prim_pd AREA=790e-15 PJ=3.3e-6 m=1
	xr0 (vssa vdda net51) prim_rdiffp l=2.1e-6 w=700e-9 m=1
	xr1 (vdda vdda net69) prim_rdiffp l=1.1e-07 w=1.3e-06 m=1
	xcc01 (net12 out) prim_cpoly c=1.5e-12p m=1
	mnm12 (net13 net56 vssa vssa) nmos1 l=180n w=1u m=1
	mnm11 (net56 net56 vssa vssa) nmos1 l=180n w=1u m=1
	mnb02 (net27 net27 net21 vssa) nmos1 l=180n w=1u m=1
	mnpd1 (net21 xpd vssa vssa) nmos1 l=180n w=1u m=1
	mn001 (out net13 vssa vssa) nmos1 l=180n w=1u m=1
	mnpd2 (net13 pd vssa vssa) nmos1 l=180n w=1u m=1
	mnc01 (net13 net69 net12 vssa) nmos1 l=2.0e-07n w=1.6e-06u m=1
	mpb02 (net27 net51 net158 vdda) pmos1 l=180n w=1u m=1
	mppd1 (net158 xpd vdda vdda) pmos1 l=180n w=1u m=1
	mps11 (net31 net158 vdda vdda) pmos1 l=180n w=1u m=1
	mpd11 (net56 inn net31 net31) pmos1 l=180n w=1u m=1
	mp001 (out net158 vdda vdda) pmos1 l=180n w=1u m=1
	mpd12 (net13 inp net31 net31) pmos1 l=180n w=1u m=1
	mpb01 (net158 net158 vdda vdda) pmos1 l=180n w=1u m=1
ends OPAMP1_variant81

subckt OPAMP1_variant82 inn inp out pd xpd vdda vssa
	xd1 (vssa vdda) prim_nwd AREA=6.13907e-9 PJ=476.6e-6 m=1
	xi0 (vssa net69) prim_nd AREA=1e-12 PJ=4e-6 m=1
	xi3 (net51 vdda) prim_pd AREA=790e-15 PJ=3.3e-6 m=1
	xr0 (vssa vdda net51) prim_rdiffp l=2.1e-6 w=700e-9 m=1
	xr1 (vdda vdda net69) prim_rdiffp l=2.1e-6 w=700e-9 m=1
	xcc01 (net12 out) prim_cpoly c=1p m=1
	mnm12 (net13 net56 vssa vssa) nmos1 l=180n w=1u m=1
	mnm11 (net56 net56 vssa vssa) nmos1 l=180n w=1u m=1
	mnb02 (net27 net27 net21 vssa) nmos1 l=180n w=1u m=1
	mnpd1 (net21 xpd vssa vssa) nmos1 l=180n w=1u m=1
	mn001 (out net13 vssa vssa) nmos1 l=180n w=1u m=1
	mnpd2 (net13 pd vssa vssa) nmos1 l=180n w=1u m=1
	mnc01 (net13 net69 net12 vssa) nmos1 l=180n w=1u m=1
	mpb02 (net27 net51 net158 vdda) pmos1 l=180n w=1u m=1
	mppd1 (net158 xpd vdda vdda) pmos1 l=2.5e-07n w=1.3e-06u m=1
	mps11 (net31 net158 vdda vdda) pmos1 l=180n w=1u m=1
	mpd11 (net56 inn net31 net31) pmos1 l=1.7e-07n w=1.9e-06u m=1
	mp001 (out net158 vdda vdda) pmos1 l=180n w=1u m=1
	mpd12 (net13 inp net31 net31) pmos1 l=180n w=1u m=1
	mpb01 (net158 net158 vdda vdda) pmos1 l=180n w=1u m=1
ends OPAMP1_variant82

subckt OPAMP1_variant83 inn inp out pd xpd vdda vssa
	xd1 (vssa vdda) prim_nwd AREA=4.3e-11 PJ=1.4e-05 m=1
	xi0 (vssa net69) prim_nd AREA=5.7e-09 PJ=5.0e-05 m=1
	xi3 (net51 vdda) prim_pd AREA=790e-15 PJ=3.3e-6 m=1
	xr0 (vssa vdda net51) prim_rdiffp l=2.1e-6 w=700e-9 m=1
	xr1 (vdda vdda net69) prim_rdiffp l=2.1e-6 w=700e-9 m=1
	xcc01 (net12 out) prim_cpoly c=1p m=1
	mnm12 (net13 net56 vssa vssa) nmos1 l=180n w=1u m=1
	mnm11 (net56 net56 vssa vssa) nmos1 l=180n w=1u m=1
	mnb02 (net27 net27 net21 vssa) nmos1 l=180n w=1u m=1
	mnpd1 (net21 xpd vssa vssa) nmos1 l=180n w=1u m=1
	mn001 (out net13 vssa vssa) nmos1 l=180n w=1u m=1
	mnpd2 (net13 pd vssa vssa) nmos1 l=2.7e-07n w=1.6e-06u m=1
	mnc01 (net13 net69 net12 vssa) nmos1 l=180n w=1u m=1
	mpb02 (net27 net51 net158 vdda) pmos1 l=180n w=1u m=1
	mppd1 (net158 xpd vdda vdda) pmos1 l=180n w=1u m=1
	mps11 (net31 net158 vdda vdda) pmos1 l=180n w=1u m=1
	mpd11 (net56 inn net31 net31) pmos1 l=180n w=1u m=1
	mp001 (out net158 vdda vdda) pmos1 l=180n w=1u m=1
	mpd12 (net13 inp net31 net31) pmos1 l=2.3e-07n w=7.1e-07u m=1
	mpb01 (net158 net158 vdda vdda) pmos1 l=180n w=1u m=1
ends OPAMP1_variant83

subckt OPAMP1_variant84 inn inp out pd xpd vdda vssa
	xd1 (vssa vdda) prim_nwd AREA=6.13907e-9 PJ=476.6e-6 m=1
	xi0 (vssa net69) prim_nd AREA=1e-12 PJ=4e-6 m=1
	xi3 (net51 vdda) prim_pd AREA=790e-15 PJ=3.3e-6 m=1
	xr0 (vssa vdda net51) prim_rdiffp l=2.1e-6 w=700e-9 m=1
	xr1 (vdda vdda net69) prim_rdiffp l=2.1e-6 w=700e-9 m=1
	xcc01 (net12 out) prim_cpoly c=1p m=1
	mnm12 (net13 net56 vssa vssa) nmos1 l=180n w=1u m=1
	mnm11 (net56 net56 vssa vssa) nmos1 l=180n w=1u m=1
	mnb02 (net27 net27 net21 vssa) nmos1 l=180n w=1u m=1
	mnpd1 (net21 xpd vssa vssa) nmos1 l=180n w=1u m=1
	mn001 (out net13 vssa vssa) nmos1 l=180n w=1u m=1
	mnpd2 (net13 pd vssa vssa) nmos1 l=180n w=1u m=1
	mnc01 (net13 net69 net12 vssa) nmos1 l=180n w=1u m=1
	mpb02 (net27 net51 net158 vdda) pmos1 l=180n w=1u m=1
	mppd1 (net158 xpd vdda vdda) pmos1 l=2.4e-07n w=9.5e-07u m=1
	mps11 (net31 net158 vdda vdda) pmos1 l=180n w=1u m=1
	mpd11 (net56 inn net31 net31) pmos1 l=2.3e-07n w=5.4e-07u m=1
	mp001 (out net158 vdda vdda) pmos1 l=180n w=1u m=1
	mpd12 (net13 inp net31 net31) pmos1 l=180n w=1u m=1
	mpb01 (net158 net158 vdda vdda) pmos1 l=180n w=1u m=1
ends OPAMP1_variant84

subckt OPAMP1_variant85 inn inp out pd xpd vdda vssa
	xd1 (vssa vdda) prim_nwd AREA=6.13907e-9 PJ=476.6e-6 m=1
	xi0 (vssa net69) prim_nd AREA=1e-12 PJ=4e-6 m=1
	xi3 (net51 vdda) prim_pd AREA=9.5e-09 PJ=8.2e-05 m=1
	xr0 (vssa vdda net51) prim_rdiffp l=2.1e-6 w=700e-9 m=1
	xr1 (vdda vdda net69) prim_rdiffp l=2.1e-6 w=700e-9 m=1
	xcc01 (net12 out) prim_cpoly c=1p m=1
	mnm12 (net13 net56 vssa vssa) nmos1 l=180n w=1u m=1
	mnm11 (net56 net56 vssa vssa) nmos1 l=180n w=1u m=1
	mnb02 (net27 net27 net21 vssa) nmos1 l=180n w=1u m=1
	mnpd1 (net21 xpd vssa vssa) nmos1 l=180n w=1u m=1
	mn001 (out net13 vssa vssa) nmos1 l=180n w=1u m=1
	mnpd2 (net13 pd vssa vssa) nmos1 l=180n w=1u m=1
	mnc01 (net13 net69 net12 vssa) nmos1 l=1.9e-07n w=1.4e-06u m=1
	mpb02 (net27 net51 net158 vdda) pmos1 l=180n w=1u m=1
	mppd1 (net158 xpd vdda vdda) pmos1 l=180n w=1u m=1
	mps11 (net31 net158 vdda vdda) pmos1 l=180n w=1u m=1
	mpd11 (net56 inn net31 net31) pmos1 l=180n w=1u m=1
	mp001 (out net158 vdda vdda) pmos1 l=180n w=1u m=1
	mpd12 (net13 inp net31 net31) pmos1 l=2.5e-07n w=8.3e-07u m=1
	mpb01 (net158 net158 vdda vdda) pmos1 l=180n w=1u m=1
ends OPAMP1_variant85

subckt OPAMP1_variant86 inn inp out pd xpd vdda vssa
	xd1 (vssa vdda) prim_nwd AREA=5.5e-09 PJ=6.6e-06 m=1
	xi0 (vssa net69) prim_nd AREA=1e-12 PJ=4e-6 m=1
	xi3 (net51 vdda) prim_pd AREA=790e-15 PJ=3.3e-6 m=1
	xr0 (vssa vdda net51) prim_rdiffp l=2.1e-6 w=700e-9 m=1
	xr1 (vdda vdda net69) prim_rdiffp l=2.1e-6 w=700e-9 m=1
	xcc01 (net12 out) prim_cpoly c=1p m=1
	mnm12 (net13 net56 vssa vssa) nmos1 l=180n w=1u m=1
	mnm11 (net56 net56 vssa vssa) nmos1 l=180n w=1u m=1
	mnb02 (net27 net27 net21 vssa) nmos1 l=180n w=1u m=1
	mnpd1 (net21 xpd vssa vssa) nmos1 l=1.9e-07n w=1.7e-06u m=1
	mn001 (out net13 vssa vssa) nmos1 l=1.7e-07n w=1.6e-06u m=1
	mnpd2 (net13 pd vssa vssa) nmos1 l=180n w=1u m=1
	mnc01 (net13 net69 net12 vssa) nmos1 l=2.0e-07n w=5.1e-07u m=1
	mpb02 (net27 net51 net158 vdda) pmos1 l=180n w=1u m=1
	mppd1 (net158 xpd vdda vdda) pmos1 l=180n w=1u m=1
	mps11 (net31 net158 vdda vdda) pmos1 l=180n w=1u m=1
	mpd11 (net56 inn net31 net31) pmos1 l=180n w=1u m=1
	mp001 (out net158 vdda vdda) pmos1 l=180n w=1u m=1
	mpd12 (net13 inp net31 net31) pmos1 l=180n w=1u m=1
	mpb01 (net158 net158 vdda vdda) pmos1 l=180n w=1u m=1
ends OPAMP1_variant86

subckt OPAMP1_variant87 inn inp out pd xpd vdda vssa
	xd1 (vssa vdda) prim_nwd AREA=6.13907e-9 PJ=476.6e-6 m=1
	xi0 (vssa net69) prim_nd AREA=1e-12 PJ=4e-6 m=1
	xi3 (net51 vdda) prim_pd AREA=790e-15 PJ=3.3e-6 m=1
	xr0 (vssa vdda net51) prim_rdiffp l=2.1e-6 w=700e-9 m=1
	xr1 (vdda vdda net69) prim_rdiffp l=2.1e-6 w=700e-9 m=1
	xcc01 (net12 out) prim_cpoly c=6.8e-13p m=1
	mnm12 (net13 net56 vssa vssa) nmos1 l=180n w=1u m=1
	mnm11 (net56 net56 vssa vssa) nmos1 l=180n w=1u m=1
	mnb02 (net27 net27 net21 vssa) nmos1 l=180n w=1u m=1
	mnpd1 (net21 xpd vssa vssa) nmos1 l=180n w=1u m=1
	mn001 (out net13 vssa vssa) nmos1 l=180n w=1u m=1
	mnpd2 (net13 pd vssa vssa) nmos1 l=180n w=1u m=1
	mnc01 (net13 net69 net12 vssa) nmos1 l=180n w=1u m=1
	mpb02 (net27 net51 net158 vdda) pmos1 l=180n w=1u m=1
	mppd1 (net158 xpd vdda vdda) pmos1 l=180n w=1u m=1
	mps11 (net31 net158 vdda vdda) pmos1 l=2.9e-07n w=1.7e-06u m=1
	mpd11 (net56 inn net31 net31) pmos1 l=180n w=1u m=1
	mp001 (out net158 vdda vdda) pmos1 l=2.0e-07n w=1.9e-06u m=1
	mpd12 (net13 inp net31 net31) pmos1 l=180n w=1u m=1
	mpb01 (net158 net158 vdda vdda) pmos1 l=1.5e-07n w=6.1e-07u m=1
ends OPAMP1_variant87

subckt OPAMP1_variant88 inn inp out pd xpd vdda vssa
	xd1 (vssa vdda) prim_nwd AREA=6.13907e-9 PJ=476.6e-6 m=1
	xi0 (vssa net69) prim_nd AREA=1e-12 PJ=4e-6 m=1
	xi3 (net51 vdda) prim_pd AREA=7.0e-09 PJ=4.5e-05 m=1
	xr0 (vssa vdda net51) prim_rdiffp l=2.1e-6 w=700e-9 m=1
	xr1 (vdda vdda net69) prim_rdiffp l=2.1e-6 w=700e-9 m=1
	xcc01 (net12 out) prim_cpoly c=1p m=1
	mnm12 (net13 net56 vssa vssa) nmos1 l=180n w=1u m=1
	mnm11 (net56 net56 vssa vssa) nmos1 l=180n w=1u m=1
	mnb02 (net27 net27 net21 vssa) nmos1 l=180n w=1u m=1
	mnpd1 (net21 xpd vssa vssa) nmos1 l=180n w=1u m=1
	mn001 (out net13 vssa vssa) nmos1 l=2.1e-07n w=1.7e-06u m=1
	mnpd2 (net13 pd vssa vssa) nmos1 l=180n w=1u m=1
	mnc01 (net13 net69 net12 vssa) nmos1 l=180n w=1u m=1
	mpb02 (net27 net51 net158 vdda) pmos1 l=180n w=1u m=1
	mppd1 (net158 xpd vdda vdda) pmos1 l=180n w=1u m=1
	mps11 (net31 net158 vdda vdda) pmos1 l=180n w=1u m=1
	mpd11 (net56 inn net31 net31) pmos1 l=180n w=1u m=1
	mp001 (out net158 vdda vdda) pmos1 l=2.5e-07n w=6.9e-07u m=1
	mpd12 (net13 inp net31 net31) pmos1 l=180n w=1u m=1
	mpb01 (net158 net158 vdda vdda) pmos1 l=180n w=1u m=1
ends OPAMP1_variant88

subckt OPAMP1_variant89 inn inp out pd xpd vdda vssa
	xd1 (vssa vdda) prim_nwd AREA=6.13907e-9 PJ=476.6e-6 m=1
	xi0 (vssa net69) prim_nd AREA=1e-12 PJ=4e-6 m=1
	xi3 (net51 vdda) prim_pd AREA=8.5e-09 PJ=8.9e-05 m=1
	xr0 (vssa vdda net51) prim_rdiffp l=2.1e-6 w=700e-9 m=1
	xr1 (vdda vdda net69) prim_rdiffp l=2.1e-6 w=700e-9 m=1
	xcc01 (net12 out) prim_cpoly c=1p m=1
	mnm12 (net13 net56 vssa vssa) nmos1 l=180n w=1u m=1
	mnm11 (net56 net56 vssa vssa) nmos1 l=180n w=1u m=1
	mnb02 (net27 net27 net21 vssa) nmos1 l=180n w=1u m=1
	mnpd1 (net21 xpd vssa vssa) nmos1 l=180n w=1u m=1
	mn001 (out net13 vssa vssa) nmos1 l=2.3e-07n w=1.2e-06u m=1
	mnpd2 (net13 pd vssa vssa) nmos1 l=180n w=1u m=1
	mnc01 (net13 net69 net12 vssa) nmos1 l=180n w=1u m=1
	mpb02 (net27 net51 net158 vdda) pmos1 l=180n w=1u m=1
	mppd1 (net158 xpd vdda vdda) pmos1 l=180n w=1u m=1
	mps11 (net31 net158 vdda vdda) pmos1 l=180n w=1u m=1
	mpd11 (net56 inn net31 net31) pmos1 l=180n w=1u m=1
	mp001 (out net158 vdda vdda) pmos1 l=180n w=1u m=1
	mpd12 (net13 inp net31 net31) pmos1 l=180n w=1u m=1
	mpb01 (net158 net158 vdda vdda) pmos1 l=180n w=1u m=1
ends OPAMP1_variant89

subckt OPAMP1_variant90 inn inp out pd xpd vdda vssa
	xd1 (vssa vdda) prim_nwd AREA=6.13907e-9 PJ=476.6e-6 m=1
	xi0 (vssa net69) prim_nd AREA=1e-12 PJ=4e-6 m=1
	xi3 (net51 vdda) prim_pd AREA=1.0e-09 PJ=5.0e-05 m=1
	xr0 (vssa vdda net51) prim_rdiffp l=2.1e-6 w=700e-9 m=1
	xr1 (vdda vdda net69) prim_rdiffp l=2.1e-6 w=700e-9 m=1
	xcc01 (net12 out) prim_cpoly c=1p m=1
	mnm12 (net13 net56 vssa vssa) nmos1 l=180n w=1u m=1
	mnm11 (net56 net56 vssa vssa) nmos1 l=2.2e-07n w=7.4e-07u m=1
	mnb02 (net27 net27 net21 vssa) nmos1 l=180n w=1u m=1
	mnpd1 (net21 xpd vssa vssa) nmos1 l=180n w=1u m=1
	mn001 (out net13 vssa vssa) nmos1 l=180n w=1u m=1
	mnpd2 (net13 pd vssa vssa) nmos1 l=180n w=1u m=1
	mnc01 (net13 net69 net12 vssa) nmos1 l=180n w=1u m=1
	mpb02 (net27 net51 net158 vdda) pmos1 l=180n w=1u m=1
	mppd1 (net158 xpd vdda vdda) pmos1 l=180n w=1u m=1
	mps11 (net31 net158 vdda vdda) pmos1 l=1.3e-07n w=1.5e-06u m=1
	mpd11 (net56 inn net31 net31) pmos1 l=180n w=1u m=1
	mp001 (out net158 vdda vdda) pmos1 l=180n w=1u m=1
	mpd12 (net13 inp net31 net31) pmos1 l=180n w=1u m=1
	mpb01 (net158 net158 vdda vdda) pmos1 l=180n w=1u m=1
ends OPAMP1_variant90

subckt OPAMP1_variant91 inn inp out pd xpd vdda vssa
	xd1 (vssa vdda) prim_nwd AREA=6.13907e-9 PJ=476.6e-6 m=1
	xi0 (vssa net69) prim_nd AREA=1e-12 PJ=4e-6 m=1
	xi3 (net51 vdda) prim_pd AREA=790e-15 PJ=3.3e-6 m=1
	xr0 (vssa vdda net51) prim_rdiffp l=2.1e-6 w=700e-9 m=1
	xr1 (vdda vdda net69) prim_rdiffp l=2.1e-6 w=700e-9 m=1
	xcc01 (net12 out) prim_cpoly c=1p m=1
	mnm12 (net13 net56 vssa vssa) nmos1 l=180n w=1u m=1
	mnm11 (net56 net56 vssa vssa) nmos1 l=180n w=1u m=1
	mnb02 (net27 net27 net21 vssa) nmos1 l=180n w=1u m=1
	mnpd1 (net21 xpd vssa vssa) nmos1 l=2.6e-07n w=9.3e-07u m=1
	mn001 (out net13 vssa vssa) nmos1 l=180n w=1u m=1
	mnpd2 (net13 pd vssa vssa) nmos1 l=180n w=1u m=1
	mnc01 (net13 net69 net12 vssa) nmos1 l=2.2e-07n w=1.5e-06u m=1
	mpb02 (net27 net51 net158 vdda) pmos1 l=180n w=1u m=1
	mppd1 (net158 xpd vdda vdda) pmos1 l=180n w=1u m=1
	mps11 (net31 net158 vdda vdda) pmos1 l=180n w=1u m=1
	mpd11 (net56 inn net31 net31) pmos1 l=180n w=1u m=1
	mp001 (out net158 vdda vdda) pmos1 l=180n w=1u m=1
	mpd12 (net13 inp net31 net31) pmos1 l=180n w=1u m=1
	mpb01 (net158 net158 vdda vdda) pmos1 l=180n w=1u m=1
ends OPAMP1_variant91

subckt OPAMP1_variant92 inn inp out pd xpd vdda vssa
	xd1 (vssa vdda) prim_nwd AREA=6.13907e-9 PJ=476.6e-6 m=1
	xi0 (vssa net69) prim_nd AREA=1e-12 PJ=4e-6 m=1
	xi3 (net51 vdda) prim_pd AREA=790e-15 PJ=3.3e-6 m=1
	xr0 (vssa vdda net51) prim_rdiffp l=2.1e-6 w=700e-9 m=1
	xr1 (vdda vdda net69) prim_rdiffp l=2.1e-6 w=700e-9 m=1
	xcc01 (net12 out) prim_cpoly c=1p m=1
	mnm12 (net13 net56 vssa vssa) nmos1 l=3.0e-07n w=1.2e-06u m=1
	mnm11 (net56 net56 vssa vssa) nmos1 l=180n w=1u m=1
	mnb02 (net27 net27 net21 vssa) nmos1 l=180n w=1u m=1
	mnpd1 (net21 xpd vssa vssa) nmos1 l=180n w=1u m=1
	mn001 (out net13 vssa vssa) nmos1 l=180n w=1u m=1
	mnpd2 (net13 pd vssa vssa) nmos1 l=1.1e-07n w=1.0e-06u m=1
	mnc01 (net13 net69 net12 vssa) nmos1 l=180n w=1u m=1
	mpb02 (net27 net51 net158 vdda) pmos1 l=2.4e-07n w=1.5e-06u m=1
	mppd1 (net158 xpd vdda vdda) pmos1 l=180n w=1u m=1
	mps11 (net31 net158 vdda vdda) pmos1 l=180n w=1u m=1
	mpd11 (net56 inn net31 net31) pmos1 l=180n w=1u m=1
	mp001 (out net158 vdda vdda) pmos1 l=180n w=1u m=1
	mpd12 (net13 inp net31 net31) pmos1 l=180n w=1u m=1
	mpb01 (net158 net158 vdda vdda) pmos1 l=180n w=1u m=1
ends OPAMP1_variant92

subckt OPAMP1_variant93 inn inp out pd xpd vdda vssa
	xd1 (vssa vdda) prim_nwd AREA=6.13907e-9 PJ=476.6e-6 m=1
	xi0 (vssa net69) prim_nd AREA=1e-12 PJ=4e-6 m=1
	xi3 (net51 vdda) prim_pd AREA=790e-15 PJ=3.3e-6 m=1
	xr0 (vssa vdda net51) prim_rdiffp l=2.1e-6 w=700e-9 m=1
	xr1 (vdda vdda net69) prim_rdiffp l=1.6e-07 w=7.9e-07 m=1
	xcc01 (net12 out) prim_cpoly c=1p m=1
	mnm12 (net13 net56 vssa vssa) nmos1 l=180n w=1u m=1
	mnm11 (net56 net56 vssa vssa) nmos1 l=180n w=1u m=1
	mnb02 (net27 net27 net21 vssa) nmos1 l=1.2e-07n w=1.5e-06u m=1
	mnpd1 (net21 xpd vssa vssa) nmos1 l=180n w=1u m=1
	mn001 (out net13 vssa vssa) nmos1 l=1.7e-07n w=5.2e-07u m=1
	mnpd2 (net13 pd vssa vssa) nmos1 l=180n w=1u m=1
	mnc01 (net13 net69 net12 vssa) nmos1 l=180n w=1u m=1
	mpb02 (net27 net51 net158 vdda) pmos1 l=180n w=1u m=1
	mppd1 (net158 xpd vdda vdda) pmos1 l=180n w=1u m=1
	mps11 (net31 net158 vdda vdda) pmos1 l=180n w=1u m=1
	mpd11 (net56 inn net31 net31) pmos1 l=180n w=1u m=1
	mp001 (out net158 vdda vdda) pmos1 l=2.0e-07n w=1.2e-06u m=1
	mpd12 (net13 inp net31 net31) pmos1 l=180n w=1u m=1
	mpb01 (net158 net158 vdda vdda) pmos1 l=1.8e-07n w=5.5e-07u m=1
ends OPAMP1_variant93

subckt OPAMP1_variant94 inn inp out pd xpd vdda vssa
	xd1 (vssa vdda) prim_nwd AREA=6.13907e-9 PJ=476.6e-6 m=1
	xi0 (vssa net69) prim_nd AREA=1e-12 PJ=4e-6 m=1
	xi3 (net51 vdda) prim_pd AREA=790e-15 PJ=3.3e-6 m=1
	xr0 (vssa vdda net51) prim_rdiffp l=2.1e-6 w=700e-9 m=1
	xr1 (vdda vdda net69) prim_rdiffp l=2.1e-6 w=700e-9 m=1
	xcc01 (net12 out) prim_cpoly c=1p m=1
	mnm12 (net13 net56 vssa vssa) nmos1 l=1.8e-07n w=1.2e-06u m=1
	mnm11 (net56 net56 vssa vssa) nmos1 l=180n w=1u m=1
	mnb02 (net27 net27 net21 vssa) nmos1 l=180n w=1u m=1
	mnpd1 (net21 xpd vssa vssa) nmos1 l=180n w=1u m=1
	mn001 (out net13 vssa vssa) nmos1 l=180n w=1u m=1
	mnpd2 (net13 pd vssa vssa) nmos1 l=2.1e-07n w=1.3e-06u m=1
	mnc01 (net13 net69 net12 vssa) nmos1 l=1.6e-07n w=6.0e-07u m=1
	mpb02 (net27 net51 net158 vdda) pmos1 l=180n w=1u m=1
	mppd1 (net158 xpd vdda vdda) pmos1 l=180n w=1u m=1
	mps11 (net31 net158 vdda vdda) pmos1 l=180n w=1u m=1
	mpd11 (net56 inn net31 net31) pmos1 l=180n w=1u m=1
	mp001 (out net158 vdda vdda) pmos1 l=180n w=1u m=1
	mpd12 (net13 inp net31 net31) pmos1 l=180n w=1u m=1
	mpb01 (net158 net158 vdda vdda) pmos1 l=180n w=1u m=1
ends OPAMP1_variant94

subckt OPAMP1_variant95 inn inp out pd xpd vdda vssa
	xd1 (vssa vdda) prim_nwd AREA=6.13907e-9 PJ=476.6e-6 m=1
	xi0 (vssa net69) prim_nd AREA=7.3e-09 PJ=1.4e-05 m=1
	xi3 (net51 vdda) prim_pd AREA=790e-15 PJ=3.3e-6 m=1
	xr0 (vssa vdda net51) prim_rdiffp l=2.1e-6 w=700e-9 m=1
	xr1 (vdda vdda net69) prim_rdiffp l=2.1e-6 w=700e-9 m=1
	xcc01 (net12 out) prim_cpoly c=1p m=1
	mnm12 (net13 net56 vssa vssa) nmos1 l=180n w=1u m=1
	mnm11 (net56 net56 vssa vssa) nmos1 l=2.1e-07n w=1.9e-06u m=1
	mnb02 (net27 net27 net21 vssa) nmos1 l=180n w=1u m=1
	mnpd1 (net21 xpd vssa vssa) nmos1 l=180n w=1u m=1
	mn001 (out net13 vssa vssa) nmos1 l=180n w=1u m=1
	mnpd2 (net13 pd vssa vssa) nmos1 l=180n w=1u m=1
	mnc01 (net13 net69 net12 vssa) nmos1 l=180n w=1u m=1
	mpb02 (net27 net51 net158 vdda) pmos1 l=180n w=1u m=1
	mppd1 (net158 xpd vdda vdda) pmos1 l=180n w=1u m=1
	mps11 (net31 net158 vdda vdda) pmos1 l=180n w=1u m=1
	mpd11 (net56 inn net31 net31) pmos1 l=180n w=1u m=1
	mp001 (out net158 vdda vdda) pmos1 l=180n w=1u m=1
	mpd12 (net13 inp net31 net31) pmos1 l=180n w=1u m=1
	mpb01 (net158 net158 vdda vdda) pmos1 l=180n w=1u m=1
ends OPAMP1_variant95

subckt OPAMP1_variant96 inn inp out pd xpd vdda vssa
	xd1 (vssa vdda) prim_nwd AREA=6.13907e-9 PJ=476.6e-6 m=1
	xi0 (vssa net69) prim_nd AREA=2.4e-10 PJ=8.4e-05 m=1
	xi3 (net51 vdda) prim_pd AREA=790e-15 PJ=3.3e-6 m=1
	xr0 (vssa vdda net51) prim_rdiffp l=2.7e-07 w=1.1e-06 m=1
	xr1 (vdda vdda net69) prim_rdiffp l=1.0e-07 w=9.6e-07 m=1
	xcc01 (net12 out) prim_cpoly c=1p m=1
	mnm12 (net13 net56 vssa vssa) nmos1 l=180n w=1u m=1
	mnm11 (net56 net56 vssa vssa) nmos1 l=180n w=1u m=1
	mnb02 (net27 net27 net21 vssa) nmos1 l=180n w=1u m=1
	mnpd1 (net21 xpd vssa vssa) nmos1 l=2.7e-07n w=2.0e-06u m=1
	mn001 (out net13 vssa vssa) nmos1 l=180n w=1u m=1
	mnpd2 (net13 pd vssa vssa) nmos1 l=180n w=1u m=1
	mnc01 (net13 net69 net12 vssa) nmos1 l=180n w=1u m=1
	mpb02 (net27 net51 net158 vdda) pmos1 l=180n w=1u m=1
	mppd1 (net158 xpd vdda vdda) pmos1 l=180n w=1u m=1
	mps11 (net31 net158 vdda vdda) pmos1 l=180n w=1u m=1
	mpd11 (net56 inn net31 net31) pmos1 l=180n w=1u m=1
	mp001 (out net158 vdda vdda) pmos1 l=2.5e-07n w=1.4e-06u m=1
	mpd12 (net13 inp net31 net31) pmos1 l=180n w=1u m=1
	mpb01 (net158 net158 vdda vdda) pmos1 l=180n w=1u m=1
ends OPAMP1_variant96

subckt OPAMP1_variant97 inn inp out pd xpd vdda vssa
	xd1 (vssa vdda) prim_nwd AREA=6.13907e-9 PJ=476.6e-6 m=1
	xi0 (vssa net69) prim_nd AREA=1e-12 PJ=4e-6 m=1
	xi3 (net51 vdda) prim_pd AREA=790e-15 PJ=3.3e-6 m=1
	xr0 (vssa vdda net51) prim_rdiffp l=2.1e-6 w=700e-9 m=1
	xr1 (vdda vdda net69) prim_rdiffp l=2.3e-07 w=1.7e-06 m=1
	xcc01 (net12 out) prim_cpoly c=1p m=1
	mnm12 (net13 net56 vssa vssa) nmos1 l=180n w=1u m=1
	mnm11 (net56 net56 vssa vssa) nmos1 l=2.2e-07n w=1.5e-06u m=1
	mnb02 (net27 net27 net21 vssa) nmos1 l=180n w=1u m=1
	mnpd1 (net21 xpd vssa vssa) nmos1 l=180n w=1u m=1
	mn001 (out net13 vssa vssa) nmos1 l=180n w=1u m=1
	mnpd2 (net13 pd vssa vssa) nmos1 l=180n w=1u m=1
	mnc01 (net13 net69 net12 vssa) nmos1 l=180n w=1u m=1
	mpb02 (net27 net51 net158 vdda) pmos1 l=1.8e-07n w=1.5e-06u m=1
	mppd1 (net158 xpd vdda vdda) pmos1 l=180n w=1u m=1
	mps11 (net31 net158 vdda vdda) pmos1 l=1.1e-07n w=1.1e-06u m=1
	mpd11 (net56 inn net31 net31) pmos1 l=180n w=1u m=1
	mp001 (out net158 vdda vdda) pmos1 l=180n w=1u m=1
	mpd12 (net13 inp net31 net31) pmos1 l=180n w=1u m=1
	mpb01 (net158 net158 vdda vdda) pmos1 l=180n w=1u m=1
ends OPAMP1_variant97

subckt OPAMP1_variant98 inn inp out pd xpd vdda vssa
	xd1 (vssa vdda) prim_nwd AREA=6.13907e-9 PJ=476.6e-6 m=1
	xi0 (vssa net69) prim_nd AREA=7.8e-09 PJ=9.5e-05 m=1
	xi3 (net51 vdda) prim_pd AREA=790e-15 PJ=3.3e-6 m=1
	xr0 (vssa vdda net51) prim_rdiffp l=2.1e-6 w=700e-9 m=1
	xr1 (vdda vdda net69) prim_rdiffp l=2.1e-6 w=700e-9 m=1
	xcc01 (net12 out) prim_cpoly c=7.6e-13p m=1
	mnm12 (net13 net56 vssa vssa) nmos1 l=180n w=1u m=1
	mnm11 (net56 net56 vssa vssa) nmos1 l=180n w=1u m=1
	mnb02 (net27 net27 net21 vssa) nmos1 l=180n w=1u m=1
	mnpd1 (net21 xpd vssa vssa) nmos1 l=180n w=1u m=1
	mn001 (out net13 vssa vssa) nmos1 l=180n w=1u m=1
	mnpd2 (net13 pd vssa vssa) nmos1 l=180n w=1u m=1
	mnc01 (net13 net69 net12 vssa) nmos1 l=2.7e-07n w=5.6e-07u m=1
	mpb02 (net27 net51 net158 vdda) pmos1 l=180n w=1u m=1
	mppd1 (net158 xpd vdda vdda) pmos1 l=180n w=1u m=1
	mps11 (net31 net158 vdda vdda) pmos1 l=180n w=1u m=1
	mpd11 (net56 inn net31 net31) pmos1 l=180n w=1u m=1
	mp001 (out net158 vdda vdda) pmos1 l=2.7e-07n w=1.2e-06u m=1
	mpd12 (net13 inp net31 net31) pmos1 l=2.0e-07n w=1.0e-06u m=1
	mpb01 (net158 net158 vdda vdda) pmos1 l=180n w=1u m=1
ends OPAMP1_variant98

subckt OPAMP1_variant99 inn inp out pd xpd vdda vssa
	xd1 (vssa vdda) prim_nwd AREA=6.13907e-9 PJ=476.6e-6 m=1
	xi0 (vssa net69) prim_nd AREA=6.8e-09 PJ=2.7e-05 m=1
	xi3 (net51 vdda) prim_pd AREA=790e-15 PJ=3.3e-6 m=1
	xr0 (vssa vdda net51) prim_rdiffp l=2.1e-6 w=700e-9 m=1
	xr1 (vdda vdda net69) prim_rdiffp l=2.1e-6 w=700e-9 m=1
	xcc01 (net12 out) prim_cpoly c=1p m=1
	mnm12 (net13 net56 vssa vssa) nmos1 l=180n w=1u m=1
	mnm11 (net56 net56 vssa vssa) nmos1 l=180n w=1u m=1
	mnb02 (net27 net27 net21 vssa) nmos1 l=2.5e-07n w=1.9e-06u m=1
	mnpd1 (net21 xpd vssa vssa) nmos1 l=180n w=1u m=1
	mn001 (out net13 vssa vssa) nmos1 l=2.8e-07n w=1.8e-06u m=1
	mnpd2 (net13 pd vssa vssa) nmos1 l=180n w=1u m=1
	mnc01 (net13 net69 net12 vssa) nmos1 l=180n w=1u m=1
	mpb02 (net27 net51 net158 vdda) pmos1 l=180n w=1u m=1
	mppd1 (net158 xpd vdda vdda) pmos1 l=2.0e-07n w=1.1e-06u m=1
	mps11 (net31 net158 vdda vdda) pmos1 l=180n w=1u m=1
	mpd11 (net56 inn net31 net31) pmos1 l=180n w=1u m=1
	mp001 (out net158 vdda vdda) pmos1 l=180n w=1u m=1
	mpd12 (net13 inp net31 net31) pmos1 l=180n w=1u m=1
	mpb01 (net158 net158 vdda vdda) pmos1 l=180n w=1u m=1
ends OPAMP1_variant99

subckt OPAMP1_variant100 inn inp out pd xpd vdda vssa
	xd1 (vssa vdda) prim_nwd AREA=6.13907e-9 PJ=476.6e-6 m=1
	xi0 (vssa net69) prim_nd AREA=4.3e-09 PJ=2.9e-05 m=1
	xi3 (net51 vdda) prim_pd AREA=790e-15 PJ=3.3e-6 m=1
	xr0 (vssa vdda net51) prim_rdiffp l=2.1e-6 w=700e-9 m=1
	xr1 (vdda vdda net69) prim_rdiffp l=1.5e-07 w=6.0e-07 m=1
	xcc01 (net12 out) prim_cpoly c=1p m=1
	mnm12 (net13 net56 vssa vssa) nmos1 l=180n w=1u m=1
	mnm11 (net56 net56 vssa vssa) nmos1 l=180n w=1u m=1
	mnb02 (net27 net27 net21 vssa) nmos1 l=180n w=1u m=1
	mnpd1 (net21 xpd vssa vssa) nmos1 l=180n w=1u m=1
	mn001 (out net13 vssa vssa) nmos1 l=180n w=1u m=1
	mnpd2 (net13 pd vssa vssa) nmos1 l=180n w=1u m=1
	mnc01 (net13 net69 net12 vssa) nmos1 l=3.0e-07n w=1.5e-06u m=1
	mpb02 (net27 net51 net158 vdda) pmos1 l=180n w=1u m=1
	mppd1 (net158 xpd vdda vdda) pmos1 l=180n w=1u m=1
	mps11 (net31 net158 vdda vdda) pmos1 l=180n w=1u m=1
	mpd11 (net56 inn net31 net31) pmos1 l=180n w=1u m=1
	mp001 (out net158 vdda vdda) pmos1 l=180n w=1u m=1
	mpd12 (net13 inp net31 net31) pmos1 l=180n w=1u m=1
	mpb01 (net158 net158 vdda vdda) pmos1 l=180n w=1u m=1
ends OPAMP1_variant100

subckt OPAMP1_variant101 inn inp out pd xpd vdda vssa
	xd1 (vssa vdda) prim_nwd AREA=6.13907e-9 PJ=476.6e-6 m=1
	xi0 (vssa net69) prim_nd AREA=4.2e-09 PJ=6.2e-05 m=1
	xi3 (net51 vdda) prim_pd AREA=790e-15 PJ=3.3e-6 m=1
	xr0 (vssa vdda net51) prim_rdiffp l=2.1e-6 w=700e-9 m=1
	xr1 (vdda vdda net69) prim_rdiffp l=2.1e-6 w=700e-9 m=1
	xcc01 (net12 out) prim_cpoly c=1p m=1
	mnm12 (net13 net56 vssa vssa) nmos1 l=180n w=1u m=1
	mnm11 (net56 net56 vssa vssa) nmos1 l=180n w=1u m=1
	mnb02 (net27 net27 net21 vssa) nmos1 l=180n w=1u m=1
	mnpd1 (net21 xpd vssa vssa) nmos1 l=2.9e-07n w=6.6e-07u m=1
	mn001 (out net13 vssa vssa) nmos1 l=180n w=1u m=1
	mnpd2 (net13 pd vssa vssa) nmos1 l=180n w=1u m=1
	mnc01 (net13 net69 net12 vssa) nmos1 l=2.8e-07n w=1.1e-06u m=1
	mpb02 (net27 net51 net158 vdda) pmos1 l=2.9e-07n w=1.5e-06u m=1
	mppd1 (net158 xpd vdda vdda) pmos1 l=180n w=1u m=1
	mps11 (net31 net158 vdda vdda) pmos1 l=180n w=1u m=1
	mpd11 (net56 inn net31 net31) pmos1 l=180n w=1u m=1
	mp001 (out net158 vdda vdda) pmos1 l=180n w=1u m=1
	mpd12 (net13 inp net31 net31) pmos1 l=180n w=1u m=1
	mpb01 (net158 net158 vdda vdda) pmos1 l=2.4e-07n w=1.7e-06u m=1
ends OPAMP1_variant101

subckt OPAMP1_variant102 inn inp out pd xpd vdda vssa
	xd1 (vssa vdda) prim_nwd AREA=6.13907e-9 PJ=476.6e-6 m=1
	xi0 (vssa net69) prim_nd AREA=1e-12 PJ=4e-6 m=1
	xi3 (net51 vdda) prim_pd AREA=790e-15 PJ=3.3e-6 m=1
	xr0 (vssa vdda net51) prim_rdiffp l=2.1e-6 w=700e-9 m=1
	xr1 (vdda vdda net69) prim_rdiffp l=2.1e-6 w=700e-9 m=1
	xcc01 (net12 out) prim_cpoly c=1p m=1
	mnm12 (net13 net56 vssa vssa) nmos1 l=180n w=1u m=1
	mnm11 (net56 net56 vssa vssa) nmos1 l=180n w=1u m=1
	mnb02 (net27 net27 net21 vssa) nmos1 l=1.8e-07n w=1.9e-06u m=1
	mnpd1 (net21 xpd vssa vssa) nmos1 l=180n w=1u m=1
	mn001 (out net13 vssa vssa) nmos1 l=180n w=1u m=1
	mnpd2 (net13 pd vssa vssa) nmos1 l=180n w=1u m=1
	mnc01 (net13 net69 net12 vssa) nmos1 l=1.1e-07n w=6.5e-07u m=1
	mpb02 (net27 net51 net158 vdda) pmos1 l=180n w=1u m=1
	mppd1 (net158 xpd vdda vdda) pmos1 l=180n w=1u m=1
	mps11 (net31 net158 vdda vdda) pmos1 l=1.8e-07n w=9.3e-07u m=1
	mpd11 (net56 inn net31 net31) pmos1 l=180n w=1u m=1
	mp001 (out net158 vdda vdda) pmos1 l=180n w=1u m=1
	mpd12 (net13 inp net31 net31) pmos1 l=180n w=1u m=1
	mpb01 (net158 net158 vdda vdda) pmos1 l=180n w=1u m=1
ends OPAMP1_variant102

subckt OPAMP1_variant103 inn inp out pd xpd vdda vssa
	xd1 (vssa vdda) prim_nwd AREA=6.13907e-9 PJ=476.6e-6 m=1
	xi0 (vssa net69) prim_nd AREA=1e-12 PJ=4e-6 m=1
	xi3 (net51 vdda) prim_pd AREA=790e-15 PJ=3.3e-6 m=1
	xr0 (vssa vdda net51) prim_rdiffp l=2.1e-6 w=700e-9 m=1
	xr1 (vdda vdda net69) prim_rdiffp l=2.1e-6 w=700e-9 m=1
	xcc01 (net12 out) prim_cpoly c=1p m=1
	mnm12 (net13 net56 vssa vssa) nmos1 l=2.5e-07n w=6.4e-07u m=1
	mnm11 (net56 net56 vssa vssa) nmos1 l=180n w=1u m=1
	mnb02 (net27 net27 net21 vssa) nmos1 l=180n w=1u m=1
	mnpd1 (net21 xpd vssa vssa) nmos1 l=180n w=1u m=1
	mn001 (out net13 vssa vssa) nmos1 l=180n w=1u m=1
	mnpd2 (net13 pd vssa vssa) nmos1 l=180n w=1u m=1
	mnc01 (net13 net69 net12 vssa) nmos1 l=180n w=1u m=1
	mpb02 (net27 net51 net158 vdda) pmos1 l=180n w=1u m=1
	mppd1 (net158 xpd vdda vdda) pmos1 l=180n w=1u m=1
	mps11 (net31 net158 vdda vdda) pmos1 l=1.5e-07n w=1.5e-06u m=1
	mpd11 (net56 inn net31 net31) pmos1 l=180n w=1u m=1
	mp001 (out net158 vdda vdda) pmos1 l=180n w=1u m=1
	mpd12 (net13 inp net31 net31) pmos1 l=180n w=1u m=1
	mpb01 (net158 net158 vdda vdda) pmos1 l=180n w=1u m=1
ends OPAMP1_variant103

subckt OPAMP1_variant104 inn inp out pd xpd vdda vssa
	xd1 (vssa vdda) prim_nwd AREA=6.13907e-9 PJ=476.6e-6 m=1
	xi0 (vssa net69) prim_nd AREA=3.7e-09 PJ=9.5e-05 m=1
	xi3 (net51 vdda) prim_pd AREA=790e-15 PJ=3.3e-6 m=1
	xr0 (vssa vdda net51) prim_rdiffp l=2.1e-6 w=700e-9 m=1
	xr1 (vdda vdda net69) prim_rdiffp l=2.1e-6 w=700e-9 m=1
	xcc01 (net12 out) prim_cpoly c=1p m=1
	mnm12 (net13 net56 vssa vssa) nmos1 l=180n w=1u m=1
	mnm11 (net56 net56 vssa vssa) nmos1 l=180n w=1u m=1
	mnb02 (net27 net27 net21 vssa) nmos1 l=180n w=1u m=1
	mnpd1 (net21 xpd vssa vssa) nmos1 l=180n w=1u m=1
	mn001 (out net13 vssa vssa) nmos1 l=2.3e-07n w=9.1e-07u m=1
	mnpd2 (net13 pd vssa vssa) nmos1 l=2.0e-07n w=7.5e-07u m=1
	mnc01 (net13 net69 net12 vssa) nmos1 l=180n w=1u m=1
	mpb02 (net27 net51 net158 vdda) pmos1 l=1.1e-07n w=1.8e-06u m=1
	mppd1 (net158 xpd vdda vdda) pmos1 l=180n w=1u m=1
	mps11 (net31 net158 vdda vdda) pmos1 l=180n w=1u m=1
	mpd11 (net56 inn net31 net31) pmos1 l=180n w=1u m=1
	mp001 (out net158 vdda vdda) pmos1 l=1.6e-07n w=1.1e-06u m=1
	mpd12 (net13 inp net31 net31) pmos1 l=180n w=1u m=1
	mpb01 (net158 net158 vdda vdda) pmos1 l=180n w=1u m=1
ends OPAMP1_variant104

subckt OPAMP1_variant105 inn inp out pd xpd vdda vssa
	xd1 (vssa vdda) prim_nwd AREA=6.13907e-9 PJ=476.6e-6 m=1
	xi0 (vssa net69) prim_nd AREA=1e-12 PJ=4e-6 m=1
	xi3 (net51 vdda) prim_pd AREA=790e-15 PJ=3.3e-6 m=1
	xr0 (vssa vdda net51) prim_rdiffp l=2.1e-6 w=700e-9 m=1
	xr1 (vdda vdda net69) prim_rdiffp l=2.1e-6 w=700e-9 m=1
	xcc01 (net12 out) prim_cpoly c=8.0e-13p m=1
	mnm12 (net13 net56 vssa vssa) nmos1 l=180n w=1u m=1
	mnm11 (net56 net56 vssa vssa) nmos1 l=180n w=1u m=1
	mnb02 (net27 net27 net21 vssa) nmos1 l=180n w=1u m=1
	mnpd1 (net21 xpd vssa vssa) nmos1 l=180n w=1u m=1
	mn001 (out net13 vssa vssa) nmos1 l=180n w=1u m=1
	mnpd2 (net13 pd vssa vssa) nmos1 l=180n w=1u m=1
	mnc01 (net13 net69 net12 vssa) nmos1 l=2.3e-07n w=1.5e-06u m=1
	mpb02 (net27 net51 net158 vdda) pmos1 l=180n w=1u m=1
	mppd1 (net158 xpd vdda vdda) pmos1 l=180n w=1u m=1
	mps11 (net31 net158 vdda vdda) pmos1 l=180n w=1u m=1
	mpd11 (net56 inn net31 net31) pmos1 l=180n w=1u m=1
	mp001 (out net158 vdda vdda) pmos1 l=180n w=1u m=1
	mpd12 (net13 inp net31 net31) pmos1 l=180n w=1u m=1
	mpb01 (net158 net158 vdda vdda) pmos1 l=180n w=1u m=1
ends OPAMP1_variant105

subckt OPAMP1_variant106 inn inp out pd xpd vdda vssa
	xd1 (vssa vdda) prim_nwd AREA=6.13907e-9 PJ=476.6e-6 m=1
	xi0 (vssa net69) prim_nd AREA=1e-12 PJ=4e-6 m=1
	xi3 (net51 vdda) prim_pd AREA=790e-15 PJ=3.3e-6 m=1
	xr0 (vssa vdda net51) prim_rdiffp l=2.1e-6 w=700e-9 m=1
	xr1 (vdda vdda net69) prim_rdiffp l=2.1e-07 w=8.4e-07 m=1
	xcc01 (net12 out) prim_cpoly c=1p m=1
	mnm12 (net13 net56 vssa vssa) nmos1 l=180n w=1u m=1
	mnm11 (net56 net56 vssa vssa) nmos1 l=180n w=1u m=1
	mnb02 (net27 net27 net21 vssa) nmos1 l=180n w=1u m=1
	mnpd1 (net21 xpd vssa vssa) nmos1 l=1.2e-07n w=1.1e-06u m=1
	mn001 (out net13 vssa vssa) nmos1 l=180n w=1u m=1
	mnpd2 (net13 pd vssa vssa) nmos1 l=180n w=1u m=1
	mnc01 (net13 net69 net12 vssa) nmos1 l=180n w=1u m=1
	mpb02 (net27 net51 net158 vdda) pmos1 l=180n w=1u m=1
	mppd1 (net158 xpd vdda vdda) pmos1 l=180n w=1u m=1
	mps11 (net31 net158 vdda vdda) pmos1 l=180n w=1u m=1
	mpd11 (net56 inn net31 net31) pmos1 l=1.2e-07n w=1.8e-06u m=1
	mp001 (out net158 vdda vdda) pmos1 l=180n w=1u m=1
	mpd12 (net13 inp net31 net31) pmos1 l=180n w=1u m=1
	mpb01 (net158 net158 vdda vdda) pmos1 l=2.4e-07n w=6.2e-07u m=1
ends OPAMP1_variant106

subckt OPAMP1_variant107 inn inp out pd xpd vdda vssa
	xd1 (vssa vdda) prim_nwd AREA=6.13907e-9 PJ=476.6e-6 m=1
	xi0 (vssa net69) prim_nd AREA=1e-12 PJ=4e-6 m=1
	xi3 (net51 vdda) prim_pd AREA=790e-15 PJ=3.3e-6 m=1
	xr0 (vssa vdda net51) prim_rdiffp l=2.1e-6 w=700e-9 m=1
	xr1 (vdda vdda net69) prim_rdiffp l=2.1e-6 w=700e-9 m=1
	xcc01 (net12 out) prim_cpoly c=1p m=1
	mnm12 (net13 net56 vssa vssa) nmos1 l=180n w=1u m=1
	mnm11 (net56 net56 vssa vssa) nmos1 l=180n w=1u m=1
	mnb02 (net27 net27 net21 vssa) nmos1 l=180n w=1u m=1
	mnpd1 (net21 xpd vssa vssa) nmos1 l=180n w=1u m=1
	mn001 (out net13 vssa vssa) nmos1 l=180n w=1u m=1
	mnpd2 (net13 pd vssa vssa) nmos1 l=180n w=1u m=1
	mnc01 (net13 net69 net12 vssa) nmos1 l=180n w=1u m=1
	mpb02 (net27 net51 net158 vdda) pmos1 l=180n w=1u m=1
	mppd1 (net158 xpd vdda vdda) pmos1 l=2.4e-07n w=8.0e-07u m=1
	mps11 (net31 net158 vdda vdda) pmos1 l=180n w=1u m=1
	mpd11 (net56 inn net31 net31) pmos1 l=180n w=1u m=1
	mp001 (out net158 vdda vdda) pmos1 l=180n w=1u m=1
	mpd12 (net13 inp net31 net31) pmos1 l=180n w=1u m=1
	mpb01 (net158 net158 vdda vdda) pmos1 l=2.1e-07n w=1.8e-06u m=1
ends OPAMP1_variant107

subckt OPAMP1_variant108 inn inp out pd xpd vdda vssa
	xd1 (vssa vdda) prim_nwd AREA=6.13907e-9 PJ=476.6e-6 m=1
	xi0 (vssa net69) prim_nd AREA=1e-12 PJ=4e-6 m=1
	xi3 (net51 vdda) prim_pd AREA=7.3e-09 PJ=1.4e-05 m=1
	xr0 (vssa vdda net51) prim_rdiffp l=2.1e-6 w=700e-9 m=1
	xr1 (vdda vdda net69) prim_rdiffp l=2.2e-07 w=1.5e-06 m=1
	xcc01 (net12 out) prim_cpoly c=1p m=1
	mnm12 (net13 net56 vssa vssa) nmos1 l=180n w=1u m=1
	mnm11 (net56 net56 vssa vssa) nmos1 l=180n w=1u m=1
	mnb02 (net27 net27 net21 vssa) nmos1 l=2.1e-07n w=1.8e-06u m=1
	mnpd1 (net21 xpd vssa vssa) nmos1 l=180n w=1u m=1
	mn001 (out net13 vssa vssa) nmos1 l=180n w=1u m=1
	mnpd2 (net13 pd vssa vssa) nmos1 l=180n w=1u m=1
	mnc01 (net13 net69 net12 vssa) nmos1 l=180n w=1u m=1
	mpb02 (net27 net51 net158 vdda) pmos1 l=180n w=1u m=1
	mppd1 (net158 xpd vdda vdda) pmos1 l=180n w=1u m=1
	mps11 (net31 net158 vdda vdda) pmos1 l=180n w=1u m=1
	mpd11 (net56 inn net31 net31) pmos1 l=180n w=1u m=1
	mp001 (out net158 vdda vdda) pmos1 l=180n w=1u m=1
	mpd12 (net13 inp net31 net31) pmos1 l=1.2e-07n w=1.9e-06u m=1
	mpb01 (net158 net158 vdda vdda) pmos1 l=180n w=1u m=1
ends OPAMP1_variant108

subckt OPAMP1_variant109 inn inp out pd xpd vdda vssa
	xd1 (vssa vdda) prim_nwd AREA=6.13907e-9 PJ=476.6e-6 m=1
	xi0 (vssa net69) prim_nd AREA=4.6e-09 PJ=2.3e-05 m=1
	xi3 (net51 vdda) prim_pd AREA=9.0e-09 PJ=5.7e-06 m=1
	xr0 (vssa vdda net51) prim_rdiffp l=2.1e-6 w=700e-9 m=1
	xr1 (vdda vdda net69) prim_rdiffp l=2.1e-6 w=700e-9 m=1
	xcc01 (net12 out) prim_cpoly c=1p m=1
	mnm12 (net13 net56 vssa vssa) nmos1 l=180n w=1u m=1
	mnm11 (net56 net56 vssa vssa) nmos1 l=180n w=1u m=1
	mnb02 (net27 net27 net21 vssa) nmos1 l=180n w=1u m=1
	mnpd1 (net21 xpd vssa vssa) nmos1 l=180n w=1u m=1
	mn001 (out net13 vssa vssa) nmos1 l=180n w=1u m=1
	mnpd2 (net13 pd vssa vssa) nmos1 l=180n w=1u m=1
	mnc01 (net13 net69 net12 vssa) nmos1 l=180n w=1u m=1
	mpb02 (net27 net51 net158 vdda) pmos1 l=180n w=1u m=1
	mppd1 (net158 xpd vdda vdda) pmos1 l=180n w=1u m=1
	mps11 (net31 net158 vdda vdda) pmos1 l=180n w=1u m=1
	mpd11 (net56 inn net31 net31) pmos1 l=180n w=1u m=1
	mp001 (out net158 vdda vdda) pmos1 l=180n w=1u m=1
	mpd12 (net13 inp net31 net31) pmos1 l=2.8e-07n w=1.2e-06u m=1
	mpb01 (net158 net158 vdda vdda) pmos1 l=180n w=1u m=1
ends OPAMP1_variant109

subckt OPAMP1_variant110 inn inp out pd xpd vdda vssa
	xd1 (vssa vdda) prim_nwd AREA=6.13907e-9 PJ=476.6e-6 m=1
	xi0 (vssa net69) prim_nd AREA=1e-12 PJ=4e-6 m=1
	xi3 (net51 vdda) prim_pd AREA=9.9e-09 PJ=8.6e-05 m=1
	xr0 (vssa vdda net51) prim_rdiffp l=2.1e-6 w=700e-9 m=1
	xr1 (vdda vdda net69) prim_rdiffp l=2.1e-6 w=700e-9 m=1
	xcc01 (net12 out) prim_cpoly c=8.6e-13p m=1
	mnm12 (net13 net56 vssa vssa) nmos1 l=180n w=1u m=1
	mnm11 (net56 net56 vssa vssa) nmos1 l=180n w=1u m=1
	mnb02 (net27 net27 net21 vssa) nmos1 l=180n w=1u m=1
	mnpd1 (net21 xpd vssa vssa) nmos1 l=180n w=1u m=1
	mn001 (out net13 vssa vssa) nmos1 l=180n w=1u m=1
	mnpd2 (net13 pd vssa vssa) nmos1 l=180n w=1u m=1
	mnc01 (net13 net69 net12 vssa) nmos1 l=180n w=1u m=1
	mpb02 (net27 net51 net158 vdda) pmos1 l=180n w=1u m=1
	mppd1 (net158 xpd vdda vdda) pmos1 l=180n w=1u m=1
	mps11 (net31 net158 vdda vdda) pmos1 l=180n w=1u m=1
	mpd11 (net56 inn net31 net31) pmos1 l=180n w=1u m=1
	mp001 (out net158 vdda vdda) pmos1 l=180n w=1u m=1
	mpd12 (net13 inp net31 net31) pmos1 l=180n w=1u m=1
	mpb01 (net158 net158 vdda vdda) pmos1 l=180n w=1u m=1
ends OPAMP1_variant110

subckt OPAMP1_variant111 inn inp out pd xpd vdda vssa
	xd1 (vssa vdda) prim_nwd AREA=3.4e-09 PJ=9.4e-05 m=1
	xi0 (vssa net69) prim_nd AREA=1e-12 PJ=4e-6 m=1
	xi3 (net51 vdda) prim_pd AREA=7.6e-10 PJ=4.2e-05 m=1
	xr0 (vssa vdda net51) prim_rdiffp l=2.1e-6 w=700e-9 m=1
	xr1 (vdda vdda net69) prim_rdiffp l=2.1e-6 w=700e-9 m=1
	xcc01 (net12 out) prim_cpoly c=1p m=1
	mnm12 (net13 net56 vssa vssa) nmos1 l=2.9e-07n w=6.3e-07u m=1
	mnm11 (net56 net56 vssa vssa) nmos1 l=180n w=1u m=1
	mnb02 (net27 net27 net21 vssa) nmos1 l=180n w=1u m=1
	mnpd1 (net21 xpd vssa vssa) nmos1 l=180n w=1u m=1
	mn001 (out net13 vssa vssa) nmos1 l=180n w=1u m=1
	mnpd2 (net13 pd vssa vssa) nmos1 l=180n w=1u m=1
	mnc01 (net13 net69 net12 vssa) nmos1 l=180n w=1u m=1
	mpb02 (net27 net51 net158 vdda) pmos1 l=180n w=1u m=1
	mppd1 (net158 xpd vdda vdda) pmos1 l=180n w=1u m=1
	mps11 (net31 net158 vdda vdda) pmos1 l=180n w=1u m=1
	mpd11 (net56 inn net31 net31) pmos1 l=180n w=1u m=1
	mp001 (out net158 vdda vdda) pmos1 l=2.9e-07n w=1.5e-06u m=1
	mpd12 (net13 inp net31 net31) pmos1 l=180n w=1u m=1
	mpb01 (net158 net158 vdda vdda) pmos1 l=180n w=1u m=1
ends OPAMP1_variant111

subckt OPAMP1_variant112 inn inp out pd xpd vdda vssa
	xd1 (vssa vdda) prim_nwd AREA=6.13907e-9 PJ=476.6e-6 m=1
	xi0 (vssa net69) prim_nd AREA=6.6e-09 PJ=6.0e-05 m=1
	xi3 (net51 vdda) prim_pd AREA=790e-15 PJ=3.3e-6 m=1
	xr0 (vssa vdda net51) prim_rdiffp l=2.1e-6 w=700e-9 m=1
	xr1 (vdda vdda net69) prim_rdiffp l=2.1e-6 w=700e-9 m=1
	xcc01 (net12 out) prim_cpoly c=1p m=1
	mnm12 (net13 net56 vssa vssa) nmos1 l=180n w=1u m=1
	mnm11 (net56 net56 vssa vssa) nmos1 l=2.1e-07n w=1.3e-06u m=1
	mnb02 (net27 net27 net21 vssa) nmos1 l=180n w=1u m=1
	mnpd1 (net21 xpd vssa vssa) nmos1 l=180n w=1u m=1
	mn001 (out net13 vssa vssa) nmos1 l=180n w=1u m=1
	mnpd2 (net13 pd vssa vssa) nmos1 l=180n w=1u m=1
	mnc01 (net13 net69 net12 vssa) nmos1 l=180n w=1u m=1
	mpb02 (net27 net51 net158 vdda) pmos1 l=180n w=1u m=1
	mppd1 (net158 xpd vdda vdda) pmos1 l=180n w=1u m=1
	mps11 (net31 net158 vdda vdda) pmos1 l=2.6e-07n w=1.4e-06u m=1
	mpd11 (net56 inn net31 net31) pmos1 l=180n w=1u m=1
	mp001 (out net158 vdda vdda) pmos1 l=180n w=1u m=1
	mpd12 (net13 inp net31 net31) pmos1 l=180n w=1u m=1
	mpb01 (net158 net158 vdda vdda) pmos1 l=180n w=1u m=1
ends OPAMP1_variant112

subckt OPAMP1_variant113 inn inp out pd xpd vdda vssa
	xd1 (vssa vdda) prim_nwd AREA=6.5e-10 PJ=3.8e-05 m=1
	xi0 (vssa net69) prim_nd AREA=1e-12 PJ=4e-6 m=1
	xi3 (net51 vdda) prim_pd AREA=790e-15 PJ=3.3e-6 m=1
	xr0 (vssa vdda net51) prim_rdiffp l=2.1e-6 w=700e-9 m=1
	xr1 (vdda vdda net69) prim_rdiffp l=2.4e-07 w=1.1e-06 m=1
	xcc01 (net12 out) prim_cpoly c=1p m=1
	mnm12 (net13 net56 vssa vssa) nmos1 l=180n w=1u m=1
	mnm11 (net56 net56 vssa vssa) nmos1 l=180n w=1u m=1
	mnb02 (net27 net27 net21 vssa) nmos1 l=180n w=1u m=1
	mnpd1 (net21 xpd vssa vssa) nmos1 l=180n w=1u m=1
	mn001 (out net13 vssa vssa) nmos1 l=180n w=1u m=1
	mnpd2 (net13 pd vssa vssa) nmos1 l=180n w=1u m=1
	mnc01 (net13 net69 net12 vssa) nmos1 l=180n w=1u m=1
	mpb02 (net27 net51 net158 vdda) pmos1 l=2.3e-07n w=1.7e-06u m=1
	mppd1 (net158 xpd vdda vdda) pmos1 l=1.2e-07n w=1.2e-06u m=1
	mps11 (net31 net158 vdda vdda) pmos1 l=180n w=1u m=1
	mpd11 (net56 inn net31 net31) pmos1 l=180n w=1u m=1
	mp001 (out net158 vdda vdda) pmos1 l=180n w=1u m=1
	mpd12 (net13 inp net31 net31) pmos1 l=180n w=1u m=1
	mpb01 (net158 net158 vdda vdda) pmos1 l=180n w=1u m=1
ends OPAMP1_variant113

subckt OPAMP1_variant114 inn inp out pd xpd vdda vssa
	xd1 (vssa vdda) prim_nwd AREA=6.13907e-9 PJ=476.6e-6 m=1
	xi0 (vssa net69) prim_nd AREA=1e-12 PJ=4e-6 m=1
	xi3 (net51 vdda) prim_pd AREA=790e-15 PJ=3.3e-6 m=1
	xr0 (vssa vdda net51) prim_rdiffp l=2.1e-6 w=700e-9 m=1
	xr1 (vdda vdda net69) prim_rdiffp l=2.0e-07 w=1.8e-06 m=1
	xcc01 (net12 out) prim_cpoly c=1p m=1
	mnm12 (net13 net56 vssa vssa) nmos1 l=180n w=1u m=1
	mnm11 (net56 net56 vssa vssa) nmos1 l=180n w=1u m=1
	mnb02 (net27 net27 net21 vssa) nmos1 l=1.6e-07n w=7.5e-07u m=1
	mnpd1 (net21 xpd vssa vssa) nmos1 l=2.9e-07n w=1.7e-06u m=1
	mn001 (out net13 vssa vssa) nmos1 l=1.0e-07n w=1.0e-06u m=1
	mnpd2 (net13 pd vssa vssa) nmos1 l=180n w=1u m=1
	mnc01 (net13 net69 net12 vssa) nmos1 l=180n w=1u m=1
	mpb02 (net27 net51 net158 vdda) pmos1 l=180n w=1u m=1
	mppd1 (net158 xpd vdda vdda) pmos1 l=180n w=1u m=1
	mps11 (net31 net158 vdda vdda) pmos1 l=1.5e-07n w=8.4e-07u m=1
	mpd11 (net56 inn net31 net31) pmos1 l=180n w=1u m=1
	mp001 (out net158 vdda vdda) pmos1 l=180n w=1u m=1
	mpd12 (net13 inp net31 net31) pmos1 l=180n w=1u m=1
	mpb01 (net158 net158 vdda vdda) pmos1 l=180n w=1u m=1
ends OPAMP1_variant114

subckt OPAMP1_variant115 inn inp out pd xpd vdda vssa
	xd1 (vssa vdda) prim_nwd AREA=6.13907e-9 PJ=476.6e-6 m=1
	xi0 (vssa net69) prim_nd AREA=1e-12 PJ=4e-6 m=1
	xi3 (net51 vdda) prim_pd AREA=790e-15 PJ=3.3e-6 m=1
	xr0 (vssa vdda net51) prim_rdiffp l=2.1e-6 w=700e-9 m=1
	xr1 (vdda vdda net69) prim_rdiffp l=2.3e-07 w=1.6e-06 m=1
	xcc01 (net12 out) prim_cpoly c=1p m=1
	mnm12 (net13 net56 vssa vssa) nmos1 l=1.5e-07n w=5.4e-07u m=1
	mnm11 (net56 net56 vssa vssa) nmos1 l=180n w=1u m=1
	mnb02 (net27 net27 net21 vssa) nmos1 l=180n w=1u m=1
	mnpd1 (net21 xpd vssa vssa) nmos1 l=180n w=1u m=1
	mn001 (out net13 vssa vssa) nmos1 l=180n w=1u m=1
	mnpd2 (net13 pd vssa vssa) nmos1 l=180n w=1u m=1
	mnc01 (net13 net69 net12 vssa) nmos1 l=180n w=1u m=1
	mpb02 (net27 net51 net158 vdda) pmos1 l=180n w=1u m=1
	mppd1 (net158 xpd vdda vdda) pmos1 l=180n w=1u m=1
	mps11 (net31 net158 vdda vdda) pmos1 l=180n w=1u m=1
	mpd11 (net56 inn net31 net31) pmos1 l=180n w=1u m=1
	mp001 (out net158 vdda vdda) pmos1 l=2.5e-07n w=2.0e-06u m=1
	mpd12 (net13 inp net31 net31) pmos1 l=180n w=1u m=1
	mpb01 (net158 net158 vdda vdda) pmos1 l=1.6e-07n w=1.4e-06u m=1
ends OPAMP1_variant115

subckt OPAMP1_variant116 inn inp out pd xpd vdda vssa
	xd1 (vssa vdda) prim_nwd AREA=6.13907e-9 PJ=476.6e-6 m=1
	xi0 (vssa net69) prim_nd AREA=1e-12 PJ=4e-6 m=1
	xi3 (net51 vdda) prim_pd AREA=790e-15 PJ=3.3e-6 m=1
	xr0 (vssa vdda net51) prim_rdiffp l=1.4e-07 w=1.9e-06 m=1
	xr1 (vdda vdda net69) prim_rdiffp l=2.1e-6 w=700e-9 m=1
	xcc01 (net12 out) prim_cpoly c=1p m=1
	mnm12 (net13 net56 vssa vssa) nmos1 l=180n w=1u m=1
	mnm11 (net56 net56 vssa vssa) nmos1 l=180n w=1u m=1
	mnb02 (net27 net27 net21 vssa) nmos1 l=180n w=1u m=1
	mnpd1 (net21 xpd vssa vssa) nmos1 l=180n w=1u m=1
	mn001 (out net13 vssa vssa) nmos1 l=180n w=1u m=1
	mnpd2 (net13 pd vssa vssa) nmos1 l=180n w=1u m=1
	mnc01 (net13 net69 net12 vssa) nmos1 l=180n w=1u m=1
	mpb02 (net27 net51 net158 vdda) pmos1 l=180n w=1u m=1
	mppd1 (net158 xpd vdda vdda) pmos1 l=180n w=1u m=1
	mps11 (net31 net158 vdda vdda) pmos1 l=180n w=1u m=1
	mpd11 (net56 inn net31 net31) pmos1 l=180n w=1u m=1
	mp001 (out net158 vdda vdda) pmos1 l=180n w=1u m=1
	mpd12 (net13 inp net31 net31) pmos1 l=2.1e-07n w=2.0e-06u m=1
	mpb01 (net158 net158 vdda vdda) pmos1 l=2.3e-07n w=1.7e-06u m=1
ends OPAMP1_variant116

subckt OPAMP1_variant117 inn inp out pd xpd vdda vssa
	xd1 (vssa vdda) prim_nwd AREA=6.13907e-9 PJ=476.6e-6 m=1
	xi0 (vssa net69) prim_nd AREA=1e-12 PJ=4e-6 m=1
	xi3 (net51 vdda) prim_pd AREA=790e-15 PJ=3.3e-6 m=1
	xr0 (vssa vdda net51) prim_rdiffp l=2.1e-6 w=700e-9 m=1
	xr1 (vdda vdda net69) prim_rdiffp l=1.3e-07 w=1.9e-06 m=1
	xcc01 (net12 out) prim_cpoly c=1p m=1
	mnm12 (net13 net56 vssa vssa) nmos1 l=180n w=1u m=1
	mnm11 (net56 net56 vssa vssa) nmos1 l=180n w=1u m=1
	mnb02 (net27 net27 net21 vssa) nmos1 l=2.7e-07n w=1.8e-06u m=1
	mnpd1 (net21 xpd vssa vssa) nmos1 l=180n w=1u m=1
	mn001 (out net13 vssa vssa) nmos1 l=180n w=1u m=1
	mnpd2 (net13 pd vssa vssa) nmos1 l=180n w=1u m=1
	mnc01 (net13 net69 net12 vssa) nmos1 l=180n w=1u m=1
	mpb02 (net27 net51 net158 vdda) pmos1 l=1.2e-07n w=2.0e-06u m=1
	mppd1 (net158 xpd vdda vdda) pmos1 l=180n w=1u m=1
	mps11 (net31 net158 vdda vdda) pmos1 l=180n w=1u m=1
	mpd11 (net56 inn net31 net31) pmos1 l=180n w=1u m=1
	mp001 (out net158 vdda vdda) pmos1 l=1.9e-07n w=6.3e-07u m=1
	mpd12 (net13 inp net31 net31) pmos1 l=180n w=1u m=1
	mpb01 (net158 net158 vdda vdda) pmos1 l=180n w=1u m=1
ends OPAMP1_variant117

subckt OPAMP1_variant118 inn inp out pd xpd vdda vssa
	xd1 (vssa vdda) prim_nwd AREA=6.13907e-9 PJ=476.6e-6 m=1
	xi0 (vssa net69) prim_nd AREA=1e-12 PJ=4e-6 m=1
	xi3 (net51 vdda) prim_pd AREA=790e-15 PJ=3.3e-6 m=1
	xr0 (vssa vdda net51) prim_rdiffp l=2.1e-6 w=700e-9 m=1
	xr1 (vdda vdda net69) prim_rdiffp l=2.1e-6 w=700e-9 m=1
	xcc01 (net12 out) prim_cpoly c=6.8e-13p m=1
	mnm12 (net13 net56 vssa vssa) nmos1 l=180n w=1u m=1
	mnm11 (net56 net56 vssa vssa) nmos1 l=2.3e-07n w=2.0e-06u m=1
	mnb02 (net27 net27 net21 vssa) nmos1 l=180n w=1u m=1
	mnpd1 (net21 xpd vssa vssa) nmos1 l=180n w=1u m=1
	mn001 (out net13 vssa vssa) nmos1 l=180n w=1u m=1
	mnpd2 (net13 pd vssa vssa) nmos1 l=180n w=1u m=1
	mnc01 (net13 net69 net12 vssa) nmos1 l=180n w=1u m=1
	mpb02 (net27 net51 net158 vdda) pmos1 l=180n w=1u m=1
	mppd1 (net158 xpd vdda vdda) pmos1 l=1.9e-07n w=1.2e-06u m=1
	mps11 (net31 net158 vdda vdda) pmos1 l=1.3e-07n w=1.4e-06u m=1
	mpd11 (net56 inn net31 net31) pmos1 l=180n w=1u m=1
	mp001 (out net158 vdda vdda) pmos1 l=180n w=1u m=1
	mpd12 (net13 inp net31 net31) pmos1 l=180n w=1u m=1
	mpb01 (net158 net158 vdda vdda) pmos1 l=180n w=1u m=1
ends OPAMP1_variant118

subckt OPAMP1_variant119 inn inp out pd xpd vdda vssa
	xd1 (vssa vdda) prim_nwd AREA=6.13907e-9 PJ=476.6e-6 m=1
	xi0 (vssa net69) prim_nd AREA=1e-12 PJ=4e-6 m=1
	xi3 (net51 vdda) prim_pd AREA=6.8e-09 PJ=8.3e-05 m=1
	xr0 (vssa vdda net51) prim_rdiffp l=2.1e-6 w=700e-9 m=1
	xr1 (vdda vdda net69) prim_rdiffp l=2.1e-6 w=700e-9 m=1
	xcc01 (net12 out) prim_cpoly c=1p m=1
	mnm12 (net13 net56 vssa vssa) nmos1 l=180n w=1u m=1
	mnm11 (net56 net56 vssa vssa) nmos1 l=180n w=1u m=1
	mnb02 (net27 net27 net21 vssa) nmos1 l=180n w=1u m=1
	mnpd1 (net21 xpd vssa vssa) nmos1 l=1.3e-07n w=7.2e-07u m=1
	mn001 (out net13 vssa vssa) nmos1 l=180n w=1u m=1
	mnpd2 (net13 pd vssa vssa) nmos1 l=180n w=1u m=1
	mnc01 (net13 net69 net12 vssa) nmos1 l=180n w=1u m=1
	mpb02 (net27 net51 net158 vdda) pmos1 l=180n w=1u m=1
	mppd1 (net158 xpd vdda vdda) pmos1 l=180n w=1u m=1
	mps11 (net31 net158 vdda vdda) pmos1 l=1.1e-07n w=1.0e-06u m=1
	mpd11 (net56 inn net31 net31) pmos1 l=180n w=1u m=1
	mp001 (out net158 vdda vdda) pmos1 l=180n w=1u m=1
	mpd12 (net13 inp net31 net31) pmos1 l=1.1e-07n w=1.8e-06u m=1
	mpb01 (net158 net158 vdda vdda) pmos1 l=180n w=1u m=1
ends OPAMP1_variant119

subckt OPAMP1_variant120 inn inp out pd xpd vdda vssa
	xd1 (vssa vdda) prim_nwd AREA=6.13907e-9 PJ=476.6e-6 m=1
	xi0 (vssa net69) prim_nd AREA=1e-12 PJ=4e-6 m=1
	xi3 (net51 vdda) prim_pd AREA=790e-15 PJ=3.3e-6 m=1
	xr0 (vssa vdda net51) prim_rdiffp l=2.1e-6 w=700e-9 m=1
	xr1 (vdda vdda net69) prim_rdiffp l=2.1e-6 w=700e-9 m=1
	xcc01 (net12 out) prim_cpoly c=1p m=1
	mnm12 (net13 net56 vssa vssa) nmos1 l=180n w=1u m=1
	mnm11 (net56 net56 vssa vssa) nmos1 l=180n w=1u m=1
	mnb02 (net27 net27 net21 vssa) nmos1 l=180n w=1u m=1
	mnpd1 (net21 xpd vssa vssa) nmos1 l=1.5e-07n w=1.3e-06u m=1
	mn001 (out net13 vssa vssa) nmos1 l=180n w=1u m=1
	mnpd2 (net13 pd vssa vssa) nmos1 l=180n w=1u m=1
	mnc01 (net13 net69 net12 vssa) nmos1 l=180n w=1u m=1
	mpb02 (net27 net51 net158 vdda) pmos1 l=180n w=1u m=1
	mppd1 (net158 xpd vdda vdda) pmos1 l=180n w=1u m=1
	mps11 (net31 net158 vdda vdda) pmos1 l=180n w=1u m=1
	mpd11 (net56 inn net31 net31) pmos1 l=180n w=1u m=1
	mp001 (out net158 vdda vdda) pmos1 l=1.3e-07n w=1.6e-06u m=1
	mpd12 (net13 inp net31 net31) pmos1 l=1.2e-07n w=2.0e-06u m=1
	mpb01 (net158 net158 vdda vdda) pmos1 l=180n w=1u m=1
ends OPAMP1_variant120

subckt OPAMP1_variant121 inn inp out pd xpd vdda vssa
	xd1 (vssa vdda) prim_nwd AREA=4.7e-09 PJ=2.7e-05 m=1
	xi0 (vssa net69) prim_nd AREA=1e-12 PJ=4e-6 m=1
	xi3 (net51 vdda) prim_pd AREA=790e-15 PJ=3.3e-6 m=1
	xr0 (vssa vdda net51) prim_rdiffp l=2.1e-6 w=700e-9 m=1
	xr1 (vdda vdda net69) prim_rdiffp l=2.1e-6 w=700e-9 m=1
	xcc01 (net12 out) prim_cpoly c=1p m=1
	mnm12 (net13 net56 vssa vssa) nmos1 l=180n w=1u m=1
	mnm11 (net56 net56 vssa vssa) nmos1 l=180n w=1u m=1
	mnb02 (net27 net27 net21 vssa) nmos1 l=180n w=1u m=1
	mnpd1 (net21 xpd vssa vssa) nmos1 l=180n w=1u m=1
	mn001 (out net13 vssa vssa) nmos1 l=180n w=1u m=1
	mnpd2 (net13 pd vssa vssa) nmos1 l=2.7e-07n w=1.0e-06u m=1
	mnc01 (net13 net69 net12 vssa) nmos1 l=180n w=1u m=1
	mpb02 (net27 net51 net158 vdda) pmos1 l=180n w=1u m=1
	mppd1 (net158 xpd vdda vdda) pmos1 l=180n w=1u m=1
	mps11 (net31 net158 vdda vdda) pmos1 l=1.2e-07n w=1.8e-06u m=1
	mpd11 (net56 inn net31 net31) pmos1 l=1.5e-07n w=8.2e-07u m=1
	mp001 (out net158 vdda vdda) pmos1 l=180n w=1u m=1
	mpd12 (net13 inp net31 net31) pmos1 l=1.4e-07n w=1.8e-06u m=1
	mpb01 (net158 net158 vdda vdda) pmos1 l=180n w=1u m=1
ends OPAMP1_variant121

subckt OPAMP1_variant122 inn inp out pd xpd vdda vssa
	xd1 (vssa vdda) prim_nwd AREA=6.13907e-9 PJ=476.6e-6 m=1
	xi0 (vssa net69) prim_nd AREA=1e-12 PJ=4e-6 m=1
	xi3 (net51 vdda) prim_pd AREA=790e-15 PJ=3.3e-6 m=1
	xr0 (vssa vdda net51) prim_rdiffp l=2.1e-6 w=700e-9 m=1
	xr1 (vdda vdda net69) prim_rdiffp l=2.9e-07 w=6.3e-07 m=1
	xcc01 (net12 out) prim_cpoly c=1p m=1
	mnm12 (net13 net56 vssa vssa) nmos1 l=180n w=1u m=1
	mnm11 (net56 net56 vssa vssa) nmos1 l=1.1e-07n w=1.7e-06u m=1
	mnb02 (net27 net27 net21 vssa) nmos1 l=180n w=1u m=1
	mnpd1 (net21 xpd vssa vssa) nmos1 l=2.9e-07n w=6.7e-07u m=1
	mn001 (out net13 vssa vssa) nmos1 l=180n w=1u m=1
	mnpd2 (net13 pd vssa vssa) nmos1 l=2.3e-07n w=7.9e-07u m=1
	mnc01 (net13 net69 net12 vssa) nmos1 l=180n w=1u m=1
	mpb02 (net27 net51 net158 vdda) pmos1 l=180n w=1u m=1
	mppd1 (net158 xpd vdda vdda) pmos1 l=2.2e-07n w=1.5e-06u m=1
	mps11 (net31 net158 vdda vdda) pmos1 l=180n w=1u m=1
	mpd11 (net56 inn net31 net31) pmos1 l=180n w=1u m=1
	mp001 (out net158 vdda vdda) pmos1 l=180n w=1u m=1
	mpd12 (net13 inp net31 net31) pmos1 l=180n w=1u m=1
	mpb01 (net158 net158 vdda vdda) pmos1 l=180n w=1u m=1
ends OPAMP1_variant122

subckt OPAMP1_variant123 inn inp out pd xpd vdda vssa
	xd1 (vssa vdda) prim_nwd AREA=6.13907e-9 PJ=476.6e-6 m=1
	xi0 (vssa net69) prim_nd AREA=1e-12 PJ=4e-6 m=1
	xi3 (net51 vdda) prim_pd AREA=790e-15 PJ=3.3e-6 m=1
	xr0 (vssa vdda net51) prim_rdiffp l=2.1e-6 w=700e-9 m=1
	xr1 (vdda vdda net69) prim_rdiffp l=2.1e-6 w=700e-9 m=1
	xcc01 (net12 out) prim_cpoly c=1p m=1
	mnm12 (net13 net56 vssa vssa) nmos1 l=180n w=1u m=1
	mnm11 (net56 net56 vssa vssa) nmos1 l=180n w=1u m=1
	mnb02 (net27 net27 net21 vssa) nmos1 l=180n w=1u m=1
	mnpd1 (net21 xpd vssa vssa) nmos1 l=180n w=1u m=1
	mn001 (out net13 vssa vssa) nmos1 l=180n w=1u m=1
	mnpd2 (net13 pd vssa vssa) nmos1 l=180n w=1u m=1
	mnc01 (net13 net69 net12 vssa) nmos1 l=180n w=1u m=1
	mpb02 (net27 net51 net158 vdda) pmos1 l=2.9e-07n w=1.9e-06u m=1
	mppd1 (net158 xpd vdda vdda) pmos1 l=180n w=1u m=1
	mps11 (net31 net158 vdda vdda) pmos1 l=1.2e-07n w=2.0e-06u m=1
	mpd11 (net56 inn net31 net31) pmos1 l=180n w=1u m=1
	mp001 (out net158 vdda vdda) pmos1 l=180n w=1u m=1
	mpd12 (net13 inp net31 net31) pmos1 l=180n w=1u m=1
	mpb01 (net158 net158 vdda vdda) pmos1 l=180n w=1u m=1
ends OPAMP1_variant123

subckt OPAMP1_variant124 inn inp out pd xpd vdda vssa
	xd1 (vssa vdda) prim_nwd AREA=9.7e-09 PJ=1.6e-06 m=1
	xi0 (vssa net69) prim_nd AREA=1e-12 PJ=4e-6 m=1
	xi3 (net51 vdda) prim_pd AREA=790e-15 PJ=3.3e-6 m=1
	xr0 (vssa vdda net51) prim_rdiffp l=1.1e-07 w=1.3e-06 m=1
	xr1 (vdda vdda net69) prim_rdiffp l=2.1e-6 w=700e-9 m=1
	xcc01 (net12 out) prim_cpoly c=1p m=1
	mnm12 (net13 net56 vssa vssa) nmos1 l=180n w=1u m=1
	mnm11 (net56 net56 vssa vssa) nmos1 l=180n w=1u m=1
	mnb02 (net27 net27 net21 vssa) nmos1 l=180n w=1u m=1
	mnpd1 (net21 xpd vssa vssa) nmos1 l=180n w=1u m=1
	mn001 (out net13 vssa vssa) nmos1 l=180n w=1u m=1
	mnpd2 (net13 pd vssa vssa) nmos1 l=180n w=1u m=1
	mnc01 (net13 net69 net12 vssa) nmos1 l=180n w=1u m=1
	mpb02 (net27 net51 net158 vdda) pmos1 l=180n w=1u m=1
	mppd1 (net158 xpd vdda vdda) pmos1 l=180n w=1u m=1
	mps11 (net31 net158 vdda vdda) pmos1 l=180n w=1u m=1
	mpd11 (net56 inn net31 net31) pmos1 l=180n w=1u m=1
	mp001 (out net158 vdda vdda) pmos1 l=180n w=1u m=1
	mpd12 (net13 inp net31 net31) pmos1 l=180n w=1u m=1
	mpb01 (net158 net158 vdda vdda) pmos1 l=180n w=1u m=1
ends OPAMP1_variant124

subckt OPAMP1_variant125 inn inp out pd xpd vdda vssa
	xd1 (vssa vdda) prim_nwd AREA=6.13907e-9 PJ=476.6e-6 m=1
	xi0 (vssa net69) prim_nd AREA=1e-12 PJ=4e-6 m=1
	xi3 (net51 vdda) prim_pd AREA=790e-15 PJ=3.3e-6 m=1
	xr0 (vssa vdda net51) prim_rdiffp l=2.1e-6 w=700e-9 m=1
	xr1 (vdda vdda net69) prim_rdiffp l=2.1e-6 w=700e-9 m=1
	xcc01 (net12 out) prim_cpoly c=1p m=1
	mnm12 (net13 net56 vssa vssa) nmos1 l=180n w=1u m=1
	mnm11 (net56 net56 vssa vssa) nmos1 l=180n w=1u m=1
	mnb02 (net27 net27 net21 vssa) nmos1 l=180n w=1u m=1
	mnpd1 (net21 xpd vssa vssa) nmos1 l=180n w=1u m=1
	mn001 (out net13 vssa vssa) nmos1 l=180n w=1u m=1
	mnpd2 (net13 pd vssa vssa) nmos1 l=180n w=1u m=1
	mnc01 (net13 net69 net12 vssa) nmos1 l=180n w=1u m=1
	mpb02 (net27 net51 net158 vdda) pmos1 l=180n w=1u m=1
	mppd1 (net158 xpd vdda vdda) pmos1 l=180n w=1u m=1
	mps11 (net31 net158 vdda vdda) pmos1 l=180n w=1u m=1
	mpd11 (net56 inn net31 net31) pmos1 l=180n w=1u m=1
	mp001 (out net158 vdda vdda) pmos1 l=180n w=1u m=1
	mpd12 (net13 inp net31 net31) pmos1 l=2.2e-07n w=7.2e-07u m=1
	mpb01 (net158 net158 vdda vdda) pmos1 l=2.3e-07n w=6.1e-07u m=1
ends OPAMP1_variant125

subckt OPAMP1_variant126 inn inp out pd xpd vdda vssa
	xd1 (vssa vdda) prim_nwd AREA=6.13907e-9 PJ=476.6e-6 m=1
	xi0 (vssa net69) prim_nd AREA=1e-12 PJ=4e-6 m=1
	xi3 (net51 vdda) prim_pd AREA=3.6e-10 PJ=6.1e-05 m=1
	xr0 (vssa vdda net51) prim_rdiffp l=2.1e-6 w=700e-9 m=1
	xr1 (vdda vdda net69) prim_rdiffp l=2.1e-6 w=700e-9 m=1
	xcc01 (net12 out) prim_cpoly c=1p m=1
	mnm12 (net13 net56 vssa vssa) nmos1 l=1.3e-07n w=1.5e-06u m=1
	mnm11 (net56 net56 vssa vssa) nmos1 l=180n w=1u m=1
	mnb02 (net27 net27 net21 vssa) nmos1 l=180n w=1u m=1
	mnpd1 (net21 xpd vssa vssa) nmos1 l=180n w=1u m=1
	mn001 (out net13 vssa vssa) nmos1 l=180n w=1u m=1
	mnpd2 (net13 pd vssa vssa) nmos1 l=1.2e-07n w=9.0e-07u m=1
	mnc01 (net13 net69 net12 vssa) nmos1 l=2.1e-07n w=1.3e-06u m=1
	mpb02 (net27 net51 net158 vdda) pmos1 l=180n w=1u m=1
	mppd1 (net158 xpd vdda vdda) pmos1 l=180n w=1u m=1
	mps11 (net31 net158 vdda vdda) pmos1 l=180n w=1u m=1
	mpd11 (net56 inn net31 net31) pmos1 l=180n w=1u m=1
	mp001 (out net158 vdda vdda) pmos1 l=2.4e-07n w=7.4e-07u m=1
	mpd12 (net13 inp net31 net31) pmos1 l=180n w=1u m=1
	mpb01 (net158 net158 vdda vdda) pmos1 l=180n w=1u m=1
ends OPAMP1_variant126

subckt OPAMP1_variant127 inn inp out pd xpd vdda vssa
	xd1 (vssa vdda) prim_nwd AREA=6.13907e-9 PJ=476.6e-6 m=1
	xi0 (vssa net69) prim_nd AREA=1e-12 PJ=4e-6 m=1
	xi3 (net51 vdda) prim_pd AREA=790e-15 PJ=3.3e-6 m=1
	xr0 (vssa vdda net51) prim_rdiffp l=2.1e-6 w=700e-9 m=1
	xr1 (vdda vdda net69) prim_rdiffp l=2.2e-07 w=6.4e-07 m=1
	xcc01 (net12 out) prim_cpoly c=1p m=1
	mnm12 (net13 net56 vssa vssa) nmos1 l=180n w=1u m=1
	mnm11 (net56 net56 vssa vssa) nmos1 l=180n w=1u m=1
	mnb02 (net27 net27 net21 vssa) nmos1 l=180n w=1u m=1
	mnpd1 (net21 xpd vssa vssa) nmos1 l=180n w=1u m=1
	mn001 (out net13 vssa vssa) nmos1 l=180n w=1u m=1
	mnpd2 (net13 pd vssa vssa) nmos1 l=180n w=1u m=1
	mnc01 (net13 net69 net12 vssa) nmos1 l=180n w=1u m=1
	mpb02 (net27 net51 net158 vdda) pmos1 l=180n w=1u m=1
	mppd1 (net158 xpd vdda vdda) pmos1 l=180n w=1u m=1
	mps11 (net31 net158 vdda vdda) pmos1 l=2.9e-07n w=1.2e-06u m=1
	mpd11 (net56 inn net31 net31) pmos1 l=180n w=1u m=1
	mp001 (out net158 vdda vdda) pmos1 l=2.2e-07n w=1.8e-06u m=1
	mpd12 (net13 inp net31 net31) pmos1 l=180n w=1u m=1
	mpb01 (net158 net158 vdda vdda) pmos1 l=180n w=1u m=1
ends OPAMP1_variant127

subckt OPAMP1_variant128 inn inp out pd xpd vdda vssa
	xd1 (vssa vdda) prim_nwd AREA=9.1e-09 PJ=4.5e-05 m=1
	xi0 (vssa net69) prim_nd AREA=1e-12 PJ=4e-6 m=1
	xi3 (net51 vdda) prim_pd AREA=790e-15 PJ=3.3e-6 m=1
	xr0 (vssa vdda net51) prim_rdiffp l=2.1e-6 w=700e-9 m=1
	xr1 (vdda vdda net69) prim_rdiffp l=2.1e-6 w=700e-9 m=1
	xcc01 (net12 out) prim_cpoly c=1p m=1
	mnm12 (net13 net56 vssa vssa) nmos1 l=180n w=1u m=1
	mnm11 (net56 net56 vssa vssa) nmos1 l=180n w=1u m=1
	mnb02 (net27 net27 net21 vssa) nmos1 l=2.8e-07n w=1.1e-06u m=1
	mnpd1 (net21 xpd vssa vssa) nmos1 l=180n w=1u m=1
	mn001 (out net13 vssa vssa) nmos1 l=180n w=1u m=1
	mnpd2 (net13 pd vssa vssa) nmos1 l=1.5e-07n w=1.2e-06u m=1
	mnc01 (net13 net69 net12 vssa) nmos1 l=180n w=1u m=1
	mpb02 (net27 net51 net158 vdda) pmos1 l=180n w=1u m=1
	mppd1 (net158 xpd vdda vdda) pmos1 l=180n w=1u m=1
	mps11 (net31 net158 vdda vdda) pmos1 l=1.7e-07n w=5.7e-07u m=1
	mpd11 (net56 inn net31 net31) pmos1 l=180n w=1u m=1
	mp001 (out net158 vdda vdda) pmos1 l=1.2e-07n w=6.2e-07u m=1
	mpd12 (net13 inp net31 net31) pmos1 l=180n w=1u m=1
	mpb01 (net158 net158 vdda vdda) pmos1 l=180n w=1u m=1
ends OPAMP1_variant128

subckt OPAMP1_variant129 inn inp out pd xpd vdda vssa
	xd1 (vssa vdda) prim_nwd AREA=1.9e-09 PJ=8.6e-06 m=1
	xi0 (vssa net69) prim_nd AREA=1.6e-09 PJ=4.3e-05 m=1
	xi3 (net51 vdda) prim_pd AREA=790e-15 PJ=3.3e-6 m=1
	xr0 (vssa vdda net51) prim_rdiffp l=2.1e-6 w=700e-9 m=1
	xr1 (vdda vdda net69) prim_rdiffp l=2.1e-6 w=700e-9 m=1
	xcc01 (net12 out) prim_cpoly c=1p m=1
	mnm12 (net13 net56 vssa vssa) nmos1 l=180n w=1u m=1
	mnm11 (net56 net56 vssa vssa) nmos1 l=180n w=1u m=1
	mnb02 (net27 net27 net21 vssa) nmos1 l=180n w=1u m=1
	mnpd1 (net21 xpd vssa vssa) nmos1 l=180n w=1u m=1
	mn001 (out net13 vssa vssa) nmos1 l=180n w=1u m=1
	mnpd2 (net13 pd vssa vssa) nmos1 l=180n w=1u m=1
	mnc01 (net13 net69 net12 vssa) nmos1 l=2.6e-07n w=1.4e-06u m=1
	mpb02 (net27 net51 net158 vdda) pmos1 l=180n w=1u m=1
	mppd1 (net158 xpd vdda vdda) pmos1 l=180n w=1u m=1
	mps11 (net31 net158 vdda vdda) pmos1 l=1.7e-07n w=1.9e-06u m=1
	mpd11 (net56 inn net31 net31) pmos1 l=1.3e-07n w=1.1e-06u m=1
	mp001 (out net158 vdda vdda) pmos1 l=180n w=1u m=1
	mpd12 (net13 inp net31 net31) pmos1 l=180n w=1u m=1
	mpb01 (net158 net158 vdda vdda) pmos1 l=180n w=1u m=1
ends OPAMP1_variant129

subckt OPAMP1_variant130 inn inp out pd xpd vdda vssa
	xd1 (vssa vdda) prim_nwd AREA=6.13907e-9 PJ=476.6e-6 m=1
	xi0 (vssa net69) prim_nd AREA=1e-12 PJ=4e-6 m=1
	xi3 (net51 vdda) prim_pd AREA=790e-15 PJ=3.3e-6 m=1
	xr0 (vssa vdda net51) prim_rdiffp l=1.9e-07 w=1.6e-06 m=1
	xr1 (vdda vdda net69) prim_rdiffp l=2.1e-6 w=700e-9 m=1
	xcc01 (net12 out) prim_cpoly c=1p m=1
	mnm12 (net13 net56 vssa vssa) nmos1 l=180n w=1u m=1
	mnm11 (net56 net56 vssa vssa) nmos1 l=180n w=1u m=1
	mnb02 (net27 net27 net21 vssa) nmos1 l=180n w=1u m=1
	mnpd1 (net21 xpd vssa vssa) nmos1 l=180n w=1u m=1
	mn001 (out net13 vssa vssa) nmos1 l=180n w=1u m=1
	mnpd2 (net13 pd vssa vssa) nmos1 l=180n w=1u m=1
	mnc01 (net13 net69 net12 vssa) nmos1 l=180n w=1u m=1
	mpb02 (net27 net51 net158 vdda) pmos1 l=2.9e-07n w=1.1e-06u m=1
	mppd1 (net158 xpd vdda vdda) pmos1 l=180n w=1u m=1
	mps11 (net31 net158 vdda vdda) pmos1 l=180n w=1u m=1
	mpd11 (net56 inn net31 net31) pmos1 l=180n w=1u m=1
	mp001 (out net158 vdda vdda) pmos1 l=180n w=1u m=1
	mpd12 (net13 inp net31 net31) pmos1 l=180n w=1u m=1
	mpb01 (net158 net158 vdda vdda) pmos1 l=180n w=1u m=1
ends OPAMP1_variant130

subckt OPAMP1_variant131 inn inp out pd xpd vdda vssa
	xd1 (vssa vdda) prim_nwd AREA=1.6e-09 PJ=3.9e-05 m=1
	xi0 (vssa net69) prim_nd AREA=1.3e-09 PJ=8.9e-05 m=1
	xi3 (net51 vdda) prim_pd AREA=790e-15 PJ=3.3e-6 m=1
	xr0 (vssa vdda net51) prim_rdiffp l=2.1e-6 w=700e-9 m=1
	xr1 (vdda vdda net69) prim_rdiffp l=2.1e-6 w=700e-9 m=1
	xcc01 (net12 out) prim_cpoly c=1p m=1
	mnm12 (net13 net56 vssa vssa) nmos1 l=180n w=1u m=1
	mnm11 (net56 net56 vssa vssa) nmos1 l=180n w=1u m=1
	mnb02 (net27 net27 net21 vssa) nmos1 l=2.9e-07n w=9.1e-07u m=1
	mnpd1 (net21 xpd vssa vssa) nmos1 l=180n w=1u m=1
	mn001 (out net13 vssa vssa) nmos1 l=180n w=1u m=1
	mnpd2 (net13 pd vssa vssa) nmos1 l=180n w=1u m=1
	mnc01 (net13 net69 net12 vssa) nmos1 l=180n w=1u m=1
	mpb02 (net27 net51 net158 vdda) pmos1 l=180n w=1u m=1
	mppd1 (net158 xpd vdda vdda) pmos1 l=180n w=1u m=1
	mps11 (net31 net158 vdda vdda) pmos1 l=180n w=1u m=1
	mpd11 (net56 inn net31 net31) pmos1 l=1.3e-07n w=1.6e-06u m=1
	mp001 (out net158 vdda vdda) pmos1 l=180n w=1u m=1
	mpd12 (net13 inp net31 net31) pmos1 l=180n w=1u m=1
	mpb01 (net158 net158 vdda vdda) pmos1 l=2.0e-07n w=1.7e-06u m=1
ends OPAMP1_variant131

subckt OPAMP1_variant132 inn inp out pd xpd vdda vssa
	xd1 (vssa vdda) prim_nwd AREA=6.13907e-9 PJ=476.6e-6 m=1
	xi0 (vssa net69) prim_nd AREA=1e-12 PJ=4e-6 m=1
	xi3 (net51 vdda) prim_pd AREA=790e-15 PJ=3.3e-6 m=1
	xr0 (vssa vdda net51) prim_rdiffp l=2.1e-6 w=700e-9 m=1
	xr1 (vdda vdda net69) prim_rdiffp l=1.8e-07 w=1.9e-06 m=1
	xcc01 (net12 out) prim_cpoly c=1.9e-12p m=1
	mnm12 (net13 net56 vssa vssa) nmos1 l=2.5e-07n w=1.7e-06u m=1
	mnm11 (net56 net56 vssa vssa) nmos1 l=180n w=1u m=1
	mnb02 (net27 net27 net21 vssa) nmos1 l=180n w=1u m=1
	mnpd1 (net21 xpd vssa vssa) nmos1 l=180n w=1u m=1
	mn001 (out net13 vssa vssa) nmos1 l=180n w=1u m=1
	mnpd2 (net13 pd vssa vssa) nmos1 l=180n w=1u m=1
	mnc01 (net13 net69 net12 vssa) nmos1 l=180n w=1u m=1
	mpb02 (net27 net51 net158 vdda) pmos1 l=180n w=1u m=1
	mppd1 (net158 xpd vdda vdda) pmos1 l=180n w=1u m=1
	mps11 (net31 net158 vdda vdda) pmos1 l=180n w=1u m=1
	mpd11 (net56 inn net31 net31) pmos1 l=180n w=1u m=1
	mp001 (out net158 vdda vdda) pmos1 l=180n w=1u m=1
	mpd12 (net13 inp net31 net31) pmos1 l=180n w=1u m=1
	mpb01 (net158 net158 vdda vdda) pmos1 l=180n w=1u m=1
ends OPAMP1_variant132

subckt OPAMP1_variant133 inn inp out pd xpd vdda vssa
	xd1 (vssa vdda) prim_nwd AREA=6.13907e-9 PJ=476.6e-6 m=1
	xi0 (vssa net69) prim_nd AREA=1e-12 PJ=4e-6 m=1
	xi3 (net51 vdda) prim_pd AREA=6.0e-10 PJ=6.2e-05 m=1
	xr0 (vssa vdda net51) prim_rdiffp l=2.1e-6 w=700e-9 m=1
	xr1 (vdda vdda net69) prim_rdiffp l=2.1e-6 w=700e-9 m=1
	xcc01 (net12 out) prim_cpoly c=5.4e-13p m=1
	mnm12 (net13 net56 vssa vssa) nmos1 l=180n w=1u m=1
	mnm11 (net56 net56 vssa vssa) nmos1 l=180n w=1u m=1
	mnb02 (net27 net27 net21 vssa) nmos1 l=180n w=1u m=1
	mnpd1 (net21 xpd vssa vssa) nmos1 l=180n w=1u m=1
	mn001 (out net13 vssa vssa) nmos1 l=1.9e-07n w=7.8e-07u m=1
	mnpd2 (net13 pd vssa vssa) nmos1 l=180n w=1u m=1
	mnc01 (net13 net69 net12 vssa) nmos1 l=180n w=1u m=1
	mpb02 (net27 net51 net158 vdda) pmos1 l=180n w=1u m=1
	mppd1 (net158 xpd vdda vdda) pmos1 l=1.2e-07n w=1.3e-06u m=1
	mps11 (net31 net158 vdda vdda) pmos1 l=2.3e-07n w=9.1e-07u m=1
	mpd11 (net56 inn net31 net31) pmos1 l=180n w=1u m=1
	mp001 (out net158 vdda vdda) pmos1 l=180n w=1u m=1
	mpd12 (net13 inp net31 net31) pmos1 l=180n w=1u m=1
	mpb01 (net158 net158 vdda vdda) pmos1 l=180n w=1u m=1
ends OPAMP1_variant133

subckt OPAMP1_variant134 inn inp out pd xpd vdda vssa
	xd1 (vssa vdda) prim_nwd AREA=6.13907e-9 PJ=476.6e-6 m=1
	xi0 (vssa net69) prim_nd AREA=1e-12 PJ=4e-6 m=1
	xi3 (net51 vdda) prim_pd AREA=790e-15 PJ=3.3e-6 m=1
	xr0 (vssa vdda net51) prim_rdiffp l=2.1e-6 w=700e-9 m=1
	xr1 (vdda vdda net69) prim_rdiffp l=2.1e-6 w=700e-9 m=1
	xcc01 (net12 out) prim_cpoly c=1p m=1
	mnm12 (net13 net56 vssa vssa) nmos1 l=180n w=1u m=1
	mnm11 (net56 net56 vssa vssa) nmos1 l=180n w=1u m=1
	mnb02 (net27 net27 net21 vssa) nmos1 l=2.8e-07n w=1.1e-06u m=1
	mnpd1 (net21 xpd vssa vssa) nmos1 l=180n w=1u m=1
	mn001 (out net13 vssa vssa) nmos1 l=180n w=1u m=1
	mnpd2 (net13 pd vssa vssa) nmos1 l=1.6e-07n w=1.2e-06u m=1
	mnc01 (net13 net69 net12 vssa) nmos1 l=180n w=1u m=1
	mpb02 (net27 net51 net158 vdda) pmos1 l=1.8e-07n w=8.3e-07u m=1
	mppd1 (net158 xpd vdda vdda) pmos1 l=180n w=1u m=1
	mps11 (net31 net158 vdda vdda) pmos1 l=2.2e-07n w=1.3e-06u m=1
	mpd11 (net56 inn net31 net31) pmos1 l=180n w=1u m=1
	mp001 (out net158 vdda vdda) pmos1 l=180n w=1u m=1
	mpd12 (net13 inp net31 net31) pmos1 l=180n w=1u m=1
	mpb01 (net158 net158 vdda vdda) pmos1 l=180n w=1u m=1
ends OPAMP1_variant134

subckt OPAMP1_variant135 inn inp out pd xpd vdda vssa
	xd1 (vssa vdda) prim_nwd AREA=6.13907e-9 PJ=476.6e-6 m=1
	xi0 (vssa net69) prim_nd AREA=1e-12 PJ=4e-6 m=1
	xi3 (net51 vdda) prim_pd AREA=790e-15 PJ=3.3e-6 m=1
	xr0 (vssa vdda net51) prim_rdiffp l=2.1e-6 w=700e-9 m=1
	xr1 (vdda vdda net69) prim_rdiffp l=1.7e-07 w=1.0e-06 m=1
	xcc01 (net12 out) prim_cpoly c=1p m=1
	mnm12 (net13 net56 vssa vssa) nmos1 l=180n w=1u m=1
	mnm11 (net56 net56 vssa vssa) nmos1 l=180n w=1u m=1
	mnb02 (net27 net27 net21 vssa) nmos1 l=180n w=1u m=1
	mnpd1 (net21 xpd vssa vssa) nmos1 l=180n w=1u m=1
	mn001 (out net13 vssa vssa) nmos1 l=1.8e-07n w=2.0e-06u m=1
	mnpd2 (net13 pd vssa vssa) nmos1 l=1.9e-07n w=1.1e-06u m=1
	mnc01 (net13 net69 net12 vssa) nmos1 l=2.4e-07n w=5.6e-07u m=1
	mpb02 (net27 net51 net158 vdda) pmos1 l=180n w=1u m=1
	mppd1 (net158 xpd vdda vdda) pmos1 l=180n w=1u m=1
	mps11 (net31 net158 vdda vdda) pmos1 l=1.6e-07n w=1.6e-06u m=1
	mpd11 (net56 inn net31 net31) pmos1 l=180n w=1u m=1
	mp001 (out net158 vdda vdda) pmos1 l=180n w=1u m=1
	mpd12 (net13 inp net31 net31) pmos1 l=180n w=1u m=1
	mpb01 (net158 net158 vdda vdda) pmos1 l=180n w=1u m=1
ends OPAMP1_variant135

subckt OPAMP1_variant136 inn inp out pd xpd vdda vssa
	xd1 (vssa vdda) prim_nwd AREA=6.13907e-9 PJ=476.6e-6 m=1
	xi0 (vssa net69) prim_nd AREA=1e-12 PJ=4e-6 m=1
	xi3 (net51 vdda) prim_pd AREA=790e-15 PJ=3.3e-6 m=1
	xr0 (vssa vdda net51) prim_rdiffp l=2.1e-6 w=700e-9 m=1
	xr1 (vdda vdda net69) prim_rdiffp l=2.1e-6 w=700e-9 m=1
	xcc01 (net12 out) prim_cpoly c=1.9e-12p m=1
	mnm12 (net13 net56 vssa vssa) nmos1 l=180n w=1u m=1
	mnm11 (net56 net56 vssa vssa) nmos1 l=180n w=1u m=1
	mnb02 (net27 net27 net21 vssa) nmos1 l=180n w=1u m=1
	mnpd1 (net21 xpd vssa vssa) nmos1 l=180n w=1u m=1
	mn001 (out net13 vssa vssa) nmos1 l=180n w=1u m=1
	mnpd2 (net13 pd vssa vssa) nmos1 l=180n w=1u m=1
	mnc01 (net13 net69 net12 vssa) nmos1 l=2.2e-07n w=2.0e-06u m=1
	mpb02 (net27 net51 net158 vdda) pmos1 l=180n w=1u m=1
	mppd1 (net158 xpd vdda vdda) pmos1 l=180n w=1u m=1
	mps11 (net31 net158 vdda vdda) pmos1 l=180n w=1u m=1
	mpd11 (net56 inn net31 net31) pmos1 l=180n w=1u m=1
	mp001 (out net158 vdda vdda) pmos1 l=180n w=1u m=1
	mpd12 (net13 inp net31 net31) pmos1 l=180n w=1u m=1
	mpb01 (net158 net158 vdda vdda) pmos1 l=180n w=1u m=1
ends OPAMP1_variant136

subckt OPAMP1_variant137 inn inp out pd xpd vdda vssa
	xd1 (vssa vdda) prim_nwd AREA=6.13907e-9 PJ=476.6e-6 m=1
	xi0 (vssa net69) prim_nd AREA=1e-12 PJ=4e-6 m=1
	xi3 (net51 vdda) prim_pd AREA=790e-15 PJ=3.3e-6 m=1
	xr0 (vssa vdda net51) prim_rdiffp l=1.9e-07 w=1.9e-06 m=1
	xr1 (vdda vdda net69) prim_rdiffp l=2.6e-07 w=2.0e-06 m=1
	xcc01 (net12 out) prim_cpoly c=1p m=1
	mnm12 (net13 net56 vssa vssa) nmos1 l=180n w=1u m=1
	mnm11 (net56 net56 vssa vssa) nmos1 l=180n w=1u m=1
	mnb02 (net27 net27 net21 vssa) nmos1 l=180n w=1u m=1
	mnpd1 (net21 xpd vssa vssa) nmos1 l=180n w=1u m=1
	mn001 (out net13 vssa vssa) nmos1 l=180n w=1u m=1
	mnpd2 (net13 pd vssa vssa) nmos1 l=180n w=1u m=1
	mnc01 (net13 net69 net12 vssa) nmos1 l=180n w=1u m=1
	mpb02 (net27 net51 net158 vdda) pmos1 l=180n w=1u m=1
	mppd1 (net158 xpd vdda vdda) pmos1 l=180n w=1u m=1
	mps11 (net31 net158 vdda vdda) pmos1 l=180n w=1u m=1
	mpd11 (net56 inn net31 net31) pmos1 l=180n w=1u m=1
	mp001 (out net158 vdda vdda) pmos1 l=180n w=1u m=1
	mpd12 (net13 inp net31 net31) pmos1 l=2.2e-07n w=1.1e-06u m=1
	mpb01 (net158 net158 vdda vdda) pmos1 l=180n w=1u m=1
ends OPAMP1_variant137

subckt OPAMP1_variant138 inn inp out pd xpd vdda vssa
	xd1 (vssa vdda) prim_nwd AREA=6.13907e-9 PJ=476.6e-6 m=1
	xi0 (vssa net69) prim_nd AREA=1e-12 PJ=4e-6 m=1
	xi3 (net51 vdda) prim_pd AREA=1.7e-09 PJ=4.5e-05 m=1
	xr0 (vssa vdda net51) prim_rdiffp l=2.1e-6 w=700e-9 m=1
	xr1 (vdda vdda net69) prim_rdiffp l=2.1e-6 w=700e-9 m=1
	xcc01 (net12 out) prim_cpoly c=1p m=1
	mnm12 (net13 net56 vssa vssa) nmos1 l=180n w=1u m=1
	mnm11 (net56 net56 vssa vssa) nmos1 l=180n w=1u m=1
	mnb02 (net27 net27 net21 vssa) nmos1 l=180n w=1u m=1
	mnpd1 (net21 xpd vssa vssa) nmos1 l=180n w=1u m=1
	mn001 (out net13 vssa vssa) nmos1 l=180n w=1u m=1
	mnpd2 (net13 pd vssa vssa) nmos1 l=180n w=1u m=1
	mnc01 (net13 net69 net12 vssa) nmos1 l=180n w=1u m=1
	mpb02 (net27 net51 net158 vdda) pmos1 l=180n w=1u m=1
	mppd1 (net158 xpd vdda vdda) pmos1 l=1.0e-07n w=8.8e-07u m=1
	mps11 (net31 net158 vdda vdda) pmos1 l=180n w=1u m=1
	mpd11 (net56 inn net31 net31) pmos1 l=180n w=1u m=1
	mp001 (out net158 vdda vdda) pmos1 l=180n w=1u m=1
	mpd12 (net13 inp net31 net31) pmos1 l=180n w=1u m=1
	mpb01 (net158 net158 vdda vdda) pmos1 l=2.5e-07n w=1.6e-06u m=1
ends OPAMP1_variant138

subckt OPAMP1_variant139 inn inp out pd xpd vdda vssa
	xd1 (vssa vdda) prim_nwd AREA=9.9e-09 PJ=3.7e-05 m=1
	xi0 (vssa net69) prim_nd AREA=1e-12 PJ=4e-6 m=1
	xi3 (net51 vdda) prim_pd AREA=8.5e-09 PJ=2.1e-05 m=1
	xr0 (vssa vdda net51) prim_rdiffp l=2.1e-6 w=700e-9 m=1
	xr1 (vdda vdda net69) prim_rdiffp l=2.1e-6 w=700e-9 m=1
	xcc01 (net12 out) prim_cpoly c=1p m=1
	mnm12 (net13 net56 vssa vssa) nmos1 l=180n w=1u m=1
	mnm11 (net56 net56 vssa vssa) nmos1 l=180n w=1u m=1
	mnb02 (net27 net27 net21 vssa) nmos1 l=180n w=1u m=1
	mnpd1 (net21 xpd vssa vssa) nmos1 l=180n w=1u m=1
	mn001 (out net13 vssa vssa) nmos1 l=180n w=1u m=1
	mnpd2 (net13 pd vssa vssa) nmos1 l=180n w=1u m=1
	mnc01 (net13 net69 net12 vssa) nmos1 l=180n w=1u m=1
	mpb02 (net27 net51 net158 vdda) pmos1 l=180n w=1u m=1
	mppd1 (net158 xpd vdda vdda) pmos1 l=2.8e-07n w=1.6e-06u m=1
	mps11 (net31 net158 vdda vdda) pmos1 l=180n w=1u m=1
	mpd11 (net56 inn net31 net31) pmos1 l=180n w=1u m=1
	mp001 (out net158 vdda vdda) pmos1 l=180n w=1u m=1
	mpd12 (net13 inp net31 net31) pmos1 l=180n w=1u m=1
	mpb01 (net158 net158 vdda vdda) pmos1 l=2.9e-07n w=1.4e-06u m=1
ends OPAMP1_variant139

subckt OPAMP1_variant140 inn inp out pd xpd vdda vssa
	xd1 (vssa vdda) prim_nwd AREA=6.13907e-9 PJ=476.6e-6 m=1
	xi0 (vssa net69) prim_nd AREA=1e-12 PJ=4e-6 m=1
	xi3 (net51 vdda) prim_pd AREA=790e-15 PJ=3.3e-6 m=1
	xr0 (vssa vdda net51) prim_rdiffp l=2.1e-6 w=700e-9 m=1
	xr1 (vdda vdda net69) prim_rdiffp l=2.1e-6 w=700e-9 m=1
	xcc01 (net12 out) prim_cpoly c=1p m=1
	mnm12 (net13 net56 vssa vssa) nmos1 l=180n w=1u m=1
	mnm11 (net56 net56 vssa vssa) nmos1 l=2.6e-07n w=1.6e-06u m=1
	mnb02 (net27 net27 net21 vssa) nmos1 l=180n w=1u m=1
	mnpd1 (net21 xpd vssa vssa) nmos1 l=180n w=1u m=1
	mn001 (out net13 vssa vssa) nmos1 l=180n w=1u m=1
	mnpd2 (net13 pd vssa vssa) nmos1 l=180n w=1u m=1
	mnc01 (net13 net69 net12 vssa) nmos1 l=1.7e-07n w=1.1e-06u m=1
	mpb02 (net27 net51 net158 vdda) pmos1 l=180n w=1u m=1
	mppd1 (net158 xpd vdda vdda) pmos1 l=180n w=1u m=1
	mps11 (net31 net158 vdda vdda) pmos1 l=180n w=1u m=1
	mpd11 (net56 inn net31 net31) pmos1 l=180n w=1u m=1
	mp001 (out net158 vdda vdda) pmos1 l=2.7e-07n w=1.6e-06u m=1
	mpd12 (net13 inp net31 net31) pmos1 l=1.7e-07n w=5.9e-07u m=1
	mpb01 (net158 net158 vdda vdda) pmos1 l=180n w=1u m=1
ends OPAMP1_variant140

subckt OPAMP1_variant141 inn inp out pd xpd vdda vssa
	xd1 (vssa vdda) prim_nwd AREA=6.13907e-9 PJ=476.6e-6 m=1
	xi0 (vssa net69) prim_nd AREA=3.3e-09 PJ=2.2e-05 m=1
	xi3 (net51 vdda) prim_pd AREA=790e-15 PJ=3.3e-6 m=1
	xr0 (vssa vdda net51) prim_rdiffp l=2.7e-07 w=9.4e-07 m=1
	xr1 (vdda vdda net69) prim_rdiffp l=2.1e-6 w=700e-9 m=1
	xcc01 (net12 out) prim_cpoly c=1p m=1
	mnm12 (net13 net56 vssa vssa) nmos1 l=180n w=1u m=1
	mnm11 (net56 net56 vssa vssa) nmos1 l=180n w=1u m=1
	mnb02 (net27 net27 net21 vssa) nmos1 l=180n w=1u m=1
	mnpd1 (net21 xpd vssa vssa) nmos1 l=180n w=1u m=1
	mn001 (out net13 vssa vssa) nmos1 l=180n w=1u m=1
	mnpd2 (net13 pd vssa vssa) nmos1 l=180n w=1u m=1
	mnc01 (net13 net69 net12 vssa) nmos1 l=180n w=1u m=1
	mpb02 (net27 net51 net158 vdda) pmos1 l=180n w=1u m=1
	mppd1 (net158 xpd vdda vdda) pmos1 l=180n w=1u m=1
	mps11 (net31 net158 vdda vdda) pmos1 l=2.0e-07n w=8.0e-07u m=1
	mpd11 (net56 inn net31 net31) pmos1 l=180n w=1u m=1
	mp001 (out net158 vdda vdda) pmos1 l=180n w=1u m=1
	mpd12 (net13 inp net31 net31) pmos1 l=180n w=1u m=1
	mpb01 (net158 net158 vdda vdda) pmos1 l=180n w=1u m=1
ends OPAMP1_variant141

subckt OPAMP1_variant142 inn inp out pd xpd vdda vssa
	xd1 (vssa vdda) prim_nwd AREA=6.13907e-9 PJ=476.6e-6 m=1
	xi0 (vssa net69) prim_nd AREA=1e-12 PJ=4e-6 m=1
	xi3 (net51 vdda) prim_pd AREA=790e-15 PJ=3.3e-6 m=1
	xr0 (vssa vdda net51) prim_rdiffp l=2.1e-6 w=700e-9 m=1
	xr1 (vdda vdda net69) prim_rdiffp l=2.1e-6 w=700e-9 m=1
	xcc01 (net12 out) prim_cpoly c=1p m=1
	mnm12 (net13 net56 vssa vssa) nmos1 l=180n w=1u m=1
	mnm11 (net56 net56 vssa vssa) nmos1 l=1.8e-07n w=1.1e-06u m=1
	mnb02 (net27 net27 net21 vssa) nmos1 l=180n w=1u m=1
	mnpd1 (net21 xpd vssa vssa) nmos1 l=180n w=1u m=1
	mn001 (out net13 vssa vssa) nmos1 l=180n w=1u m=1
	mnpd2 (net13 pd vssa vssa) nmos1 l=180n w=1u m=1
	mnc01 (net13 net69 net12 vssa) nmos1 l=2.5e-07n w=1.3e-06u m=1
	mpb02 (net27 net51 net158 vdda) pmos1 l=1.7e-07n w=1.9e-06u m=1
	mppd1 (net158 xpd vdda vdda) pmos1 l=1.0e-07n w=7.6e-07u m=1
	mps11 (net31 net158 vdda vdda) pmos1 l=180n w=1u m=1
	mpd11 (net56 inn net31 net31) pmos1 l=180n w=1u m=1
	mp001 (out net158 vdda vdda) pmos1 l=180n w=1u m=1
	mpd12 (net13 inp net31 net31) pmos1 l=180n w=1u m=1
	mpb01 (net158 net158 vdda vdda) pmos1 l=180n w=1u m=1
ends OPAMP1_variant142

subckt OPAMP1_variant143 inn inp out pd xpd vdda vssa
	xd1 (vssa vdda) prim_nwd AREA=5.3e-11 PJ=9.5e-05 m=1
	xi0 (vssa net69) prim_nd AREA=1e-12 PJ=4e-6 m=1
	xi3 (net51 vdda) prim_pd AREA=790e-15 PJ=3.3e-6 m=1
	xr0 (vssa vdda net51) prim_rdiffp l=2.3e-07 w=1.9e-06 m=1
	xr1 (vdda vdda net69) prim_rdiffp l=2.1e-6 w=700e-9 m=1
	xcc01 (net12 out) prim_cpoly c=1.7e-12p m=1
	mnm12 (net13 net56 vssa vssa) nmos1 l=180n w=1u m=1
	mnm11 (net56 net56 vssa vssa) nmos1 l=180n w=1u m=1
	mnb02 (net27 net27 net21 vssa) nmos1 l=1.4e-07n w=1.3e-06u m=1
	mnpd1 (net21 xpd vssa vssa) nmos1 l=180n w=1u m=1
	mn001 (out net13 vssa vssa) nmos1 l=180n w=1u m=1
	mnpd2 (net13 pd vssa vssa) nmos1 l=180n w=1u m=1
	mnc01 (net13 net69 net12 vssa) nmos1 l=180n w=1u m=1
	mpb02 (net27 net51 net158 vdda) pmos1 l=180n w=1u m=1
	mppd1 (net158 xpd vdda vdda) pmos1 l=2.3e-07n w=1.3e-06u m=1
	mps11 (net31 net158 vdda vdda) pmos1 l=180n w=1u m=1
	mpd11 (net56 inn net31 net31) pmos1 l=180n w=1u m=1
	mp001 (out net158 vdda vdda) pmos1 l=180n w=1u m=1
	mpd12 (net13 inp net31 net31) pmos1 l=180n w=1u m=1
	mpb01 (net158 net158 vdda vdda) pmos1 l=180n w=1u m=1
ends OPAMP1_variant143

subckt OPAMP1_variant144 inn inp out pd xpd vdda vssa
	xd1 (vssa vdda) prim_nwd AREA=6.13907e-9 PJ=476.6e-6 m=1
	xi0 (vssa net69) prim_nd AREA=1e-12 PJ=4e-6 m=1
	xi3 (net51 vdda) prim_pd AREA=790e-15 PJ=3.3e-6 m=1
	xr0 (vssa vdda net51) prim_rdiffp l=2.1e-6 w=700e-9 m=1
	xr1 (vdda vdda net69) prim_rdiffp l=2.1e-6 w=700e-9 m=1
	xcc01 (net12 out) prim_cpoly c=1p m=1
	mnm12 (net13 net56 vssa vssa) nmos1 l=180n w=1u m=1
	mnm11 (net56 net56 vssa vssa) nmos1 l=180n w=1u m=1
	mnb02 (net27 net27 net21 vssa) nmos1 l=180n w=1u m=1
	mnpd1 (net21 xpd vssa vssa) nmos1 l=1.4e-07n w=7.8e-07u m=1
	mn001 (out net13 vssa vssa) nmos1 l=180n w=1u m=1
	mnpd2 (net13 pd vssa vssa) nmos1 l=180n w=1u m=1
	mnc01 (net13 net69 net12 vssa) nmos1 l=180n w=1u m=1
	mpb02 (net27 net51 net158 vdda) pmos1 l=1.7e-07n w=1.5e-06u m=1
	mppd1 (net158 xpd vdda vdda) pmos1 l=1.5e-07n w=1.1e-06u m=1
	mps11 (net31 net158 vdda vdda) pmos1 l=180n w=1u m=1
	mpd11 (net56 inn net31 net31) pmos1 l=180n w=1u m=1
	mp001 (out net158 vdda vdda) pmos1 l=180n w=1u m=1
	mpd12 (net13 inp net31 net31) pmos1 l=1.2e-07n w=1.8e-06u m=1
	mpb01 (net158 net158 vdda vdda) pmos1 l=180n w=1u m=1
ends OPAMP1_variant144

subckt OPAMP1_variant145 inn inp out pd xpd vdda vssa
	xd1 (vssa vdda) prim_nwd AREA=6.13907e-9 PJ=476.6e-6 m=1
	xi0 (vssa net69) prim_nd AREA=1e-12 PJ=4e-6 m=1
	xi3 (net51 vdda) prim_pd AREA=1.9e-09 PJ=4.7e-05 m=1
	xr0 (vssa vdda net51) prim_rdiffp l=2.1e-6 w=700e-9 m=1
	xr1 (vdda vdda net69) prim_rdiffp l=2.1e-6 w=700e-9 m=1
	xcc01 (net12 out) prim_cpoly c=1.1e-12p m=1
	mnm12 (net13 net56 vssa vssa) nmos1 l=1.8e-07n w=9.8e-07u m=1
	mnm11 (net56 net56 vssa vssa) nmos1 l=180n w=1u m=1
	mnb02 (net27 net27 net21 vssa) nmos1 l=180n w=1u m=1
	mnpd1 (net21 xpd vssa vssa) nmos1 l=1.3e-07n w=1.1e-06u m=1
	mn001 (out net13 vssa vssa) nmos1 l=180n w=1u m=1
	mnpd2 (net13 pd vssa vssa) nmos1 l=180n w=1u m=1
	mnc01 (net13 net69 net12 vssa) nmos1 l=180n w=1u m=1
	mpb02 (net27 net51 net158 vdda) pmos1 l=180n w=1u m=1
	mppd1 (net158 xpd vdda vdda) pmos1 l=180n w=1u m=1
	mps11 (net31 net158 vdda vdda) pmos1 l=180n w=1u m=1
	mpd11 (net56 inn net31 net31) pmos1 l=180n w=1u m=1
	mp001 (out net158 vdda vdda) pmos1 l=180n w=1u m=1
	mpd12 (net13 inp net31 net31) pmos1 l=180n w=1u m=1
	mpb01 (net158 net158 vdda vdda) pmos1 l=180n w=1u m=1
ends OPAMP1_variant145

subckt OPAMP1_variant146 inn inp out pd xpd vdda vssa
	xd1 (vssa vdda) prim_nwd AREA=6.13907e-9 PJ=476.6e-6 m=1
	xi0 (vssa net69) prim_nd AREA=1e-12 PJ=4e-6 m=1
	xi3 (net51 vdda) prim_pd AREA=790e-15 PJ=3.3e-6 m=1
	xr0 (vssa vdda net51) prim_rdiffp l=2.1e-6 w=700e-9 m=1
	xr1 (vdda vdda net69) prim_rdiffp l=2.1e-6 w=700e-9 m=1
	xcc01 (net12 out) prim_cpoly c=1p m=1
	mnm12 (net13 net56 vssa vssa) nmos1 l=180n w=1u m=1
	mnm11 (net56 net56 vssa vssa) nmos1 l=180n w=1u m=1
	mnb02 (net27 net27 net21 vssa) nmos1 l=180n w=1u m=1
	mnpd1 (net21 xpd vssa vssa) nmos1 l=2.3e-07n w=8.6e-07u m=1
	mn001 (out net13 vssa vssa) nmos1 l=180n w=1u m=1
	mnpd2 (net13 pd vssa vssa) nmos1 l=180n w=1u m=1
	mnc01 (net13 net69 net12 vssa) nmos1 l=180n w=1u m=1
	mpb02 (net27 net51 net158 vdda) pmos1 l=180n w=1u m=1
	mppd1 (net158 xpd vdda vdda) pmos1 l=180n w=1u m=1
	mps11 (net31 net158 vdda vdda) pmos1 l=2.1e-07n w=6.7e-07u m=1
	mpd11 (net56 inn net31 net31) pmos1 l=180n w=1u m=1
	mp001 (out net158 vdda vdda) pmos1 l=180n w=1u m=1
	mpd12 (net13 inp net31 net31) pmos1 l=2.0e-07n w=1.9e-06u m=1
	mpb01 (net158 net158 vdda vdda) pmos1 l=180n w=1u m=1
ends OPAMP1_variant146

subckt OPAMP1_variant147 inn inp out pd xpd vdda vssa
	xd1 (vssa vdda) prim_nwd AREA=7.0e-09 PJ=2.5e-05 m=1
	xi0 (vssa net69) prim_nd AREA=1e-12 PJ=4e-6 m=1
	xi3 (net51 vdda) prim_pd AREA=790e-15 PJ=3.3e-6 m=1
	xr0 (vssa vdda net51) prim_rdiffp l=2.1e-6 w=700e-9 m=1
	xr1 (vdda vdda net69) prim_rdiffp l=2.5e-07 w=6.2e-07 m=1
	xcc01 (net12 out) prim_cpoly c=1p m=1
	mnm12 (net13 net56 vssa vssa) nmos1 l=180n w=1u m=1
	mnm11 (net56 net56 vssa vssa) nmos1 l=180n w=1u m=1
	mnb02 (net27 net27 net21 vssa) nmos1 l=1.9e-07n w=1.2e-06u m=1
	mnpd1 (net21 xpd vssa vssa) nmos1 l=1.2e-07n w=1.7e-06u m=1
	mn001 (out net13 vssa vssa) nmos1 l=180n w=1u m=1
	mnpd2 (net13 pd vssa vssa) nmos1 l=180n w=1u m=1
	mnc01 (net13 net69 net12 vssa) nmos1 l=180n w=1u m=1
	mpb02 (net27 net51 net158 vdda) pmos1 l=180n w=1u m=1
	mppd1 (net158 xpd vdda vdda) pmos1 l=180n w=1u m=1
	mps11 (net31 net158 vdda vdda) pmos1 l=180n w=1u m=1
	mpd11 (net56 inn net31 net31) pmos1 l=180n w=1u m=1
	mp001 (out net158 vdda vdda) pmos1 l=180n w=1u m=1
	mpd12 (net13 inp net31 net31) pmos1 l=180n w=1u m=1
	mpb01 (net158 net158 vdda vdda) pmos1 l=1.1e-07n w=1.7e-06u m=1
ends OPAMP1_variant147

subckt OPAMP1_variant148 inn inp out pd xpd vdda vssa
	xd1 (vssa vdda) prim_nwd AREA=3.6e-09 PJ=7.6e-05 m=1
	xi0 (vssa net69) prim_nd AREA=1e-12 PJ=4e-6 m=1
	xi3 (net51 vdda) prim_pd AREA=790e-15 PJ=3.3e-6 m=1
	xr0 (vssa vdda net51) prim_rdiffp l=2.1e-6 w=700e-9 m=1
	xr1 (vdda vdda net69) prim_rdiffp l=2.1e-6 w=700e-9 m=1
	xcc01 (net12 out) prim_cpoly c=1p m=1
	mnm12 (net13 net56 vssa vssa) nmos1 l=180n w=1u m=1
	mnm11 (net56 net56 vssa vssa) nmos1 l=180n w=1u m=1
	mnb02 (net27 net27 net21 vssa) nmos1 l=180n w=1u m=1
	mnpd1 (net21 xpd vssa vssa) nmos1 l=180n w=1u m=1
	mn001 (out net13 vssa vssa) nmos1 l=180n w=1u m=1
	mnpd2 (net13 pd vssa vssa) nmos1 l=180n w=1u m=1
	mnc01 (net13 net69 net12 vssa) nmos1 l=180n w=1u m=1
	mpb02 (net27 net51 net158 vdda) pmos1 l=180n w=1u m=1
	mppd1 (net158 xpd vdda vdda) pmos1 l=180n w=1u m=1
	mps11 (net31 net158 vdda vdda) pmos1 l=180n w=1u m=1
	mpd11 (net56 inn net31 net31) pmos1 l=180n w=1u m=1
	mp001 (out net158 vdda vdda) pmos1 l=180n w=1u m=1
	mpd12 (net13 inp net31 net31) pmos1 l=1.8e-07n w=9.1e-07u m=1
	mpb01 (net158 net158 vdda vdda) pmos1 l=180n w=1u m=1
ends OPAMP1_variant148

subckt OPAMP1_variant149 inn inp out pd xpd vdda vssa
	xd1 (vssa vdda) prim_nwd AREA=6.13907e-9 PJ=476.6e-6 m=1
	xi0 (vssa net69) prim_nd AREA=1.5e-09 PJ=2.9e-05 m=1
	xi3 (net51 vdda) prim_pd AREA=7.1e-09 PJ=9.1e-05 m=1
	xr0 (vssa vdda net51) prim_rdiffp l=2.1e-07 w=9.2e-07 m=1
	xr1 (vdda vdda net69) prim_rdiffp l=2.1e-6 w=700e-9 m=1
	xcc01 (net12 out) prim_cpoly c=1.0e-12p m=1
	mnm12 (net13 net56 vssa vssa) nmos1 l=180n w=1u m=1
	mnm11 (net56 net56 vssa vssa) nmos1 l=180n w=1u m=1
	mnb02 (net27 net27 net21 vssa) nmos1 l=180n w=1u m=1
	mnpd1 (net21 xpd vssa vssa) nmos1 l=180n w=1u m=1
	mn001 (out net13 vssa vssa) nmos1 l=180n w=1u m=1
	mnpd2 (net13 pd vssa vssa) nmos1 l=180n w=1u m=1
	mnc01 (net13 net69 net12 vssa) nmos1 l=180n w=1u m=1
	mpb02 (net27 net51 net158 vdda) pmos1 l=180n w=1u m=1
	mppd1 (net158 xpd vdda vdda) pmos1 l=180n w=1u m=1
	mps11 (net31 net158 vdda vdda) pmos1 l=180n w=1u m=1
	mpd11 (net56 inn net31 net31) pmos1 l=180n w=1u m=1
	mp001 (out net158 vdda vdda) pmos1 l=180n w=1u m=1
	mpd12 (net13 inp net31 net31) pmos1 l=180n w=1u m=1
	mpb01 (net158 net158 vdda vdda) pmos1 l=180n w=1u m=1
ends OPAMP1_variant149

subckt OPAMP1_variant150 inn inp out pd xpd vdda vssa
	xd1 (vssa vdda) prim_nwd AREA=6.13907e-9 PJ=476.6e-6 m=1
	xi0 (vssa net69) prim_nd AREA=1e-12 PJ=4e-6 m=1
	xi3 (net51 vdda) prim_pd AREA=8.7e-09 PJ=5.7e-05 m=1
	xr0 (vssa vdda net51) prim_rdiffp l=1.7e-07 w=5.1e-07 m=1
	xr1 (vdda vdda net69) prim_rdiffp l=2.1e-6 w=700e-9 m=1
	xcc01 (net12 out) prim_cpoly c=1p m=1
	mnm12 (net13 net56 vssa vssa) nmos1 l=180n w=1u m=1
	mnm11 (net56 net56 vssa vssa) nmos1 l=180n w=1u m=1
	mnb02 (net27 net27 net21 vssa) nmos1 l=180n w=1u m=1
	mnpd1 (net21 xpd vssa vssa) nmos1 l=180n w=1u m=1
	mn001 (out net13 vssa vssa) nmos1 l=180n w=1u m=1
	mnpd2 (net13 pd vssa vssa) nmos1 l=180n w=1u m=1
	mnc01 (net13 net69 net12 vssa) nmos1 l=180n w=1u m=1
	mpb02 (net27 net51 net158 vdda) pmos1 l=2.7e-07n w=1.8e-06u m=1
	mppd1 (net158 xpd vdda vdda) pmos1 l=1.3e-07n w=1.3e-06u m=1
	mps11 (net31 net158 vdda vdda) pmos1 l=180n w=1u m=1
	mpd11 (net56 inn net31 net31) pmos1 l=180n w=1u m=1
	mp001 (out net158 vdda vdda) pmos1 l=180n w=1u m=1
	mpd12 (net13 inp net31 net31) pmos1 l=180n w=1u m=1
	mpb01 (net158 net158 vdda vdda) pmos1 l=180n w=1u m=1
ends OPAMP1_variant150

subckt OPAMP1_variant151 inn inp out pd xpd vdda vssa
	xd1 (vssa vdda) prim_nwd AREA=4.6e-09 PJ=4.1e-05 m=1
	xi0 (vssa net69) prim_nd AREA=1e-12 PJ=4e-6 m=1
	xi3 (net51 vdda) prim_pd AREA=7.0e-09 PJ=4.4e-05 m=1
	xr0 (vssa vdda net51) prim_rdiffp l=2.1e-6 w=700e-9 m=1
	xr1 (vdda vdda net69) prim_rdiffp l=2.1e-6 w=700e-9 m=1
	xcc01 (net12 out) prim_cpoly c=1p m=1
	mnm12 (net13 net56 vssa vssa) nmos1 l=2.9e-07n w=1.3e-06u m=1
	mnm11 (net56 net56 vssa vssa) nmos1 l=180n w=1u m=1
	mnb02 (net27 net27 net21 vssa) nmos1 l=180n w=1u m=1
	mnpd1 (net21 xpd vssa vssa) nmos1 l=180n w=1u m=1
	mn001 (out net13 vssa vssa) nmos1 l=180n w=1u m=1
	mnpd2 (net13 pd vssa vssa) nmos1 l=180n w=1u m=1
	mnc01 (net13 net69 net12 vssa) nmos1 l=180n w=1u m=1
	mpb02 (net27 net51 net158 vdda) pmos1 l=180n w=1u m=1
	mppd1 (net158 xpd vdda vdda) pmos1 l=180n w=1u m=1
	mps11 (net31 net158 vdda vdda) pmos1 l=180n w=1u m=1
	mpd11 (net56 inn net31 net31) pmos1 l=180n w=1u m=1
	mp001 (out net158 vdda vdda) pmos1 l=180n w=1u m=1
	mpd12 (net13 inp net31 net31) pmos1 l=180n w=1u m=1
	mpb01 (net158 net158 vdda vdda) pmos1 l=180n w=1u m=1
ends OPAMP1_variant151

subckt OPAMP1_variant152 inn inp out pd xpd vdda vssa
	xd1 (vssa vdda) prim_nwd AREA=6.13907e-9 PJ=476.6e-6 m=1
	xi0 (vssa net69) prim_nd AREA=1e-12 PJ=4e-6 m=1
	xi3 (net51 vdda) prim_pd AREA=790e-15 PJ=3.3e-6 m=1
	xr0 (vssa vdda net51) prim_rdiffp l=2.1e-6 w=700e-9 m=1
	xr1 (vdda vdda net69) prim_rdiffp l=2.1e-6 w=700e-9 m=1
	xcc01 (net12 out) prim_cpoly c=1p m=1
	mnm12 (net13 net56 vssa vssa) nmos1 l=180n w=1u m=1
	mnm11 (net56 net56 vssa vssa) nmos1 l=180n w=1u m=1
	mnb02 (net27 net27 net21 vssa) nmos1 l=180n w=1u m=1
	mnpd1 (net21 xpd vssa vssa) nmos1 l=180n w=1u m=1
	mn001 (out net13 vssa vssa) nmos1 l=180n w=1u m=1
	mnpd2 (net13 pd vssa vssa) nmos1 l=180n w=1u m=1
	mnc01 (net13 net69 net12 vssa) nmos1 l=180n w=1u m=1
	mpb02 (net27 net51 net158 vdda) pmos1 l=1.8e-07n w=7.0e-07u m=1
	mppd1 (net158 xpd vdda vdda) pmos1 l=180n w=1u m=1
	mps11 (net31 net158 vdda vdda) pmos1 l=180n w=1u m=1
	mpd11 (net56 inn net31 net31) pmos1 l=180n w=1u m=1
	mp001 (out net158 vdda vdda) pmos1 l=1.7e-07n w=1.2e-06u m=1
	mpd12 (net13 inp net31 net31) pmos1 l=180n w=1u m=1
	mpb01 (net158 net158 vdda vdda) pmos1 l=180n w=1u m=1
ends OPAMP1_variant152

subckt OPAMP1_variant153 inn inp out pd xpd vdda vssa
	xd1 (vssa vdda) prim_nwd AREA=6.13907e-9 PJ=476.6e-6 m=1
	xi0 (vssa net69) prim_nd AREA=1e-12 PJ=4e-6 m=1
	xi3 (net51 vdda) prim_pd AREA=1.3e-09 PJ=3.3e-05 m=1
	xr0 (vssa vdda net51) prim_rdiffp l=2.1e-6 w=700e-9 m=1
	xr1 (vdda vdda net69) prim_rdiffp l=2.1e-6 w=700e-9 m=1
	xcc01 (net12 out) prim_cpoly c=1p m=1
	mnm12 (net13 net56 vssa vssa) nmos1 l=180n w=1u m=1
	mnm11 (net56 net56 vssa vssa) nmos1 l=180n w=1u m=1
	mnb02 (net27 net27 net21 vssa) nmos1 l=180n w=1u m=1
	mnpd1 (net21 xpd vssa vssa) nmos1 l=180n w=1u m=1
	mn001 (out net13 vssa vssa) nmos1 l=180n w=1u m=1
	mnpd2 (net13 pd vssa vssa) nmos1 l=180n w=1u m=1
	mnc01 (net13 net69 net12 vssa) nmos1 l=180n w=1u m=1
	mpb02 (net27 net51 net158 vdda) pmos1 l=180n w=1u m=1
	mppd1 (net158 xpd vdda vdda) pmos1 l=180n w=1u m=1
	mps11 (net31 net158 vdda vdda) pmos1 l=1.4e-07n w=1.5e-06u m=1
	mpd11 (net56 inn net31 net31) pmos1 l=180n w=1u m=1
	mp001 (out net158 vdda vdda) pmos1 l=180n w=1u m=1
	mpd12 (net13 inp net31 net31) pmos1 l=180n w=1u m=1
	mpb01 (net158 net158 vdda vdda) pmos1 l=180n w=1u m=1
ends OPAMP1_variant153

subckt OPAMP1_variant154 inn inp out pd xpd vdda vssa
	xd1 (vssa vdda) prim_nwd AREA=6.13907e-9 PJ=476.6e-6 m=1
	xi0 (vssa net69) prim_nd AREA=1e-12 PJ=4e-6 m=1
	xi3 (net51 vdda) prim_pd AREA=790e-15 PJ=3.3e-6 m=1
	xr0 (vssa vdda net51) prim_rdiffp l=2.1e-6 w=700e-9 m=1
	xr1 (vdda vdda net69) prim_rdiffp l=2.1e-6 w=700e-9 m=1
	xcc01 (net12 out) prim_cpoly c=1p m=1
	mnm12 (net13 net56 vssa vssa) nmos1 l=180n w=1u m=1
	mnm11 (net56 net56 vssa vssa) nmos1 l=180n w=1u m=1
	mnb02 (net27 net27 net21 vssa) nmos1 l=1.5e-07n w=1.4e-06u m=1
	mnpd1 (net21 xpd vssa vssa) nmos1 l=1.1e-07n w=1.0e-06u m=1
	mn001 (out net13 vssa vssa) nmos1 l=180n w=1u m=1
	mnpd2 (net13 pd vssa vssa) nmos1 l=180n w=1u m=1
	mnc01 (net13 net69 net12 vssa) nmos1 l=1.9e-07n w=1.6e-06u m=1
	mpb02 (net27 net51 net158 vdda) pmos1 l=1.8e-07n w=1.7e-06u m=1
	mppd1 (net158 xpd vdda vdda) pmos1 l=180n w=1u m=1
	mps11 (net31 net158 vdda vdda) pmos1 l=2.3e-07n w=1.4e-06u m=1
	mpd11 (net56 inn net31 net31) pmos1 l=180n w=1u m=1
	mp001 (out net158 vdda vdda) pmos1 l=180n w=1u m=1
	mpd12 (net13 inp net31 net31) pmos1 l=180n w=1u m=1
	mpb01 (net158 net158 vdda vdda) pmos1 l=180n w=1u m=1
ends OPAMP1_variant154

subckt OPAMP1_variant155 inn inp out pd xpd vdda vssa
	xd1 (vssa vdda) prim_nwd AREA=6.13907e-9 PJ=476.6e-6 m=1
	xi0 (vssa net69) prim_nd AREA=1e-12 PJ=4e-6 m=1
	xi3 (net51 vdda) prim_pd AREA=5.4e-09 PJ=5.7e-05 m=1
	xr0 (vssa vdda net51) prim_rdiffp l=2.1e-6 w=700e-9 m=1
	xr1 (vdda vdda net69) prim_rdiffp l=1.8e-07 w=5.9e-07 m=1
	xcc01 (net12 out) prim_cpoly c=1p m=1
	mnm12 (net13 net56 vssa vssa) nmos1 l=180n w=1u m=1
	mnm11 (net56 net56 vssa vssa) nmos1 l=180n w=1u m=1
	mnb02 (net27 net27 net21 vssa) nmos1 l=180n w=1u m=1
	mnpd1 (net21 xpd vssa vssa) nmos1 l=180n w=1u m=1
	mn001 (out net13 vssa vssa) nmos1 l=180n w=1u m=1
	mnpd2 (net13 pd vssa vssa) nmos1 l=180n w=1u m=1
	mnc01 (net13 net69 net12 vssa) nmos1 l=180n w=1u m=1
	mpb02 (net27 net51 net158 vdda) pmos1 l=1.3e-07n w=1.2e-06u m=1
	mppd1 (net158 xpd vdda vdda) pmos1 l=180n w=1u m=1
	mps11 (net31 net158 vdda vdda) pmos1 l=180n w=1u m=1
	mpd11 (net56 inn net31 net31) pmos1 l=180n w=1u m=1
	mp001 (out net158 vdda vdda) pmos1 l=180n w=1u m=1
	mpd12 (net13 inp net31 net31) pmos1 l=180n w=1u m=1
	mpb01 (net158 net158 vdda vdda) pmos1 l=180n w=1u m=1
ends OPAMP1_variant155

subckt OPAMP1_variant156 inn inp out pd xpd vdda vssa
	xd1 (vssa vdda) prim_nwd AREA=2.0e-10 PJ=8.4e-05 m=1
	xi0 (vssa net69) prim_nd AREA=1e-12 PJ=4e-6 m=1
	xi3 (net51 vdda) prim_pd AREA=790e-15 PJ=3.3e-6 m=1
	xr0 (vssa vdda net51) prim_rdiffp l=2.1e-6 w=700e-9 m=1
	xr1 (vdda vdda net69) prim_rdiffp l=1.3e-07 w=7.4e-07 m=1
	xcc01 (net12 out) prim_cpoly c=1p m=1
	mnm12 (net13 net56 vssa vssa) nmos1 l=180n w=1u m=1
	mnm11 (net56 net56 vssa vssa) nmos1 l=1.5e-07n w=1.4e-06u m=1
	mnb02 (net27 net27 net21 vssa) nmos1 l=180n w=1u m=1
	mnpd1 (net21 xpd vssa vssa) nmos1 l=180n w=1u m=1
	mn001 (out net13 vssa vssa) nmos1 l=180n w=1u m=1
	mnpd2 (net13 pd vssa vssa) nmos1 l=180n w=1u m=1
	mnc01 (net13 net69 net12 vssa) nmos1 l=180n w=1u m=1
	mpb02 (net27 net51 net158 vdda) pmos1 l=180n w=1u m=1
	mppd1 (net158 xpd vdda vdda) pmos1 l=180n w=1u m=1
	mps11 (net31 net158 vdda vdda) pmos1 l=1.7e-07n w=1.3e-06u m=1
	mpd11 (net56 inn net31 net31) pmos1 l=180n w=1u m=1
	mp001 (out net158 vdda vdda) pmos1 l=180n w=1u m=1
	mpd12 (net13 inp net31 net31) pmos1 l=180n w=1u m=1
	mpb01 (net158 net158 vdda vdda) pmos1 l=3.0e-07n w=1.1e-06u m=1
ends OPAMP1_variant156

subckt OPAMP1_variant157 inn inp out pd xpd vdda vssa
	xd1 (vssa vdda) prim_nwd AREA=5.0e-09 PJ=5.5e-05 m=1
	xi0 (vssa net69) prim_nd AREA=7.9e-09 PJ=7.9e-05 m=1
	xi3 (net51 vdda) prim_pd AREA=790e-15 PJ=3.3e-6 m=1
	xr0 (vssa vdda net51) prim_rdiffp l=2.1e-6 w=700e-9 m=1
	xr1 (vdda vdda net69) prim_rdiffp l=1.6e-07 w=2.0e-06 m=1
	xcc01 (net12 out) prim_cpoly c=1p m=1
	mnm12 (net13 net56 vssa vssa) nmos1 l=2.3e-07n w=1.3e-06u m=1
	mnm11 (net56 net56 vssa vssa) nmos1 l=180n w=1u m=1
	mnb02 (net27 net27 net21 vssa) nmos1 l=180n w=1u m=1
	mnpd1 (net21 xpd vssa vssa) nmos1 l=180n w=1u m=1
	mn001 (out net13 vssa vssa) nmos1 l=180n w=1u m=1
	mnpd2 (net13 pd vssa vssa) nmos1 l=1.5e-07n w=1.3e-06u m=1
	mnc01 (net13 net69 net12 vssa) nmos1 l=180n w=1u m=1
	mpb02 (net27 net51 net158 vdda) pmos1 l=180n w=1u m=1
	mppd1 (net158 xpd vdda vdda) pmos1 l=180n w=1u m=1
	mps11 (net31 net158 vdda vdda) pmos1 l=180n w=1u m=1
	mpd11 (net56 inn net31 net31) pmos1 l=180n w=1u m=1
	mp001 (out net158 vdda vdda) pmos1 l=180n w=1u m=1
	mpd12 (net13 inp net31 net31) pmos1 l=180n w=1u m=1
	mpb01 (net158 net158 vdda vdda) pmos1 l=180n w=1u m=1
ends OPAMP1_variant157

subckt OPAMP1_variant158 inn inp out pd xpd vdda vssa
	xd1 (vssa vdda) prim_nwd AREA=6.13907e-9 PJ=476.6e-6 m=1
	xi0 (vssa net69) prim_nd AREA=1e-12 PJ=4e-6 m=1
	xi3 (net51 vdda) prim_pd AREA=790e-15 PJ=3.3e-6 m=1
	xr0 (vssa vdda net51) prim_rdiffp l=2.1e-6 w=700e-9 m=1
	xr1 (vdda vdda net69) prim_rdiffp l=2.1e-6 w=700e-9 m=1
	xcc01 (net12 out) prim_cpoly c=1p m=1
	mnm12 (net13 net56 vssa vssa) nmos1 l=180n w=1u m=1
	mnm11 (net56 net56 vssa vssa) nmos1 l=180n w=1u m=1
	mnb02 (net27 net27 net21 vssa) nmos1 l=180n w=1u m=1
	mnpd1 (net21 xpd vssa vssa) nmos1 l=180n w=1u m=1
	mn001 (out net13 vssa vssa) nmos1 l=180n w=1u m=1
	mnpd2 (net13 pd vssa vssa) nmos1 l=180n w=1u m=1
	mnc01 (net13 net69 net12 vssa) nmos1 l=1.9e-07n w=1.3e-06u m=1
	mpb02 (net27 net51 net158 vdda) pmos1 l=180n w=1u m=1
	mppd1 (net158 xpd vdda vdda) pmos1 l=180n w=1u m=1
	mps11 (net31 net158 vdda vdda) pmos1 l=180n w=1u m=1
	mpd11 (net56 inn net31 net31) pmos1 l=180n w=1u m=1
	mp001 (out net158 vdda vdda) pmos1 l=1.0e-07n w=1.3e-06u m=1
	mpd12 (net13 inp net31 net31) pmos1 l=180n w=1u m=1
	mpb01 (net158 net158 vdda vdda) pmos1 l=180n w=1u m=1
ends OPAMP1_variant158

subckt OPAMP1_variant159 inn inp out pd xpd vdda vssa
	xd1 (vssa vdda) prim_nwd AREA=6.13907e-9 PJ=476.6e-6 m=1
	xi0 (vssa net69) prim_nd AREA=9.9e-09 PJ=3.2e-05 m=1
	xi3 (net51 vdda) prim_pd AREA=7.3e-09 PJ=7.9e-05 m=1
	xr0 (vssa vdda net51) prim_rdiffp l=2.1e-6 w=700e-9 m=1
	xr1 (vdda vdda net69) prim_rdiffp l=2.1e-6 w=700e-9 m=1
	xcc01 (net12 out) prim_cpoly c=1p m=1
	mnm12 (net13 net56 vssa vssa) nmos1 l=180n w=1u m=1
	mnm11 (net56 net56 vssa vssa) nmos1 l=180n w=1u m=1
	mnb02 (net27 net27 net21 vssa) nmos1 l=180n w=1u m=1
	mnpd1 (net21 xpd vssa vssa) nmos1 l=180n w=1u m=1
	mn001 (out net13 vssa vssa) nmos1 l=180n w=1u m=1
	mnpd2 (net13 pd vssa vssa) nmos1 l=2.0e-07n w=7.2e-07u m=1
	mnc01 (net13 net69 net12 vssa) nmos1 l=180n w=1u m=1
	mpb02 (net27 net51 net158 vdda) pmos1 l=180n w=1u m=1
	mppd1 (net158 xpd vdda vdda) pmos1 l=180n w=1u m=1
	mps11 (net31 net158 vdda vdda) pmos1 l=2.8e-07n w=5.6e-07u m=1
	mpd11 (net56 inn net31 net31) pmos1 l=180n w=1u m=1
	mp001 (out net158 vdda vdda) pmos1 l=180n w=1u m=1
	mpd12 (net13 inp net31 net31) pmos1 l=1.1e-07n w=1.3e-06u m=1
	mpb01 (net158 net158 vdda vdda) pmos1 l=180n w=1u m=1
ends OPAMP1_variant159

subckt OPAMP1_variant160 inn inp out pd xpd vdda vssa
	xd1 (vssa vdda) prim_nwd AREA=6.13907e-9 PJ=476.6e-6 m=1
	xi0 (vssa net69) prim_nd AREA=1e-12 PJ=4e-6 m=1
	xi3 (net51 vdda) prim_pd AREA=790e-15 PJ=3.3e-6 m=1
	xr0 (vssa vdda net51) prim_rdiffp l=1.1e-07 w=1.5e-06 m=1
	xr1 (vdda vdda net69) prim_rdiffp l=2.1e-6 w=700e-9 m=1
	xcc01 (net12 out) prim_cpoly c=1p m=1
	mnm12 (net13 net56 vssa vssa) nmos1 l=180n w=1u m=1
	mnm11 (net56 net56 vssa vssa) nmos1 l=180n w=1u m=1
	mnb02 (net27 net27 net21 vssa) nmos1 l=180n w=1u m=1
	mnpd1 (net21 xpd vssa vssa) nmos1 l=180n w=1u m=1
	mn001 (out net13 vssa vssa) nmos1 l=1.8e-07n w=1.4e-06u m=1
	mnpd2 (net13 pd vssa vssa) nmos1 l=2.3e-07n w=1.4e-06u m=1
	mnc01 (net13 net69 net12 vssa) nmos1 l=180n w=1u m=1
	mpb02 (net27 net51 net158 vdda) pmos1 l=180n w=1u m=1
	mppd1 (net158 xpd vdda vdda) pmos1 l=180n w=1u m=1
	mps11 (net31 net158 vdda vdda) pmos1 l=180n w=1u m=1
	mpd11 (net56 inn net31 net31) pmos1 l=180n w=1u m=1
	mp001 (out net158 vdda vdda) pmos1 l=2.1e-07n w=1.5e-06u m=1
	mpd12 (net13 inp net31 net31) pmos1 l=180n w=1u m=1
	mpb01 (net158 net158 vdda vdda) pmos1 l=180n w=1u m=1
ends OPAMP1_variant160

subckt OPAMP1_variant161 inn inp out pd xpd vdda vssa
	xd1 (vssa vdda) prim_nwd AREA=6.13907e-9 PJ=476.6e-6 m=1
	xi0 (vssa net69) prim_nd AREA=1e-12 PJ=4e-6 m=1
	xi3 (net51 vdda) prim_pd AREA=790e-15 PJ=3.3e-6 m=1
	xr0 (vssa vdda net51) prim_rdiffp l=2.1e-6 w=700e-9 m=1
	xr1 (vdda vdda net69) prim_rdiffp l=2.1e-6 w=700e-9 m=1
	xcc01 (net12 out) prim_cpoly c=1p m=1
	mnm12 (net13 net56 vssa vssa) nmos1 l=180n w=1u m=1
	mnm11 (net56 net56 vssa vssa) nmos1 l=3.0e-07n w=1.0e-06u m=1
	mnb02 (net27 net27 net21 vssa) nmos1 l=180n w=1u m=1
	mnpd1 (net21 xpd vssa vssa) nmos1 l=180n w=1u m=1
	mn001 (out net13 vssa vssa) nmos1 l=180n w=1u m=1
	mnpd2 (net13 pd vssa vssa) nmos1 l=180n w=1u m=1
	mnc01 (net13 net69 net12 vssa) nmos1 l=180n w=1u m=1
	mpb02 (net27 net51 net158 vdda) pmos1 l=180n w=1u m=1
	mppd1 (net158 xpd vdda vdda) pmos1 l=180n w=1u m=1
	mps11 (net31 net158 vdda vdda) pmos1 l=180n w=1u m=1
	mpd11 (net56 inn net31 net31) pmos1 l=180n w=1u m=1
	mp001 (out net158 vdda vdda) pmos1 l=1.7e-07n w=1.4e-06u m=1
	mpd12 (net13 inp net31 net31) pmos1 l=180n w=1u m=1
	mpb01 (net158 net158 vdda vdda) pmos1 l=180n w=1u m=1
ends OPAMP1_variant161

subckt OPAMP1_variant162 inn inp out pd xpd vdda vssa
	xd1 (vssa vdda) prim_nwd AREA=6.13907e-9 PJ=476.6e-6 m=1
	xi0 (vssa net69) prim_nd AREA=1e-12 PJ=4e-6 m=1
	xi3 (net51 vdda) prim_pd AREA=1.7e-09 PJ=2.4e-06 m=1
	xr0 (vssa vdda net51) prim_rdiffp l=2.1e-6 w=700e-9 m=1
	xr1 (vdda vdda net69) prim_rdiffp l=2.1e-6 w=700e-9 m=1
	xcc01 (net12 out) prim_cpoly c=1p m=1
	mnm12 (net13 net56 vssa vssa) nmos1 l=180n w=1u m=1
	mnm11 (net56 net56 vssa vssa) nmos1 l=180n w=1u m=1
	mnb02 (net27 net27 net21 vssa) nmos1 l=180n w=1u m=1
	mnpd1 (net21 xpd vssa vssa) nmos1 l=180n w=1u m=1
	mn001 (out net13 vssa vssa) nmos1 l=180n w=1u m=1
	mnpd2 (net13 pd vssa vssa) nmos1 l=180n w=1u m=1
	mnc01 (net13 net69 net12 vssa) nmos1 l=180n w=1u m=1
	mpb02 (net27 net51 net158 vdda) pmos1 l=180n w=1u m=1
	mppd1 (net158 xpd vdda vdda) pmos1 l=180n w=1u m=1
	mps11 (net31 net158 vdda vdda) pmos1 l=180n w=1u m=1
	mpd11 (net56 inn net31 net31) pmos1 l=180n w=1u m=1
	mp001 (out net158 vdda vdda) pmos1 l=2.2e-07n w=1.3e-06u m=1
	mpd12 (net13 inp net31 net31) pmos1 l=2.9e-07n w=2.0e-06u m=1
	mpb01 (net158 net158 vdda vdda) pmos1 l=180n w=1u m=1
ends OPAMP1_variant162

subckt OPAMP1_variant163 inn inp out pd xpd vdda vssa
	xd1 (vssa vdda) prim_nwd AREA=6.13907e-9 PJ=476.6e-6 m=1
	xi0 (vssa net69) prim_nd AREA=1e-12 PJ=4e-6 m=1
	xi3 (net51 vdda) prim_pd AREA=790e-15 PJ=3.3e-6 m=1
	xr0 (vssa vdda net51) prim_rdiffp l=2.1e-6 w=700e-9 m=1
	xr1 (vdda vdda net69) prim_rdiffp l=2.1e-6 w=700e-9 m=1
	xcc01 (net12 out) prim_cpoly c=1.0e-12p m=1
	mnm12 (net13 net56 vssa vssa) nmos1 l=180n w=1u m=1
	mnm11 (net56 net56 vssa vssa) nmos1 l=180n w=1u m=1
	mnb02 (net27 net27 net21 vssa) nmos1 l=180n w=1u m=1
	mnpd1 (net21 xpd vssa vssa) nmos1 l=180n w=1u m=1
	mn001 (out net13 vssa vssa) nmos1 l=1.0e-07n w=1.9e-06u m=1
	mnpd2 (net13 pd vssa vssa) nmos1 l=180n w=1u m=1
	mnc01 (net13 net69 net12 vssa) nmos1 l=180n w=1u m=1
	mpb02 (net27 net51 net158 vdda) pmos1 l=180n w=1u m=1
	mppd1 (net158 xpd vdda vdda) pmos1 l=180n w=1u m=1
	mps11 (net31 net158 vdda vdda) pmos1 l=180n w=1u m=1
	mpd11 (net56 inn net31 net31) pmos1 l=180n w=1u m=1
	mp001 (out net158 vdda vdda) pmos1 l=180n w=1u m=1
	mpd12 (net13 inp net31 net31) pmos1 l=180n w=1u m=1
	mpb01 (net158 net158 vdda vdda) pmos1 l=2.9e-07n w=1.0e-06u m=1
ends OPAMP1_variant163

subckt OPAMP1_variant164 inn inp out pd xpd vdda vssa
	xd1 (vssa vdda) prim_nwd AREA=1.8e-09 PJ=9.4e-05 m=1
	xi0 (vssa net69) prim_nd AREA=1e-12 PJ=4e-6 m=1
	xi3 (net51 vdda) prim_pd AREA=790e-15 PJ=3.3e-6 m=1
	xr0 (vssa vdda net51) prim_rdiffp l=2.0e-07 w=1.5e-06 m=1
	xr1 (vdda vdda net69) prim_rdiffp l=2.1e-6 w=700e-9 m=1
	xcc01 (net12 out) prim_cpoly c=1p m=1
	mnm12 (net13 net56 vssa vssa) nmos1 l=180n w=1u m=1
	mnm11 (net56 net56 vssa vssa) nmos1 l=180n w=1u m=1
	mnb02 (net27 net27 net21 vssa) nmos1 l=180n w=1u m=1
	mnpd1 (net21 xpd vssa vssa) nmos1 l=180n w=1u m=1
	mn001 (out net13 vssa vssa) nmos1 l=180n w=1u m=1
	mnpd2 (net13 pd vssa vssa) nmos1 l=180n w=1u m=1
	mnc01 (net13 net69 net12 vssa) nmos1 l=180n w=1u m=1
	mpb02 (net27 net51 net158 vdda) pmos1 l=180n w=1u m=1
	mppd1 (net158 xpd vdda vdda) pmos1 l=180n w=1u m=1
	mps11 (net31 net158 vdda vdda) pmos1 l=180n w=1u m=1
	mpd11 (net56 inn net31 net31) pmos1 l=180n w=1u m=1
	mp001 (out net158 vdda vdda) pmos1 l=180n w=1u m=1
	mpd12 (net13 inp net31 net31) pmos1 l=1.5e-07n w=1.4e-06u m=1
	mpb01 (net158 net158 vdda vdda) pmos1 l=180n w=1u m=1
ends OPAMP1_variant164

subckt OPAMP1_variant165 inn inp out pd xpd vdda vssa
	xd1 (vssa vdda) prim_nwd AREA=6.13907e-9 PJ=476.6e-6 m=1
	xi0 (vssa net69) prim_nd AREA=1e-12 PJ=4e-6 m=1
	xi3 (net51 vdda) prim_pd AREA=790e-15 PJ=3.3e-6 m=1
	xr0 (vssa vdda net51) prim_rdiffp l=2.1e-6 w=700e-9 m=1
	xr1 (vdda vdda net69) prim_rdiffp l=2.4e-07 w=8.6e-07 m=1
	xcc01 (net12 out) prim_cpoly c=1p m=1
	mnm12 (net13 net56 vssa vssa) nmos1 l=180n w=1u m=1
	mnm11 (net56 net56 vssa vssa) nmos1 l=180n w=1u m=1
	mnb02 (net27 net27 net21 vssa) nmos1 l=2.2e-07n w=1.6e-06u m=1
	mnpd1 (net21 xpd vssa vssa) nmos1 l=180n w=1u m=1
	mn001 (out net13 vssa vssa) nmos1 l=180n w=1u m=1
	mnpd2 (net13 pd vssa vssa) nmos1 l=2.4e-07n w=1.5e-06u m=1
	mnc01 (net13 net69 net12 vssa) nmos1 l=180n w=1u m=1
	mpb02 (net27 net51 net158 vdda) pmos1 l=180n w=1u m=1
	mppd1 (net158 xpd vdda vdda) pmos1 l=180n w=1u m=1
	mps11 (net31 net158 vdda vdda) pmos1 l=180n w=1u m=1
	mpd11 (net56 inn net31 net31) pmos1 l=180n w=1u m=1
	mp001 (out net158 vdda vdda) pmos1 l=180n w=1u m=1
	mpd12 (net13 inp net31 net31) pmos1 l=180n w=1u m=1
	mpb01 (net158 net158 vdda vdda) pmos1 l=180n w=1u m=1
ends OPAMP1_variant165

subckt OPAMP1_variant166 inn inp out pd xpd vdda vssa
	xd1 (vssa vdda) prim_nwd AREA=6.13907e-9 PJ=476.6e-6 m=1
	xi0 (vssa net69) prim_nd AREA=1e-12 PJ=4e-6 m=1
	xi3 (net51 vdda) prim_pd AREA=790e-15 PJ=3.3e-6 m=1
	xr0 (vssa vdda net51) prim_rdiffp l=2.1e-6 w=700e-9 m=1
	xr1 (vdda vdda net69) prim_rdiffp l=2.1e-6 w=700e-9 m=1
	xcc01 (net12 out) prim_cpoly c=1p m=1
	mnm12 (net13 net56 vssa vssa) nmos1 l=180n w=1u m=1
	mnm11 (net56 net56 vssa vssa) nmos1 l=1.2e-07n w=1.7e-06u m=1
	mnb02 (net27 net27 net21 vssa) nmos1 l=180n w=1u m=1
	mnpd1 (net21 xpd vssa vssa) nmos1 l=2.6e-07n w=1.9e-06u m=1
	mn001 (out net13 vssa vssa) nmos1 l=180n w=1u m=1
	mnpd2 (net13 pd vssa vssa) nmos1 l=180n w=1u m=1
	mnc01 (net13 net69 net12 vssa) nmos1 l=2.0e-07n w=5.0e-07u m=1
	mpb02 (net27 net51 net158 vdda) pmos1 l=2.1e-07n w=1.3e-06u m=1
	mppd1 (net158 xpd vdda vdda) pmos1 l=180n w=1u m=1
	mps11 (net31 net158 vdda vdda) pmos1 l=180n w=1u m=1
	mpd11 (net56 inn net31 net31) pmos1 l=180n w=1u m=1
	mp001 (out net158 vdda vdda) pmos1 l=180n w=1u m=1
	mpd12 (net13 inp net31 net31) pmos1 l=2.4e-07n w=1.3e-06u m=1
	mpb01 (net158 net158 vdda vdda) pmos1 l=180n w=1u m=1
ends OPAMP1_variant166

subckt OPAMP1_variant167 inn inp out pd xpd vdda vssa
	xd1 (vssa vdda) prim_nwd AREA=6.13907e-9 PJ=476.6e-6 m=1
	xi0 (vssa net69) prim_nd AREA=6.5e-09 PJ=3.8e-05 m=1
	xi3 (net51 vdda) prim_pd AREA=8.3e-09 PJ=4.9e-05 m=1
	xr0 (vssa vdda net51) prim_rdiffp l=1.4e-07 w=1.5e-06 m=1
	xr1 (vdda vdda net69) prim_rdiffp l=2.1e-6 w=700e-9 m=1
	xcc01 (net12 out) prim_cpoly c=1p m=1
	mnm12 (net13 net56 vssa vssa) nmos1 l=180n w=1u m=1
	mnm11 (net56 net56 vssa vssa) nmos1 l=180n w=1u m=1
	mnb02 (net27 net27 net21 vssa) nmos1 l=180n w=1u m=1
	mnpd1 (net21 xpd vssa vssa) nmos1 l=180n w=1u m=1
	mn001 (out net13 vssa vssa) nmos1 l=180n w=1u m=1
	mnpd2 (net13 pd vssa vssa) nmos1 l=180n w=1u m=1
	mnc01 (net13 net69 net12 vssa) nmos1 l=1.2e-07n w=1.1e-06u m=1
	mpb02 (net27 net51 net158 vdda) pmos1 l=180n w=1u m=1
	mppd1 (net158 xpd vdda vdda) pmos1 l=180n w=1u m=1
	mps11 (net31 net158 vdda vdda) pmos1 l=180n w=1u m=1
	mpd11 (net56 inn net31 net31) pmos1 l=180n w=1u m=1
	mp001 (out net158 vdda vdda) pmos1 l=2.4e-07n w=5.4e-07u m=1
	mpd12 (net13 inp net31 net31) pmos1 l=180n w=1u m=1
	mpb01 (net158 net158 vdda vdda) pmos1 l=180n w=1u m=1
ends OPAMP1_variant167

subckt OPAMP1_variant168 inn inp out pd xpd vdda vssa
	xd1 (vssa vdda) prim_nwd AREA=6.13907e-9 PJ=476.6e-6 m=1
	xi0 (vssa net69) prim_nd AREA=1e-12 PJ=4e-6 m=1
	xi3 (net51 vdda) prim_pd AREA=790e-15 PJ=3.3e-6 m=1
	xr0 (vssa vdda net51) prim_rdiffp l=1.2e-07 w=1.1e-06 m=1
	xr1 (vdda vdda net69) prim_rdiffp l=2.1e-6 w=700e-9 m=1
	xcc01 (net12 out) prim_cpoly c=1p m=1
	mnm12 (net13 net56 vssa vssa) nmos1 l=180n w=1u m=1
	mnm11 (net56 net56 vssa vssa) nmos1 l=180n w=1u m=1
	mnb02 (net27 net27 net21 vssa) nmos1 l=180n w=1u m=1
	mnpd1 (net21 xpd vssa vssa) nmos1 l=180n w=1u m=1
	mn001 (out net13 vssa vssa) nmos1 l=180n w=1u m=1
	mnpd2 (net13 pd vssa vssa) nmos1 l=180n w=1u m=1
	mnc01 (net13 net69 net12 vssa) nmos1 l=180n w=1u m=1
	mpb02 (net27 net51 net158 vdda) pmos1 l=180n w=1u m=1
	mppd1 (net158 xpd vdda vdda) pmos1 l=1.3e-07n w=8.6e-07u m=1
	mps11 (net31 net158 vdda vdda) pmos1 l=180n w=1u m=1
	mpd11 (net56 inn net31 net31) pmos1 l=180n w=1u m=1
	mp001 (out net158 vdda vdda) pmos1 l=180n w=1u m=1
	mpd12 (net13 inp net31 net31) pmos1 l=180n w=1u m=1
	mpb01 (net158 net158 vdda vdda) pmos1 l=180n w=1u m=1
ends OPAMP1_variant168

subckt OPAMP1_variant169 inn inp out pd xpd vdda vssa
	xd1 (vssa vdda) prim_nwd AREA=6.13907e-9 PJ=476.6e-6 m=1
	xi0 (vssa net69) prim_nd AREA=1e-12 PJ=4e-6 m=1
	xi3 (net51 vdda) prim_pd AREA=790e-15 PJ=3.3e-6 m=1
	xr0 (vssa vdda net51) prim_rdiffp l=2.1e-6 w=700e-9 m=1
	xr1 (vdda vdda net69) prim_rdiffp l=2.1e-6 w=700e-9 m=1
	xcc01 (net12 out) prim_cpoly c=1p m=1
	mnm12 (net13 net56 vssa vssa) nmos1 l=180n w=1u m=1
	mnm11 (net56 net56 vssa vssa) nmos1 l=180n w=1u m=1
	mnb02 (net27 net27 net21 vssa) nmos1 l=180n w=1u m=1
	mnpd1 (net21 xpd vssa vssa) nmos1 l=180n w=1u m=1
	mn001 (out net13 vssa vssa) nmos1 l=180n w=1u m=1
	mnpd2 (net13 pd vssa vssa) nmos1 l=180n w=1u m=1
	mnc01 (net13 net69 net12 vssa) nmos1 l=2.6e-07n w=5.5e-07u m=1
	mpb02 (net27 net51 net158 vdda) pmos1 l=180n w=1u m=1
	mppd1 (net158 xpd vdda vdda) pmos1 l=1.5e-07n w=1.8e-06u m=1
	mps11 (net31 net158 vdda vdda) pmos1 l=180n w=1u m=1
	mpd11 (net56 inn net31 net31) pmos1 l=180n w=1u m=1
	mp001 (out net158 vdda vdda) pmos1 l=180n w=1u m=1
	mpd12 (net13 inp net31 net31) pmos1 l=180n w=1u m=1
	mpb01 (net158 net158 vdda vdda) pmos1 l=1.2e-07n w=1.3e-06u m=1
ends OPAMP1_variant169

subckt OPAMP1_variant170 inn inp out pd xpd vdda vssa
	xd1 (vssa vdda) prim_nwd AREA=1.9e-09 PJ=1.8e-05 m=1
	xi0 (vssa net69) prim_nd AREA=1e-12 PJ=4e-6 m=1
	xi3 (net51 vdda) prim_pd AREA=790e-15 PJ=3.3e-6 m=1
	xr0 (vssa vdda net51) prim_rdiffp l=2.1e-6 w=700e-9 m=1
	xr1 (vdda vdda net69) prim_rdiffp l=2.1e-6 w=700e-9 m=1
	xcc01 (net12 out) prim_cpoly c=1p m=1
	mnm12 (net13 net56 vssa vssa) nmos1 l=180n w=1u m=1
	mnm11 (net56 net56 vssa vssa) nmos1 l=180n w=1u m=1
	mnb02 (net27 net27 net21 vssa) nmos1 l=2.8e-07n w=5.5e-07u m=1
	mnpd1 (net21 xpd vssa vssa) nmos1 l=2.2e-07n w=1.2e-06u m=1
	mn001 (out net13 vssa vssa) nmos1 l=180n w=1u m=1
	mnpd2 (net13 pd vssa vssa) nmos1 l=180n w=1u m=1
	mnc01 (net13 net69 net12 vssa) nmos1 l=180n w=1u m=1
	mpb02 (net27 net51 net158 vdda) pmos1 l=180n w=1u m=1
	mppd1 (net158 xpd vdda vdda) pmos1 l=180n w=1u m=1
	mps11 (net31 net158 vdda vdda) pmos1 l=180n w=1u m=1
	mpd11 (net56 inn net31 net31) pmos1 l=180n w=1u m=1
	mp001 (out net158 vdda vdda) pmos1 l=180n w=1u m=1
	mpd12 (net13 inp net31 net31) pmos1 l=2.1e-07n w=7.3e-07u m=1
	mpb01 (net158 net158 vdda vdda) pmos1 l=180n w=1u m=1
ends OPAMP1_variant170

subckt OPAMP1_variant171 inn inp out pd xpd vdda vssa
	xd1 (vssa vdda) prim_nwd AREA=6.13907e-9 PJ=476.6e-6 m=1
	xi0 (vssa net69) prim_nd AREA=1e-12 PJ=4e-6 m=1
	xi3 (net51 vdda) prim_pd AREA=790e-15 PJ=3.3e-6 m=1
	xr0 (vssa vdda net51) prim_rdiffp l=2.1e-6 w=700e-9 m=1
	xr1 (vdda vdda net69) prim_rdiffp l=2.1e-6 w=700e-9 m=1
	xcc01 (net12 out) prim_cpoly c=1p m=1
	mnm12 (net13 net56 vssa vssa) nmos1 l=180n w=1u m=1
	mnm11 (net56 net56 vssa vssa) nmos1 l=2.0e-07n w=1.7e-06u m=1
	mnb02 (net27 net27 net21 vssa) nmos1 l=180n w=1u m=1
	mnpd1 (net21 xpd vssa vssa) nmos1 l=180n w=1u m=1
	mn001 (out net13 vssa vssa) nmos1 l=180n w=1u m=1
	mnpd2 (net13 pd vssa vssa) nmos1 l=180n w=1u m=1
	mnc01 (net13 net69 net12 vssa) nmos1 l=180n w=1u m=1
	mpb02 (net27 net51 net158 vdda) pmos1 l=2.6e-07n w=1.1e-06u m=1
	mppd1 (net158 xpd vdda vdda) pmos1 l=180n w=1u m=1
	mps11 (net31 net158 vdda vdda) pmos1 l=180n w=1u m=1
	mpd11 (net56 inn net31 net31) pmos1 l=180n w=1u m=1
	mp001 (out net158 vdda vdda) pmos1 l=180n w=1u m=1
	mpd12 (net13 inp net31 net31) pmos1 l=180n w=1u m=1
	mpb01 (net158 net158 vdda vdda) pmos1 l=180n w=1u m=1
ends OPAMP1_variant171

subckt OPAMP1_variant172 inn inp out pd xpd vdda vssa
	xd1 (vssa vdda) prim_nwd AREA=6.13907e-9 PJ=476.6e-6 m=1
	xi0 (vssa net69) prim_nd AREA=1e-12 PJ=4e-6 m=1
	xi3 (net51 vdda) prim_pd AREA=790e-15 PJ=3.3e-6 m=1
	xr0 (vssa vdda net51) prim_rdiffp l=1.2e-07 w=1.4e-06 m=1
	xr1 (vdda vdda net69) prim_rdiffp l=2.1e-6 w=700e-9 m=1
	xcc01 (net12 out) prim_cpoly c=1p m=1
	mnm12 (net13 net56 vssa vssa) nmos1 l=180n w=1u m=1
	mnm11 (net56 net56 vssa vssa) nmos1 l=180n w=1u m=1
	mnb02 (net27 net27 net21 vssa) nmos1 l=180n w=1u m=1
	mnpd1 (net21 xpd vssa vssa) nmos1 l=180n w=1u m=1
	mn001 (out net13 vssa vssa) nmos1 l=180n w=1u m=1
	mnpd2 (net13 pd vssa vssa) nmos1 l=180n w=1u m=1
	mnc01 (net13 net69 net12 vssa) nmos1 l=180n w=1u m=1
	mpb02 (net27 net51 net158 vdda) pmos1 l=180n w=1u m=1
	mppd1 (net158 xpd vdda vdda) pmos1 l=1.9e-07n w=1.1e-06u m=1
	mps11 (net31 net158 vdda vdda) pmos1 l=180n w=1u m=1
	mpd11 (net56 inn net31 net31) pmos1 l=180n w=1u m=1
	mp001 (out net158 vdda vdda) pmos1 l=180n w=1u m=1
	mpd12 (net13 inp net31 net31) pmos1 l=180n w=1u m=1
	mpb01 (net158 net158 vdda vdda) pmos1 l=180n w=1u m=1
ends OPAMP1_variant172

subckt OPAMP1_variant173 inn inp out pd xpd vdda vssa
	xd1 (vssa vdda) prim_nwd AREA=9.6e-09 PJ=4.8e-05 m=1
	xi0 (vssa net69) prim_nd AREA=1e-12 PJ=4e-6 m=1
	xi3 (net51 vdda) prim_pd AREA=1.5e-09 PJ=4.4e-05 m=1
	xr0 (vssa vdda net51) prim_rdiffp l=2.1e-6 w=700e-9 m=1
	xr1 (vdda vdda net69) prim_rdiffp l=2.1e-6 w=700e-9 m=1
	xcc01 (net12 out) prim_cpoly c=1p m=1
	mnm12 (net13 net56 vssa vssa) nmos1 l=180n w=1u m=1
	mnm11 (net56 net56 vssa vssa) nmos1 l=180n w=1u m=1
	mnb02 (net27 net27 net21 vssa) nmos1 l=180n w=1u m=1
	mnpd1 (net21 xpd vssa vssa) nmos1 l=2.3e-07n w=1.6e-06u m=1
	mn001 (out net13 vssa vssa) nmos1 l=180n w=1u m=1
	mnpd2 (net13 pd vssa vssa) nmos1 l=180n w=1u m=1
	mnc01 (net13 net69 net12 vssa) nmos1 l=180n w=1u m=1
	mpb02 (net27 net51 net158 vdda) pmos1 l=180n w=1u m=1
	mppd1 (net158 xpd vdda vdda) pmos1 l=2.1e-07n w=6.2e-07u m=1
	mps11 (net31 net158 vdda vdda) pmos1 l=180n w=1u m=1
	mpd11 (net56 inn net31 net31) pmos1 l=180n w=1u m=1
	mp001 (out net158 vdda vdda) pmos1 l=180n w=1u m=1
	mpd12 (net13 inp net31 net31) pmos1 l=180n w=1u m=1
	mpb01 (net158 net158 vdda vdda) pmos1 l=180n w=1u m=1
ends OPAMP1_variant173

subckt OPAMP1_variant174 inn inp out pd xpd vdda vssa
	xd1 (vssa vdda) prim_nwd AREA=6.13907e-9 PJ=476.6e-6 m=1
	xi0 (vssa net69) prim_nd AREA=5.6e-09 PJ=5.2e-05 m=1
	xi3 (net51 vdda) prim_pd AREA=790e-15 PJ=3.3e-6 m=1
	xr0 (vssa vdda net51) prim_rdiffp l=2.1e-6 w=700e-9 m=1
	xr1 (vdda vdda net69) prim_rdiffp l=2.1e-07 w=1.8e-06 m=1
	xcc01 (net12 out) prim_cpoly c=1p m=1
	mnm12 (net13 net56 vssa vssa) nmos1 l=180n w=1u m=1
	mnm11 (net56 net56 vssa vssa) nmos1 l=180n w=1u m=1
	mnb02 (net27 net27 net21 vssa) nmos1 l=180n w=1u m=1
	mnpd1 (net21 xpd vssa vssa) nmos1 l=180n w=1u m=1
	mn001 (out net13 vssa vssa) nmos1 l=180n w=1u m=1
	mnpd2 (net13 pd vssa vssa) nmos1 l=1.3e-07n w=1.1e-06u m=1
	mnc01 (net13 net69 net12 vssa) nmos1 l=180n w=1u m=1
	mpb02 (net27 net51 net158 vdda) pmos1 l=180n w=1u m=1
	mppd1 (net158 xpd vdda vdda) pmos1 l=180n w=1u m=1
	mps11 (net31 net158 vdda vdda) pmos1 l=180n w=1u m=1
	mpd11 (net56 inn net31 net31) pmos1 l=2.6e-07n w=5.6e-07u m=1
	mp001 (out net158 vdda vdda) pmos1 l=180n w=1u m=1
	mpd12 (net13 inp net31 net31) pmos1 l=180n w=1u m=1
	mpb01 (net158 net158 vdda vdda) pmos1 l=180n w=1u m=1
ends OPAMP1_variant174

subckt OPAMP1_variant175 inn inp out pd xpd vdda vssa
	xd1 (vssa vdda) prim_nwd AREA=8.8e-09 PJ=1.2e-05 m=1
	xi0 (vssa net69) prim_nd AREA=7.5e-09 PJ=9.6e-05 m=1
	xi3 (net51 vdda) prim_pd AREA=790e-15 PJ=3.3e-6 m=1
	xr0 (vssa vdda net51) prim_rdiffp l=2.8e-07 w=1.8e-06 m=1
	xr1 (vdda vdda net69) prim_rdiffp l=2.1e-6 w=700e-9 m=1
	xcc01 (net12 out) prim_cpoly c=1p m=1
	mnm12 (net13 net56 vssa vssa) nmos1 l=180n w=1u m=1
	mnm11 (net56 net56 vssa vssa) nmos1 l=1.6e-07n w=1.9e-06u m=1
	mnb02 (net27 net27 net21 vssa) nmos1 l=180n w=1u m=1
	mnpd1 (net21 xpd vssa vssa) nmos1 l=180n w=1u m=1
	mn001 (out net13 vssa vssa) nmos1 l=180n w=1u m=1
	mnpd2 (net13 pd vssa vssa) nmos1 l=180n w=1u m=1
	mnc01 (net13 net69 net12 vssa) nmos1 l=180n w=1u m=1
	mpb02 (net27 net51 net158 vdda) pmos1 l=180n w=1u m=1
	mppd1 (net158 xpd vdda vdda) pmos1 l=180n w=1u m=1
	mps11 (net31 net158 vdda vdda) pmos1 l=180n w=1u m=1
	mpd11 (net56 inn net31 net31) pmos1 l=180n w=1u m=1
	mp001 (out net158 vdda vdda) pmos1 l=180n w=1u m=1
	mpd12 (net13 inp net31 net31) pmos1 l=180n w=1u m=1
	mpb01 (net158 net158 vdda vdda) pmos1 l=2.6e-07n w=8.4e-07u m=1
ends OPAMP1_variant175

subckt OPAMP1_variant176 inn inp out pd xpd vdda vssa
	xd1 (vssa vdda) prim_nwd AREA=6.13907e-9 PJ=476.6e-6 m=1
	xi0 (vssa net69) prim_nd AREA=1e-12 PJ=4e-6 m=1
	xi3 (net51 vdda) prim_pd AREA=790e-15 PJ=3.3e-6 m=1
	xr0 (vssa vdda net51) prim_rdiffp l=2.1e-6 w=700e-9 m=1
	xr1 (vdda vdda net69) prim_rdiffp l=1.8e-07 w=9.6e-07 m=1
	xcc01 (net12 out) prim_cpoly c=1p m=1
	mnm12 (net13 net56 vssa vssa) nmos1 l=180n w=1u m=1
	mnm11 (net56 net56 vssa vssa) nmos1 l=180n w=1u m=1
	mnb02 (net27 net27 net21 vssa) nmos1 l=180n w=1u m=1
	mnpd1 (net21 xpd vssa vssa) nmos1 l=180n w=1u m=1
	mn001 (out net13 vssa vssa) nmos1 l=2.7e-07n w=1.4e-06u m=1
	mnpd2 (net13 pd vssa vssa) nmos1 l=180n w=1u m=1
	mnc01 (net13 net69 net12 vssa) nmos1 l=180n w=1u m=1
	mpb02 (net27 net51 net158 vdda) pmos1 l=180n w=1u m=1
	mppd1 (net158 xpd vdda vdda) pmos1 l=1.1e-07n w=9.0e-07u m=1
	mps11 (net31 net158 vdda vdda) pmos1 l=180n w=1u m=1
	mpd11 (net56 inn net31 net31) pmos1 l=2.2e-07n w=7.6e-07u m=1
	mp001 (out net158 vdda vdda) pmos1 l=2.0e-07n w=1.4e-06u m=1
	mpd12 (net13 inp net31 net31) pmos1 l=180n w=1u m=1
	mpb01 (net158 net158 vdda vdda) pmos1 l=180n w=1u m=1
ends OPAMP1_variant176

subckt OPAMP1_variant177 inn inp out pd xpd vdda vssa
	xd1 (vssa vdda) prim_nwd AREA=6.13907e-9 PJ=476.6e-6 m=1
	xi0 (vssa net69) prim_nd AREA=1e-12 PJ=4e-6 m=1
	xi3 (net51 vdda) prim_pd AREA=790e-15 PJ=3.3e-6 m=1
	xr0 (vssa vdda net51) prim_rdiffp l=2.1e-6 w=700e-9 m=1
	xr1 (vdda vdda net69) prim_rdiffp l=2.1e-6 w=700e-9 m=1
	xcc01 (net12 out) prim_cpoly c=1p m=1
	mnm12 (net13 net56 vssa vssa) nmos1 l=2.3e-07n w=1.6e-06u m=1
	mnm11 (net56 net56 vssa vssa) nmos1 l=180n w=1u m=1
	mnb02 (net27 net27 net21 vssa) nmos1 l=1.3e-07n w=1.2e-06u m=1
	mnpd1 (net21 xpd vssa vssa) nmos1 l=180n w=1u m=1
	mn001 (out net13 vssa vssa) nmos1 l=180n w=1u m=1
	mnpd2 (net13 pd vssa vssa) nmos1 l=180n w=1u m=1
	mnc01 (net13 net69 net12 vssa) nmos1 l=180n w=1u m=1
	mpb02 (net27 net51 net158 vdda) pmos1 l=180n w=1u m=1
	mppd1 (net158 xpd vdda vdda) pmos1 l=180n w=1u m=1
	mps11 (net31 net158 vdda vdda) pmos1 l=180n w=1u m=1
	mpd11 (net56 inn net31 net31) pmos1 l=180n w=1u m=1
	mp001 (out net158 vdda vdda) pmos1 l=180n w=1u m=1
	mpd12 (net13 inp net31 net31) pmos1 l=180n w=1u m=1
	mpb01 (net158 net158 vdda vdda) pmos1 l=180n w=1u m=1
ends OPAMP1_variant177

subckt OPAMP1_variant178 inn inp out pd xpd vdda vssa
	xd1 (vssa vdda) prim_nwd AREA=6.13907e-9 PJ=476.6e-6 m=1
	xi0 (vssa net69) prim_nd AREA=1e-12 PJ=4e-6 m=1
	xi3 (net51 vdda) prim_pd AREA=790e-15 PJ=3.3e-6 m=1
	xr0 (vssa vdda net51) prim_rdiffp l=2.1e-6 w=700e-9 m=1
	xr1 (vdda vdda net69) prim_rdiffp l=1.5e-07 w=1.9e-06 m=1
	xcc01 (net12 out) prim_cpoly c=1p m=1
	mnm12 (net13 net56 vssa vssa) nmos1 l=180n w=1u m=1
	mnm11 (net56 net56 vssa vssa) nmos1 l=180n w=1u m=1
	mnb02 (net27 net27 net21 vssa) nmos1 l=180n w=1u m=1
	mnpd1 (net21 xpd vssa vssa) nmos1 l=180n w=1u m=1
	mn001 (out net13 vssa vssa) nmos1 l=180n w=1u m=1
	mnpd2 (net13 pd vssa vssa) nmos1 l=1.3e-07n w=1.1e-06u m=1
	mnc01 (net13 net69 net12 vssa) nmos1 l=2.7e-07n w=9.2e-07u m=1
	mpb02 (net27 net51 net158 vdda) pmos1 l=180n w=1u m=1
	mppd1 (net158 xpd vdda vdda) pmos1 l=180n w=1u m=1
	mps11 (net31 net158 vdda vdda) pmos1 l=2.9e-07n w=1.7e-06u m=1
	mpd11 (net56 inn net31 net31) pmos1 l=1.8e-07n w=8.2e-07u m=1
	mp001 (out net158 vdda vdda) pmos1 l=180n w=1u m=1
	mpd12 (net13 inp net31 net31) pmos1 l=180n w=1u m=1
	mpb01 (net158 net158 vdda vdda) pmos1 l=180n w=1u m=1
ends OPAMP1_variant178

subckt OPAMP1_variant179 inn inp out pd xpd vdda vssa
	xd1 (vssa vdda) prim_nwd AREA=6.13907e-9 PJ=476.6e-6 m=1
	xi0 (vssa net69) prim_nd AREA=1e-12 PJ=4e-6 m=1
	xi3 (net51 vdda) prim_pd AREA=790e-15 PJ=3.3e-6 m=1
	xr0 (vssa vdda net51) prim_rdiffp l=2.1e-6 w=700e-9 m=1
	xr1 (vdda vdda net69) prim_rdiffp l=2.1e-6 w=700e-9 m=1
	xcc01 (net12 out) prim_cpoly c=1p m=1
	mnm12 (net13 net56 vssa vssa) nmos1 l=180n w=1u m=1
	mnm11 (net56 net56 vssa vssa) nmos1 l=1.2e-07n w=8.7e-07u m=1
	mnb02 (net27 net27 net21 vssa) nmos1 l=180n w=1u m=1
	mnpd1 (net21 xpd vssa vssa) nmos1 l=2.3e-07n w=2.0e-06u m=1
	mn001 (out net13 vssa vssa) nmos1 l=1.5e-07n w=1.3e-06u m=1
	mnpd2 (net13 pd vssa vssa) nmos1 l=2.7e-07n w=8.4e-07u m=1
	mnc01 (net13 net69 net12 vssa) nmos1 l=180n w=1u m=1
	mpb02 (net27 net51 net158 vdda) pmos1 l=180n w=1u m=1
	mppd1 (net158 xpd vdda vdda) pmos1 l=180n w=1u m=1
	mps11 (net31 net158 vdda vdda) pmos1 l=3.0e-07n w=1.8e-06u m=1
	mpd11 (net56 inn net31 net31) pmos1 l=180n w=1u m=1
	mp001 (out net158 vdda vdda) pmos1 l=180n w=1u m=1
	mpd12 (net13 inp net31 net31) pmos1 l=180n w=1u m=1
	mpb01 (net158 net158 vdda vdda) pmos1 l=180n w=1u m=1
ends OPAMP1_variant179

subckt OPAMP1_variant180 inn inp out pd xpd vdda vssa
	xd1 (vssa vdda) prim_nwd AREA=6.13907e-9 PJ=476.6e-6 m=1
	xi0 (vssa net69) prim_nd AREA=1e-12 PJ=4e-6 m=1
	xi3 (net51 vdda) prim_pd AREA=3.6e-09 PJ=3.2e-05 m=1
	xr0 (vssa vdda net51) prim_rdiffp l=2.1e-6 w=700e-9 m=1
	xr1 (vdda vdda net69) prim_rdiffp l=2.1e-6 w=700e-9 m=1
	xcc01 (net12 out) prim_cpoly c=1p m=1
	mnm12 (net13 net56 vssa vssa) nmos1 l=180n w=1u m=1
	mnm11 (net56 net56 vssa vssa) nmos1 l=180n w=1u m=1
	mnb02 (net27 net27 net21 vssa) nmos1 l=180n w=1u m=1
	mnpd1 (net21 xpd vssa vssa) nmos1 l=2.7e-07n w=1.8e-06u m=1
	mn001 (out net13 vssa vssa) nmos1 l=180n w=1u m=1
	mnpd2 (net13 pd vssa vssa) nmos1 l=180n w=1u m=1
	mnc01 (net13 net69 net12 vssa) nmos1 l=180n w=1u m=1
	mpb02 (net27 net51 net158 vdda) pmos1 l=180n w=1u m=1
	mppd1 (net158 xpd vdda vdda) pmos1 l=180n w=1u m=1
	mps11 (net31 net158 vdda vdda) pmos1 l=1.8e-07n w=1.6e-06u m=1
	mpd11 (net56 inn net31 net31) pmos1 l=180n w=1u m=1
	mp001 (out net158 vdda vdda) pmos1 l=2.9e-07n w=5.3e-07u m=1
	mpd12 (net13 inp net31 net31) pmos1 l=180n w=1u m=1
	mpb01 (net158 net158 vdda vdda) pmos1 l=180n w=1u m=1
ends OPAMP1_variant180

subckt OPAMP1_variant181 inn inp out pd xpd vdda vssa
	xd1 (vssa vdda) prim_nwd AREA=7.8e-09 PJ=1.1e-05 m=1
	xi0 (vssa net69) prim_nd AREA=1e-12 PJ=4e-6 m=1
	xi3 (net51 vdda) prim_pd AREA=790e-15 PJ=3.3e-6 m=1
	xr0 (vssa vdda net51) prim_rdiffp l=2.1e-6 w=700e-9 m=1
	xr1 (vdda vdda net69) prim_rdiffp l=2.1e-6 w=700e-9 m=1
	xcc01 (net12 out) prim_cpoly c=1p m=1
	mnm12 (net13 net56 vssa vssa) nmos1 l=180n w=1u m=1
	mnm11 (net56 net56 vssa vssa) nmos1 l=180n w=1u m=1
	mnb02 (net27 net27 net21 vssa) nmos1 l=180n w=1u m=1
	mnpd1 (net21 xpd vssa vssa) nmos1 l=180n w=1u m=1
	mn001 (out net13 vssa vssa) nmos1 l=180n w=1u m=1
	mnpd2 (net13 pd vssa vssa) nmos1 l=180n w=1u m=1
	mnc01 (net13 net69 net12 vssa) nmos1 l=180n w=1u m=1
	mpb02 (net27 net51 net158 vdda) pmos1 l=180n w=1u m=1
	mppd1 (net158 xpd vdda vdda) pmos1 l=180n w=1u m=1
	mps11 (net31 net158 vdda vdda) pmos1 l=180n w=1u m=1
	mpd11 (net56 inn net31 net31) pmos1 l=2.9e-07n w=6.0e-07u m=1
	mp001 (out net158 vdda vdda) pmos1 l=180n w=1u m=1
	mpd12 (net13 inp net31 net31) pmos1 l=1.2e-07n w=6.5e-07u m=1
	mpb01 (net158 net158 vdda vdda) pmos1 l=180n w=1u m=1
ends OPAMP1_variant181

subckt OPAMP1_variant182 inn inp out pd xpd vdda vssa
	xd1 (vssa vdda) prim_nwd AREA=6.13907e-9 PJ=476.6e-6 m=1
	xi0 (vssa net69) prim_nd AREA=1e-12 PJ=4e-6 m=1
	xi3 (net51 vdda) prim_pd AREA=790e-15 PJ=3.3e-6 m=1
	xr0 (vssa vdda net51) prim_rdiffp l=2.1e-6 w=700e-9 m=1
	xr1 (vdda vdda net69) prim_rdiffp l=2.1e-6 w=700e-9 m=1
	xcc01 (net12 out) prim_cpoly c=1.4e-12p m=1
	mnm12 (net13 net56 vssa vssa) nmos1 l=180n w=1u m=1
	mnm11 (net56 net56 vssa vssa) nmos1 l=180n w=1u m=1
	mnb02 (net27 net27 net21 vssa) nmos1 l=180n w=1u m=1
	mnpd1 (net21 xpd vssa vssa) nmos1 l=180n w=1u m=1
	mn001 (out net13 vssa vssa) nmos1 l=180n w=1u m=1
	mnpd2 (net13 pd vssa vssa) nmos1 l=180n w=1u m=1
	mnc01 (net13 net69 net12 vssa) nmos1 l=1.2e-07n w=1.7e-06u m=1
	mpb02 (net27 net51 net158 vdda) pmos1 l=1.5e-07n w=1.9e-06u m=1
	mppd1 (net158 xpd vdda vdda) pmos1 l=180n w=1u m=1
	mps11 (net31 net158 vdda vdda) pmos1 l=180n w=1u m=1
	mpd11 (net56 inn net31 net31) pmos1 l=180n w=1u m=1
	mp001 (out net158 vdda vdda) pmos1 l=180n w=1u m=1
	mpd12 (net13 inp net31 net31) pmos1 l=180n w=1u m=1
	mpb01 (net158 net158 vdda vdda) pmos1 l=2.3e-07n w=1.5e-06u m=1
ends OPAMP1_variant182

subckt OPAMP1_variant183 inn inp out pd xpd vdda vssa
	xd1 (vssa vdda) prim_nwd AREA=6.13907e-9 PJ=476.6e-6 m=1
	xi0 (vssa net69) prim_nd AREA=1e-12 PJ=4e-6 m=1
	xi3 (net51 vdda) prim_pd AREA=790e-15 PJ=3.3e-6 m=1
	xr0 (vssa vdda net51) prim_rdiffp l=2.9e-07 w=1.3e-06 m=1
	xr1 (vdda vdda net69) prim_rdiffp l=2.1e-6 w=700e-9 m=1
	xcc01 (net12 out) prim_cpoly c=1p m=1
	mnm12 (net13 net56 vssa vssa) nmos1 l=180n w=1u m=1
	mnm11 (net56 net56 vssa vssa) nmos1 l=3.0e-07n w=1.6e-06u m=1
	mnb02 (net27 net27 net21 vssa) nmos1 l=180n w=1u m=1
	mnpd1 (net21 xpd vssa vssa) nmos1 l=180n w=1u m=1
	mn001 (out net13 vssa vssa) nmos1 l=180n w=1u m=1
	mnpd2 (net13 pd vssa vssa) nmos1 l=2.6e-07n w=1.5e-06u m=1
	mnc01 (net13 net69 net12 vssa) nmos1 l=180n w=1u m=1
	mpb02 (net27 net51 net158 vdda) pmos1 l=180n w=1u m=1
	mppd1 (net158 xpd vdda vdda) pmos1 l=180n w=1u m=1
	mps11 (net31 net158 vdda vdda) pmos1 l=180n w=1u m=1
	mpd11 (net56 inn net31 net31) pmos1 l=180n w=1u m=1
	mp001 (out net158 vdda vdda) pmos1 l=2.8e-07n w=1.1e-06u m=1
	mpd12 (net13 inp net31 net31) pmos1 l=180n w=1u m=1
	mpb01 (net158 net158 vdda vdda) pmos1 l=180n w=1u m=1
ends OPAMP1_variant183

subckt OPAMP1_variant184 inn inp out pd xpd vdda vssa
	xd1 (vssa vdda) prim_nwd AREA=6.13907e-9 PJ=476.6e-6 m=1
	xi0 (vssa net69) prim_nd AREA=1e-12 PJ=4e-6 m=1
	xi3 (net51 vdda) prim_pd AREA=8.8e-09 PJ=7.5e-05 m=1
	xr0 (vssa vdda net51) prim_rdiffp l=2.1e-6 w=700e-9 m=1
	xr1 (vdda vdda net69) prim_rdiffp l=2.1e-6 w=700e-9 m=1
	xcc01 (net12 out) prim_cpoly c=1p m=1
	mnm12 (net13 net56 vssa vssa) nmos1 l=180n w=1u m=1
	mnm11 (net56 net56 vssa vssa) nmos1 l=180n w=1u m=1
	mnb02 (net27 net27 net21 vssa) nmos1 l=180n w=1u m=1
	mnpd1 (net21 xpd vssa vssa) nmos1 l=180n w=1u m=1
	mn001 (out net13 vssa vssa) nmos1 l=2.6e-07n w=1.8e-06u m=1
	mnpd2 (net13 pd vssa vssa) nmos1 l=180n w=1u m=1
	mnc01 (net13 net69 net12 vssa) nmos1 l=180n w=1u m=1
	mpb02 (net27 net51 net158 vdda) pmos1 l=180n w=1u m=1
	mppd1 (net158 xpd vdda vdda) pmos1 l=180n w=1u m=1
	mps11 (net31 net158 vdda vdda) pmos1 l=180n w=1u m=1
	mpd11 (net56 inn net31 net31) pmos1 l=180n w=1u m=1
	mp001 (out net158 vdda vdda) pmos1 l=180n w=1u m=1
	mpd12 (net13 inp net31 net31) pmos1 l=180n w=1u m=1
	mpb01 (net158 net158 vdda vdda) pmos1 l=180n w=1u m=1
ends OPAMP1_variant184

subckt OPAMP1_variant185 inn inp out pd xpd vdda vssa
	xd1 (vssa vdda) prim_nwd AREA=4.2e-09 PJ=3.0e-06 m=1
	xi0 (vssa net69) prim_nd AREA=1e-12 PJ=4e-6 m=1
	xi3 (net51 vdda) prim_pd AREA=790e-15 PJ=3.3e-6 m=1
	xr0 (vssa vdda net51) prim_rdiffp l=2.1e-6 w=700e-9 m=1
	xr1 (vdda vdda net69) prim_rdiffp l=2.1e-6 w=700e-9 m=1
	xcc01 (net12 out) prim_cpoly c=1p m=1
	mnm12 (net13 net56 vssa vssa) nmos1 l=180n w=1u m=1
	mnm11 (net56 net56 vssa vssa) nmos1 l=180n w=1u m=1
	mnb02 (net27 net27 net21 vssa) nmos1 l=180n w=1u m=1
	mnpd1 (net21 xpd vssa vssa) nmos1 l=180n w=1u m=1
	mn001 (out net13 vssa vssa) nmos1 l=180n w=1u m=1
	mnpd2 (net13 pd vssa vssa) nmos1 l=180n w=1u m=1
	mnc01 (net13 net69 net12 vssa) nmos1 l=180n w=1u m=1
	mpb02 (net27 net51 net158 vdda) pmos1 l=180n w=1u m=1
	mppd1 (net158 xpd vdda vdda) pmos1 l=180n w=1u m=1
	mps11 (net31 net158 vdda vdda) pmos1 l=180n w=1u m=1
	mpd11 (net56 inn net31 net31) pmos1 l=180n w=1u m=1
	mp001 (out net158 vdda vdda) pmos1 l=180n w=1u m=1
	mpd12 (net13 inp net31 net31) pmos1 l=2.2e-07n w=1.6e-06u m=1
	mpb01 (net158 net158 vdda vdda) pmos1 l=180n w=1u m=1
ends OPAMP1_variant185

subckt OPAMP1_variant186 inn inp out pd xpd vdda vssa
	xd1 (vssa vdda) prim_nwd AREA=6.13907e-9 PJ=476.6e-6 m=1
	xi0 (vssa net69) prim_nd AREA=1e-12 PJ=4e-6 m=1
	xi3 (net51 vdda) prim_pd AREA=790e-15 PJ=3.3e-6 m=1
	xr0 (vssa vdda net51) prim_rdiffp l=2.5e-07 w=1.2e-06 m=1
	xr1 (vdda vdda net69) prim_rdiffp l=2.1e-6 w=700e-9 m=1
	xcc01 (net12 out) prim_cpoly c=1p m=1
	mnm12 (net13 net56 vssa vssa) nmos1 l=180n w=1u m=1
	mnm11 (net56 net56 vssa vssa) nmos1 l=180n w=1u m=1
	mnb02 (net27 net27 net21 vssa) nmos1 l=180n w=1u m=1
	mnpd1 (net21 xpd vssa vssa) nmos1 l=180n w=1u m=1
	mn001 (out net13 vssa vssa) nmos1 l=180n w=1u m=1
	mnpd2 (net13 pd vssa vssa) nmos1 l=180n w=1u m=1
	mnc01 (net13 net69 net12 vssa) nmos1 l=180n w=1u m=1
	mpb02 (net27 net51 net158 vdda) pmos1 l=180n w=1u m=1
	mppd1 (net158 xpd vdda vdda) pmos1 l=180n w=1u m=1
	mps11 (net31 net158 vdda vdda) pmos1 l=180n w=1u m=1
	mpd11 (net56 inn net31 net31) pmos1 l=1.6e-07n w=1.2e-06u m=1
	mp001 (out net158 vdda vdda) pmos1 l=2.2e-07n w=1.7e-06u m=1
	mpd12 (net13 inp net31 net31) pmos1 l=180n w=1u m=1
	mpb01 (net158 net158 vdda vdda) pmos1 l=180n w=1u m=1
ends OPAMP1_variant186

subckt OPAMP1_variant187 inn inp out pd xpd vdda vssa
	xd1 (vssa vdda) prim_nwd AREA=4.1e-09 PJ=9.5e-05 m=1
	xi0 (vssa net69) prim_nd AREA=2.1e-09 PJ=5.4e-05 m=1
	xi3 (net51 vdda) prim_pd AREA=790e-15 PJ=3.3e-6 m=1
	xr0 (vssa vdda net51) prim_rdiffp l=2.1e-6 w=700e-9 m=1
	xr1 (vdda vdda net69) prim_rdiffp l=2.1e-6 w=700e-9 m=1
	xcc01 (net12 out) prim_cpoly c=1p m=1
	mnm12 (net13 net56 vssa vssa) nmos1 l=180n w=1u m=1
	mnm11 (net56 net56 vssa vssa) nmos1 l=180n w=1u m=1
	mnb02 (net27 net27 net21 vssa) nmos1 l=180n w=1u m=1
	mnpd1 (net21 xpd vssa vssa) nmos1 l=180n w=1u m=1
	mn001 (out net13 vssa vssa) nmos1 l=180n w=1u m=1
	mnpd2 (net13 pd vssa vssa) nmos1 l=180n w=1u m=1
	mnc01 (net13 net69 net12 vssa) nmos1 l=180n w=1u m=1
	mpb02 (net27 net51 net158 vdda) pmos1 l=1.6e-07n w=1.9e-06u m=1
	mppd1 (net158 xpd vdda vdda) pmos1 l=180n w=1u m=1
	mps11 (net31 net158 vdda vdda) pmos1 l=180n w=1u m=1
	mpd11 (net56 inn net31 net31) pmos1 l=1.7e-07n w=5.5e-07u m=1
	mp001 (out net158 vdda vdda) pmos1 l=180n w=1u m=1
	mpd12 (net13 inp net31 net31) pmos1 l=180n w=1u m=1
	mpb01 (net158 net158 vdda vdda) pmos1 l=180n w=1u m=1
ends OPAMP1_variant187

subckt OPAMP1_variant188 inn inp out pd xpd vdda vssa
	xd1 (vssa vdda) prim_nwd AREA=5.5e-10 PJ=7.6e-05 m=1
	xi0 (vssa net69) prim_nd AREA=5.9e-09 PJ=5.7e-05 m=1
	xi3 (net51 vdda) prim_pd AREA=790e-15 PJ=3.3e-6 m=1
	xr0 (vssa vdda net51) prim_rdiffp l=2.1e-6 w=700e-9 m=1
	xr1 (vdda vdda net69) prim_rdiffp l=2.1e-6 w=700e-9 m=1
	xcc01 (net12 out) prim_cpoly c=1p m=1
	mnm12 (net13 net56 vssa vssa) nmos1 l=180n w=1u m=1
	mnm11 (net56 net56 vssa vssa) nmos1 l=180n w=1u m=1
	mnb02 (net27 net27 net21 vssa) nmos1 l=180n w=1u m=1
	mnpd1 (net21 xpd vssa vssa) nmos1 l=180n w=1u m=1
	mn001 (out net13 vssa vssa) nmos1 l=180n w=1u m=1
	mnpd2 (net13 pd vssa vssa) nmos1 l=180n w=1u m=1
	mnc01 (net13 net69 net12 vssa) nmos1 l=180n w=1u m=1
	mpb02 (net27 net51 net158 vdda) pmos1 l=180n w=1u m=1
	mppd1 (net158 xpd vdda vdda) pmos1 l=180n w=1u m=1
	mps11 (net31 net158 vdda vdda) pmos1 l=180n w=1u m=1
	mpd11 (net56 inn net31 net31) pmos1 l=180n w=1u m=1
	mp001 (out net158 vdda vdda) pmos1 l=180n w=1u m=1
	mpd12 (net13 inp net31 net31) pmos1 l=1.5e-07n w=1.3e-06u m=1
	mpb01 (net158 net158 vdda vdda) pmos1 l=180n w=1u m=1
ends OPAMP1_variant188

subckt OPAMP1_variant189 inn inp out pd xpd vdda vssa
	xd1 (vssa vdda) prim_nwd AREA=6.13907e-9 PJ=476.6e-6 m=1
	xi0 (vssa net69) prim_nd AREA=1e-12 PJ=4e-6 m=1
	xi3 (net51 vdda) prim_pd AREA=790e-15 PJ=3.3e-6 m=1
	xr0 (vssa vdda net51) prim_rdiffp l=2.9e-07 w=1.1e-06 m=1
	xr1 (vdda vdda net69) prim_rdiffp l=2.1e-6 w=700e-9 m=1
	xcc01 (net12 out) prim_cpoly c=1p m=1
	mnm12 (net13 net56 vssa vssa) nmos1 l=180n w=1u m=1
	mnm11 (net56 net56 vssa vssa) nmos1 l=2.6e-07n w=1.5e-06u m=1
	mnb02 (net27 net27 net21 vssa) nmos1 l=180n w=1u m=1
	mnpd1 (net21 xpd vssa vssa) nmos1 l=180n w=1u m=1
	mn001 (out net13 vssa vssa) nmos1 l=180n w=1u m=1
	mnpd2 (net13 pd vssa vssa) nmos1 l=180n w=1u m=1
	mnc01 (net13 net69 net12 vssa) nmos1 l=180n w=1u m=1
	mpb02 (net27 net51 net158 vdda) pmos1 l=180n w=1u m=1
	mppd1 (net158 xpd vdda vdda) pmos1 l=180n w=1u m=1
	mps11 (net31 net158 vdda vdda) pmos1 l=180n w=1u m=1
	mpd11 (net56 inn net31 net31) pmos1 l=1.6e-07n w=2.0e-06u m=1
	mp001 (out net158 vdda vdda) pmos1 l=180n w=1u m=1
	mpd12 (net13 inp net31 net31) pmos1 l=180n w=1u m=1
	mpb01 (net158 net158 vdda vdda) pmos1 l=180n w=1u m=1
ends OPAMP1_variant189

subckt OPAMP1_variant190 inn inp out pd xpd vdda vssa
	xd1 (vssa vdda) prim_nwd AREA=6.13907e-9 PJ=476.6e-6 m=1
	xi0 (vssa net69) prim_nd AREA=1e-12 PJ=4e-6 m=1
	xi3 (net51 vdda) prim_pd AREA=790e-15 PJ=3.3e-6 m=1
	xr0 (vssa vdda net51) prim_rdiffp l=2.1e-6 w=700e-9 m=1
	xr1 (vdda vdda net69) prim_rdiffp l=2.1e-6 w=700e-9 m=1
	xcc01 (net12 out) prim_cpoly c=1p m=1
	mnm12 (net13 net56 vssa vssa) nmos1 l=1.9e-07n w=9.3e-07u m=1
	mnm11 (net56 net56 vssa vssa) nmos1 l=180n w=1u m=1
	mnb02 (net27 net27 net21 vssa) nmos1 l=180n w=1u m=1
	mnpd1 (net21 xpd vssa vssa) nmos1 l=180n w=1u m=1
	mn001 (out net13 vssa vssa) nmos1 l=180n w=1u m=1
	mnpd2 (net13 pd vssa vssa) nmos1 l=180n w=1u m=1
	mnc01 (net13 net69 net12 vssa) nmos1 l=2.1e-07n w=1.2e-06u m=1
	mpb02 (net27 net51 net158 vdda) pmos1 l=180n w=1u m=1
	mppd1 (net158 xpd vdda vdda) pmos1 l=180n w=1u m=1
	mps11 (net31 net158 vdda vdda) pmos1 l=1.2e-07n w=9.0e-07u m=1
	mpd11 (net56 inn net31 net31) pmos1 l=180n w=1u m=1
	mp001 (out net158 vdda vdda) pmos1 l=180n w=1u m=1
	mpd12 (net13 inp net31 net31) pmos1 l=180n w=1u m=1
	mpb01 (net158 net158 vdda vdda) pmos1 l=180n w=1u m=1
ends OPAMP1_variant190

subckt OPAMP1_variant191 inn inp out pd xpd vdda vssa
	xd1 (vssa vdda) prim_nwd AREA=1.5e-09 PJ=2.3e-05 m=1
	xi0 (vssa net69) prim_nd AREA=1e-12 PJ=4e-6 m=1
	xi3 (net51 vdda) prim_pd AREA=790e-15 PJ=3.3e-6 m=1
	xr0 (vssa vdda net51) prim_rdiffp l=2.1e-6 w=700e-9 m=1
	xr1 (vdda vdda net69) prim_rdiffp l=2.1e-6 w=700e-9 m=1
	xcc01 (net12 out) prim_cpoly c=1p m=1
	mnm12 (net13 net56 vssa vssa) nmos1 l=180n w=1u m=1
	mnm11 (net56 net56 vssa vssa) nmos1 l=180n w=1u m=1
	mnb02 (net27 net27 net21 vssa) nmos1 l=180n w=1u m=1
	mnpd1 (net21 xpd vssa vssa) nmos1 l=180n w=1u m=1
	mn001 (out net13 vssa vssa) nmos1 l=2.1e-07n w=1.9e-06u m=1
	mnpd2 (net13 pd vssa vssa) nmos1 l=1.4e-07n w=1.3e-06u m=1
	mnc01 (net13 net69 net12 vssa) nmos1 l=180n w=1u m=1
	mpb02 (net27 net51 net158 vdda) pmos1 l=1.2e-07n w=5.9e-07u m=1
	mppd1 (net158 xpd vdda vdda) pmos1 l=180n w=1u m=1
	mps11 (net31 net158 vdda vdda) pmos1 l=180n w=1u m=1
	mpd11 (net56 inn net31 net31) pmos1 l=180n w=1u m=1
	mp001 (out net158 vdda vdda) pmos1 l=2.3e-07n w=1.0e-06u m=1
	mpd12 (net13 inp net31 net31) pmos1 l=180n w=1u m=1
	mpb01 (net158 net158 vdda vdda) pmos1 l=180n w=1u m=1
ends OPAMP1_variant191

subckt OPAMP1_variant192 inn inp out pd xpd vdda vssa
	xd1 (vssa vdda) prim_nwd AREA=6.13907e-9 PJ=476.6e-6 m=1
	xi0 (vssa net69) prim_nd AREA=1e-12 PJ=4e-6 m=1
	xi3 (net51 vdda) prim_pd AREA=790e-15 PJ=3.3e-6 m=1
	xr0 (vssa vdda net51) prim_rdiffp l=1.1e-07 w=1.8e-06 m=1
	xr1 (vdda vdda net69) prim_rdiffp l=2.1e-6 w=700e-9 m=1
	xcc01 (net12 out) prim_cpoly c=1p m=1
	mnm12 (net13 net56 vssa vssa) nmos1 l=180n w=1u m=1
	mnm11 (net56 net56 vssa vssa) nmos1 l=180n w=1u m=1
	mnb02 (net27 net27 net21 vssa) nmos1 l=180n w=1u m=1
	mnpd1 (net21 xpd vssa vssa) nmos1 l=2.5e-07n w=1.7e-06u m=1
	mn001 (out net13 vssa vssa) nmos1 l=180n w=1u m=1
	mnpd2 (net13 pd vssa vssa) nmos1 l=2.2e-07n w=1.1e-06u m=1
	mnc01 (net13 net69 net12 vssa) nmos1 l=180n w=1u m=1
	mpb02 (net27 net51 net158 vdda) pmos1 l=180n w=1u m=1
	mppd1 (net158 xpd vdda vdda) pmos1 l=1.6e-07n w=1.7e-06u m=1
	mps11 (net31 net158 vdda vdda) pmos1 l=2.0e-07n w=1.2e-06u m=1
	mpd11 (net56 inn net31 net31) pmos1 l=180n w=1u m=1
	mp001 (out net158 vdda vdda) pmos1 l=180n w=1u m=1
	mpd12 (net13 inp net31 net31) pmos1 l=180n w=1u m=1
	mpb01 (net158 net158 vdda vdda) pmos1 l=180n w=1u m=1
ends OPAMP1_variant192

subckt OPAMP1_variant193 inn inp out pd xpd vdda vssa
	xd1 (vssa vdda) prim_nwd AREA=6.13907e-9 PJ=476.6e-6 m=1
	xi0 (vssa net69) prim_nd AREA=1e-12 PJ=4e-6 m=1
	xi3 (net51 vdda) prim_pd AREA=790e-15 PJ=3.3e-6 m=1
	xr0 (vssa vdda net51) prim_rdiffp l=2.1e-6 w=700e-9 m=1
	xr1 (vdda vdda net69) prim_rdiffp l=2.1e-6 w=700e-9 m=1
	xcc01 (net12 out) prim_cpoly c=1.5e-12p m=1
	mnm12 (net13 net56 vssa vssa) nmos1 l=180n w=1u m=1
	mnm11 (net56 net56 vssa vssa) nmos1 l=180n w=1u m=1
	mnb02 (net27 net27 net21 vssa) nmos1 l=180n w=1u m=1
	mnpd1 (net21 xpd vssa vssa) nmos1 l=180n w=1u m=1
	mn001 (out net13 vssa vssa) nmos1 l=180n w=1u m=1
	mnpd2 (net13 pd vssa vssa) nmos1 l=1.6e-07n w=1.0e-06u m=1
	mnc01 (net13 net69 net12 vssa) nmos1 l=180n w=1u m=1
	mpb02 (net27 net51 net158 vdda) pmos1 l=180n w=1u m=1
	mppd1 (net158 xpd vdda vdda) pmos1 l=180n w=1u m=1
	mps11 (net31 net158 vdda vdda) pmos1 l=180n w=1u m=1
	mpd11 (net56 inn net31 net31) pmos1 l=180n w=1u m=1
	mp001 (out net158 vdda vdda) pmos1 l=1.1e-07n w=9.1e-07u m=1
	mpd12 (net13 inp net31 net31) pmos1 l=180n w=1u m=1
	mpb01 (net158 net158 vdda vdda) pmos1 l=180n w=1u m=1
ends OPAMP1_variant193

subckt OPAMP1_variant194 inn inp out pd xpd vdda vssa
	xd1 (vssa vdda) prim_nwd AREA=6.13907e-9 PJ=476.6e-6 m=1
	xi0 (vssa net69) prim_nd AREA=1e-12 PJ=4e-6 m=1
	xi3 (net51 vdda) prim_pd AREA=790e-15 PJ=3.3e-6 m=1
	xr0 (vssa vdda net51) prim_rdiffp l=2.1e-6 w=700e-9 m=1
	xr1 (vdda vdda net69) prim_rdiffp l=2.1e-6 w=700e-9 m=1
	xcc01 (net12 out) prim_cpoly c=1p m=1
	mnm12 (net13 net56 vssa vssa) nmos1 l=180n w=1u m=1
	mnm11 (net56 net56 vssa vssa) nmos1 l=180n w=1u m=1
	mnb02 (net27 net27 net21 vssa) nmos1 l=180n w=1u m=1
	mnpd1 (net21 xpd vssa vssa) nmos1 l=180n w=1u m=1
	mn001 (out net13 vssa vssa) nmos1 l=180n w=1u m=1
	mnpd2 (net13 pd vssa vssa) nmos1 l=1.3e-07n w=1.0e-06u m=1
	mnc01 (net13 net69 net12 vssa) nmos1 l=180n w=1u m=1
	mpb02 (net27 net51 net158 vdda) pmos1 l=180n w=1u m=1
	mppd1 (net158 xpd vdda vdda) pmos1 l=180n w=1u m=1
	mps11 (net31 net158 vdda vdda) pmos1 l=180n w=1u m=1
	mpd11 (net56 inn net31 net31) pmos1 l=180n w=1u m=1
	mp001 (out net158 vdda vdda) pmos1 l=2.8e-07n w=1.8e-06u m=1
	mpd12 (net13 inp net31 net31) pmos1 l=180n w=1u m=1
	mpb01 (net158 net158 vdda vdda) pmos1 l=180n w=1u m=1
ends OPAMP1_variant194

subckt OPAMP1_variant195 inn inp out pd xpd vdda vssa
	xd1 (vssa vdda) prim_nwd AREA=6.13907e-9 PJ=476.6e-6 m=1
	xi0 (vssa net69) prim_nd AREA=1e-12 PJ=4e-6 m=1
	xi3 (net51 vdda) prim_pd AREA=790e-15 PJ=3.3e-6 m=1
	xr0 (vssa vdda net51) prim_rdiffp l=2.1e-6 w=700e-9 m=1
	xr1 (vdda vdda net69) prim_rdiffp l=2.1e-6 w=700e-9 m=1
	xcc01 (net12 out) prim_cpoly c=1.6e-12p m=1
	mnm12 (net13 net56 vssa vssa) nmos1 l=180n w=1u m=1
	mnm11 (net56 net56 vssa vssa) nmos1 l=180n w=1u m=1
	mnb02 (net27 net27 net21 vssa) nmos1 l=180n w=1u m=1
	mnpd1 (net21 xpd vssa vssa) nmos1 l=180n w=1u m=1
	mn001 (out net13 vssa vssa) nmos1 l=180n w=1u m=1
	mnpd2 (net13 pd vssa vssa) nmos1 l=180n w=1u m=1
	mnc01 (net13 net69 net12 vssa) nmos1 l=180n w=1u m=1
	mpb02 (net27 net51 net158 vdda) pmos1 l=180n w=1u m=1
	mppd1 (net158 xpd vdda vdda) pmos1 l=180n w=1u m=1
	mps11 (net31 net158 vdda vdda) pmos1 l=1.1e-07n w=1.5e-06u m=1
	mpd11 (net56 inn net31 net31) pmos1 l=180n w=1u m=1
	mp001 (out net158 vdda vdda) pmos1 l=180n w=1u m=1
	mpd12 (net13 inp net31 net31) pmos1 l=2.0e-07n w=1.7e-06u m=1
	mpb01 (net158 net158 vdda vdda) pmos1 l=2.2e-07n w=1.7e-06u m=1
ends OPAMP1_variant195

subckt OPAMP1_variant196 inn inp out pd xpd vdda vssa
	xd1 (vssa vdda) prim_nwd AREA=8.5e-10 PJ=4.9e-05 m=1
	xi0 (vssa net69) prim_nd AREA=7.7e-09 PJ=2.8e-05 m=1
	xi3 (net51 vdda) prim_pd AREA=7.9e-09 PJ=8.6e-05 m=1
	xr0 (vssa vdda net51) prim_rdiffp l=2.1e-6 w=700e-9 m=1
	xr1 (vdda vdda net69) prim_rdiffp l=2.1e-6 w=700e-9 m=1
	xcc01 (net12 out) prim_cpoly c=1p m=1
	mnm12 (net13 net56 vssa vssa) nmos1 l=180n w=1u m=1
	mnm11 (net56 net56 vssa vssa) nmos1 l=180n w=1u m=1
	mnb02 (net27 net27 net21 vssa) nmos1 l=180n w=1u m=1
	mnpd1 (net21 xpd vssa vssa) nmos1 l=180n w=1u m=1
	mn001 (out net13 vssa vssa) nmos1 l=180n w=1u m=1
	mnpd2 (net13 pd vssa vssa) nmos1 l=180n w=1u m=1
	mnc01 (net13 net69 net12 vssa) nmos1 l=180n w=1u m=1
	mpb02 (net27 net51 net158 vdda) pmos1 l=180n w=1u m=1
	mppd1 (net158 xpd vdda vdda) pmos1 l=2.6e-07n w=1.6e-06u m=1
	mps11 (net31 net158 vdda vdda) pmos1 l=180n w=1u m=1
	mpd11 (net56 inn net31 net31) pmos1 l=180n w=1u m=1
	mp001 (out net158 vdda vdda) pmos1 l=2.5e-07n w=1.3e-06u m=1
	mpd12 (net13 inp net31 net31) pmos1 l=180n w=1u m=1
	mpb01 (net158 net158 vdda vdda) pmos1 l=180n w=1u m=1
ends OPAMP1_variant196

subckt OPAMP1_variant197 inn inp out pd xpd vdda vssa
	xd1 (vssa vdda) prim_nwd AREA=6.13907e-9 PJ=476.6e-6 m=1
	xi0 (vssa net69) prim_nd AREA=1e-12 PJ=4e-6 m=1
	xi3 (net51 vdda) prim_pd AREA=790e-15 PJ=3.3e-6 m=1
	xr0 (vssa vdda net51) prim_rdiffp l=2.1e-6 w=700e-9 m=1
	xr1 (vdda vdda net69) prim_rdiffp l=2.1e-6 w=700e-9 m=1
	xcc01 (net12 out) prim_cpoly c=1.7e-12p m=1
	mnm12 (net13 net56 vssa vssa) nmos1 l=180n w=1u m=1
	mnm11 (net56 net56 vssa vssa) nmos1 l=180n w=1u m=1
	mnb02 (net27 net27 net21 vssa) nmos1 l=180n w=1u m=1
	mnpd1 (net21 xpd vssa vssa) nmos1 l=180n w=1u m=1
	mn001 (out net13 vssa vssa) nmos1 l=180n w=1u m=1
	mnpd2 (net13 pd vssa vssa) nmos1 l=180n w=1u m=1
	mnc01 (net13 net69 net12 vssa) nmos1 l=180n w=1u m=1
	mpb02 (net27 net51 net158 vdda) pmos1 l=180n w=1u m=1
	mppd1 (net158 xpd vdda vdda) pmos1 l=180n w=1u m=1
	mps11 (net31 net158 vdda vdda) pmos1 l=180n w=1u m=1
	mpd11 (net56 inn net31 net31) pmos1 l=180n w=1u m=1
	mp001 (out net158 vdda vdda) pmos1 l=180n w=1u m=1
	mpd12 (net13 inp net31 net31) pmos1 l=2.0e-07n w=1.6e-06u m=1
	mpb01 (net158 net158 vdda vdda) pmos1 l=2.6e-07n w=1.2e-06u m=1
ends OPAMP1_variant197

subckt OPAMP1_variant198 inn inp out pd xpd vdda vssa
	xd1 (vssa vdda) prim_nwd AREA=6.13907e-9 PJ=476.6e-6 m=1
	xi0 (vssa net69) prim_nd AREA=1e-12 PJ=4e-6 m=1
	xi3 (net51 vdda) prim_pd AREA=790e-15 PJ=3.3e-6 m=1
	xr0 (vssa vdda net51) prim_rdiffp l=2.1e-6 w=700e-9 m=1
	xr1 (vdda vdda net69) prim_rdiffp l=2.9e-07 w=7.8e-07 m=1
	xcc01 (net12 out) prim_cpoly c=1p m=1
	mnm12 (net13 net56 vssa vssa) nmos1 l=180n w=1u m=1
	mnm11 (net56 net56 vssa vssa) nmos1 l=180n w=1u m=1
	mnb02 (net27 net27 net21 vssa) nmos1 l=180n w=1u m=1
	mnpd1 (net21 xpd vssa vssa) nmos1 l=180n w=1u m=1
	mn001 (out net13 vssa vssa) nmos1 l=180n w=1u m=1
	mnpd2 (net13 pd vssa vssa) nmos1 l=2.1e-07n w=6.0e-07u m=1
	mnc01 (net13 net69 net12 vssa) nmos1 l=180n w=1u m=1
	mpb02 (net27 net51 net158 vdda) pmos1 l=180n w=1u m=1
	mppd1 (net158 xpd vdda vdda) pmos1 l=180n w=1u m=1
	mps11 (net31 net158 vdda vdda) pmos1 l=1.5e-07n w=1.0e-06u m=1
	mpd11 (net56 inn net31 net31) pmos1 l=180n w=1u m=1
	mp001 (out net158 vdda vdda) pmos1 l=180n w=1u m=1
	mpd12 (net13 inp net31 net31) pmos1 l=180n w=1u m=1
	mpb01 (net158 net158 vdda vdda) pmos1 l=180n w=1u m=1
ends OPAMP1_variant198

subckt OPAMP1_variant199 inn inp out pd xpd vdda vssa
	xd1 (vssa vdda) prim_nwd AREA=6.13907e-9 PJ=476.6e-6 m=1
	xi0 (vssa net69) prim_nd AREA=3.9e-09 PJ=4.7e-05 m=1
	xi3 (net51 vdda) prim_pd AREA=790e-15 PJ=3.3e-6 m=1
	xr0 (vssa vdda net51) prim_rdiffp l=2.1e-6 w=700e-9 m=1
	xr1 (vdda vdda net69) prim_rdiffp l=1.7e-07 w=1.0e-06 m=1
	xcc01 (net12 out) prim_cpoly c=1.7e-12p m=1
	mnm12 (net13 net56 vssa vssa) nmos1 l=180n w=1u m=1
	mnm11 (net56 net56 vssa vssa) nmos1 l=180n w=1u m=1
	mnb02 (net27 net27 net21 vssa) nmos1 l=180n w=1u m=1
	mnpd1 (net21 xpd vssa vssa) nmos1 l=180n w=1u m=1
	mn001 (out net13 vssa vssa) nmos1 l=180n w=1u m=1
	mnpd2 (net13 pd vssa vssa) nmos1 l=180n w=1u m=1
	mnc01 (net13 net69 net12 vssa) nmos1 l=180n w=1u m=1
	mpb02 (net27 net51 net158 vdda) pmos1 l=180n w=1u m=1
	mppd1 (net158 xpd vdda vdda) pmos1 l=180n w=1u m=1
	mps11 (net31 net158 vdda vdda) pmos1 l=180n w=1u m=1
	mpd11 (net56 inn net31 net31) pmos1 l=180n w=1u m=1
	mp001 (out net158 vdda vdda) pmos1 l=180n w=1u m=1
	mpd12 (net13 inp net31 net31) pmos1 l=180n w=1u m=1
	mpb01 (net158 net158 vdda vdda) pmos1 l=180n w=1u m=1
ends OPAMP1_variant199

subckt OPAMP1_variant200 inn inp out pd xpd vdda vssa
	xd1 (vssa vdda) prim_nwd AREA=6.13907e-9 PJ=476.6e-6 m=1
	xi0 (vssa net69) prim_nd AREA=1e-12 PJ=4e-6 m=1
	xi3 (net51 vdda) prim_pd AREA=790e-15 PJ=3.3e-6 m=1
	xr0 (vssa vdda net51) prim_rdiffp l=2.1e-6 w=700e-9 m=1
	xr1 (vdda vdda net69) prim_rdiffp l=2.1e-6 w=700e-9 m=1
	xcc01 (net12 out) prim_cpoly c=1p m=1
	mnm12 (net13 net56 vssa vssa) nmos1 l=1.2e-07n w=1.7e-06u m=1
	mnm11 (net56 net56 vssa vssa) nmos1 l=1.9e-07n w=1.7e-06u m=1
	mnb02 (net27 net27 net21 vssa) nmos1 l=180n w=1u m=1
	mnpd1 (net21 xpd vssa vssa) nmos1 l=2.2e-07n w=2.0e-06u m=1
	mn001 (out net13 vssa vssa) nmos1 l=180n w=1u m=1
	mnpd2 (net13 pd vssa vssa) nmos1 l=2.3e-07n w=1.1e-06u m=1
	mnc01 (net13 net69 net12 vssa) nmos1 l=180n w=1u m=1
	mpb02 (net27 net51 net158 vdda) pmos1 l=180n w=1u m=1
	mppd1 (net158 xpd vdda vdda) pmos1 l=180n w=1u m=1
	mps11 (net31 net158 vdda vdda) pmos1 l=180n w=1u m=1
	mpd11 (net56 inn net31 net31) pmos1 l=180n w=1u m=1
	mp001 (out net158 vdda vdda) pmos1 l=180n w=1u m=1
	mpd12 (net13 inp net31 net31) pmos1 l=180n w=1u m=1
	mpb01 (net158 net158 vdda vdda) pmos1 l=180n w=1u m=1
ends OPAMP1_variant200

subckt OPAMP1_variant201 inn inp out pd xpd vdda vssa
	xd1 (vssa vdda) prim_nwd AREA=7.6e-09 PJ=7.0e-05 m=1
	xi0 (vssa net69) prim_nd AREA=1e-12 PJ=4e-6 m=1
	xi3 (net51 vdda) prim_pd AREA=790e-15 PJ=3.3e-6 m=1
	xr0 (vssa vdda net51) prim_rdiffp l=2.1e-6 w=700e-9 m=1
	xr1 (vdda vdda net69) prim_rdiffp l=2.1e-6 w=700e-9 m=1
	xcc01 (net12 out) prim_cpoly c=1p m=1
	mnm12 (net13 net56 vssa vssa) nmos1 l=180n w=1u m=1
	mnm11 (net56 net56 vssa vssa) nmos1 l=180n w=1u m=1
	mnb02 (net27 net27 net21 vssa) nmos1 l=180n w=1u m=1
	mnpd1 (net21 xpd vssa vssa) nmos1 l=180n w=1u m=1
	mn001 (out net13 vssa vssa) nmos1 l=180n w=1u m=1
	mnpd2 (net13 pd vssa vssa) nmos1 l=180n w=1u m=1
	mnc01 (net13 net69 net12 vssa) nmos1 l=180n w=1u m=1
	mpb02 (net27 net51 net158 vdda) pmos1 l=2.5e-07n w=5.8e-07u m=1
	mppd1 (net158 xpd vdda vdda) pmos1 l=180n w=1u m=1
	mps11 (net31 net158 vdda vdda) pmos1 l=2.1e-07n w=9.9e-07u m=1
	mpd11 (net56 inn net31 net31) pmos1 l=180n w=1u m=1
	mp001 (out net158 vdda vdda) pmos1 l=180n w=1u m=1
	mpd12 (net13 inp net31 net31) pmos1 l=180n w=1u m=1
	mpb01 (net158 net158 vdda vdda) pmos1 l=180n w=1u m=1
ends OPAMP1_variant201

subckt OPAMP1_variant202 inn inp out pd xpd vdda vssa
	xd1 (vssa vdda) prim_nwd AREA=8.7e-10 PJ=9.7e-05 m=1
	xi0 (vssa net69) prim_nd AREA=1e-12 PJ=4e-6 m=1
	xi3 (net51 vdda) prim_pd AREA=790e-15 PJ=3.3e-6 m=1
	xr0 (vssa vdda net51) prim_rdiffp l=2.1e-6 w=700e-9 m=1
	xr1 (vdda vdda net69) prim_rdiffp l=2.1e-6 w=700e-9 m=1
	xcc01 (net12 out) prim_cpoly c=1p m=1
	mnm12 (net13 net56 vssa vssa) nmos1 l=2.7e-07n w=6.5e-07u m=1
	mnm11 (net56 net56 vssa vssa) nmos1 l=2.5e-07n w=1.2e-06u m=1
	mnb02 (net27 net27 net21 vssa) nmos1 l=180n w=1u m=1
	mnpd1 (net21 xpd vssa vssa) nmos1 l=180n w=1u m=1
	mn001 (out net13 vssa vssa) nmos1 l=180n w=1u m=1
	mnpd2 (net13 pd vssa vssa) nmos1 l=180n w=1u m=1
	mnc01 (net13 net69 net12 vssa) nmos1 l=180n w=1u m=1
	mpb02 (net27 net51 net158 vdda) pmos1 l=180n w=1u m=1
	mppd1 (net158 xpd vdda vdda) pmos1 l=180n w=1u m=1
	mps11 (net31 net158 vdda vdda) pmos1 l=2.2e-07n w=8.6e-07u m=1
	mpd11 (net56 inn net31 net31) pmos1 l=1.8e-07n w=1.3e-06u m=1
	mp001 (out net158 vdda vdda) pmos1 l=180n w=1u m=1
	mpd12 (net13 inp net31 net31) pmos1 l=180n w=1u m=1
	mpb01 (net158 net158 vdda vdda) pmos1 l=180n w=1u m=1
ends OPAMP1_variant202

subckt OPAMP1_variant203 inn inp out pd xpd vdda vssa
	xd1 (vssa vdda) prim_nwd AREA=6.13907e-9 PJ=476.6e-6 m=1
	xi0 (vssa net69) prim_nd AREA=1e-12 PJ=4e-6 m=1
	xi3 (net51 vdda) prim_pd AREA=790e-15 PJ=3.3e-6 m=1
	xr0 (vssa vdda net51) prim_rdiffp l=2.2e-07 w=1.5e-06 m=1
	xr1 (vdda vdda net69) prim_rdiffp l=2.1e-6 w=700e-9 m=1
	xcc01 (net12 out) prim_cpoly c=1p m=1
	mnm12 (net13 net56 vssa vssa) nmos1 l=1.1e-07n w=9.8e-07u m=1
	mnm11 (net56 net56 vssa vssa) nmos1 l=180n w=1u m=1
	mnb02 (net27 net27 net21 vssa) nmos1 l=180n w=1u m=1
	mnpd1 (net21 xpd vssa vssa) nmos1 l=180n w=1u m=1
	mn001 (out net13 vssa vssa) nmos1 l=180n w=1u m=1
	mnpd2 (net13 pd vssa vssa) nmos1 l=180n w=1u m=1
	mnc01 (net13 net69 net12 vssa) nmos1 l=180n w=1u m=1
	mpb02 (net27 net51 net158 vdda) pmos1 l=180n w=1u m=1
	mppd1 (net158 xpd vdda vdda) pmos1 l=180n w=1u m=1
	mps11 (net31 net158 vdda vdda) pmos1 l=1.2e-07n w=1.7e-06u m=1
	mpd11 (net56 inn net31 net31) pmos1 l=180n w=1u m=1
	mp001 (out net158 vdda vdda) pmos1 l=180n w=1u m=1
	mpd12 (net13 inp net31 net31) pmos1 l=180n w=1u m=1
	mpb01 (net158 net158 vdda vdda) pmos1 l=1.6e-07n w=1.6e-06u m=1
ends OPAMP1_variant203

subckt OPAMP1_variant204 inn inp out pd xpd vdda vssa
	xd1 (vssa vdda) prim_nwd AREA=6.13907e-9 PJ=476.6e-6 m=1
	xi0 (vssa net69) prim_nd AREA=1e-12 PJ=4e-6 m=1
	xi3 (net51 vdda) prim_pd AREA=790e-15 PJ=3.3e-6 m=1
	xr0 (vssa vdda net51) prim_rdiffp l=2.3e-07 w=1.2e-06 m=1
	xr1 (vdda vdda net69) prim_rdiffp l=2.1e-6 w=700e-9 m=1
	xcc01 (net12 out) prim_cpoly c=8.9e-13p m=1
	mnm12 (net13 net56 vssa vssa) nmos1 l=180n w=1u m=1
	mnm11 (net56 net56 vssa vssa) nmos1 l=180n w=1u m=1
	mnb02 (net27 net27 net21 vssa) nmos1 l=180n w=1u m=1
	mnpd1 (net21 xpd vssa vssa) nmos1 l=1.1e-07n w=8.8e-07u m=1
	mn001 (out net13 vssa vssa) nmos1 l=180n w=1u m=1
	mnpd2 (net13 pd vssa vssa) nmos1 l=180n w=1u m=1
	mnc01 (net13 net69 net12 vssa) nmos1 l=180n w=1u m=1
	mpb02 (net27 net51 net158 vdda) pmos1 l=180n w=1u m=1
	mppd1 (net158 xpd vdda vdda) pmos1 l=180n w=1u m=1
	mps11 (net31 net158 vdda vdda) pmos1 l=180n w=1u m=1
	mpd11 (net56 inn net31 net31) pmos1 l=180n w=1u m=1
	mp001 (out net158 vdda vdda) pmos1 l=180n w=1u m=1
	mpd12 (net13 inp net31 net31) pmos1 l=180n w=1u m=1
	mpb01 (net158 net158 vdda vdda) pmos1 l=180n w=1u m=1
ends OPAMP1_variant204

subckt OPAMP1_variant205 inn inp out pd xpd vdda vssa
	xd1 (vssa vdda) prim_nwd AREA=6.13907e-9 PJ=476.6e-6 m=1
	xi0 (vssa net69) prim_nd AREA=1e-12 PJ=4e-6 m=1
	xi3 (net51 vdda) prim_pd AREA=790e-15 PJ=3.3e-6 m=1
	xr0 (vssa vdda net51) prim_rdiffp l=2.1e-6 w=700e-9 m=1
	xr1 (vdda vdda net69) prim_rdiffp l=2.1e-6 w=700e-9 m=1
	xcc01 (net12 out) prim_cpoly c=1p m=1
	mnm12 (net13 net56 vssa vssa) nmos1 l=180n w=1u m=1
	mnm11 (net56 net56 vssa vssa) nmos1 l=180n w=1u m=1
	mnb02 (net27 net27 net21 vssa) nmos1 l=180n w=1u m=1
	mnpd1 (net21 xpd vssa vssa) nmos1 l=2.1e-07n w=1.3e-06u m=1
	mn001 (out net13 vssa vssa) nmos1 l=180n w=1u m=1
	mnpd2 (net13 pd vssa vssa) nmos1 l=180n w=1u m=1
	mnc01 (net13 net69 net12 vssa) nmos1 l=1.5e-07n w=6.1e-07u m=1
	mpb02 (net27 net51 net158 vdda) pmos1 l=180n w=1u m=1
	mppd1 (net158 xpd vdda vdda) pmos1 l=180n w=1u m=1
	mps11 (net31 net158 vdda vdda) pmos1 l=2.2e-07n w=1.9e-06u m=1
	mpd11 (net56 inn net31 net31) pmos1 l=180n w=1u m=1
	mp001 (out net158 vdda vdda) pmos1 l=180n w=1u m=1
	mpd12 (net13 inp net31 net31) pmos1 l=180n w=1u m=1
	mpb01 (net158 net158 vdda vdda) pmos1 l=180n w=1u m=1
ends OPAMP1_variant205

subckt OPAMP1_variant206 inn inp out pd xpd vdda vssa
	xd1 (vssa vdda) prim_nwd AREA=6.13907e-9 PJ=476.6e-6 m=1
	xi0 (vssa net69) prim_nd AREA=1e-12 PJ=4e-6 m=1
	xi3 (net51 vdda) prim_pd AREA=790e-15 PJ=3.3e-6 m=1
	xr0 (vssa vdda net51) prim_rdiffp l=2.1e-6 w=700e-9 m=1
	xr1 (vdda vdda net69) prim_rdiffp l=2.1e-6 w=700e-9 m=1
	xcc01 (net12 out) prim_cpoly c=5.8e-13p m=1
	mnm12 (net13 net56 vssa vssa) nmos1 l=1.0e-07n w=6.4e-07u m=1
	mnm11 (net56 net56 vssa vssa) nmos1 l=2.3e-07n w=1.3e-06u m=1
	mnb02 (net27 net27 net21 vssa) nmos1 l=2.5e-07n w=1.5e-06u m=1
	mnpd1 (net21 xpd vssa vssa) nmos1 l=180n w=1u m=1
	mn001 (out net13 vssa vssa) nmos1 l=180n w=1u m=1
	mnpd2 (net13 pd vssa vssa) nmos1 l=180n w=1u m=1
	mnc01 (net13 net69 net12 vssa) nmos1 l=1.3e-07n w=8.2e-07u m=1
	mpb02 (net27 net51 net158 vdda) pmos1 l=180n w=1u m=1
	mppd1 (net158 xpd vdda vdda) pmos1 l=180n w=1u m=1
	mps11 (net31 net158 vdda vdda) pmos1 l=180n w=1u m=1
	mpd11 (net56 inn net31 net31) pmos1 l=180n w=1u m=1
	mp001 (out net158 vdda vdda) pmos1 l=180n w=1u m=1
	mpd12 (net13 inp net31 net31) pmos1 l=180n w=1u m=1
	mpb01 (net158 net158 vdda vdda) pmos1 l=180n w=1u m=1
ends OPAMP1_variant206

subckt OPAMP1_variant207 inn inp out pd xpd vdda vssa
	xd1 (vssa vdda) prim_nwd AREA=6.13907e-9 PJ=476.6e-6 m=1
	xi0 (vssa net69) prim_nd AREA=1e-12 PJ=4e-6 m=1
	xi3 (net51 vdda) prim_pd AREA=790e-15 PJ=3.3e-6 m=1
	xr0 (vssa vdda net51) prim_rdiffp l=2.1e-6 w=700e-9 m=1
	xr1 (vdda vdda net69) prim_rdiffp l=2.1e-6 w=700e-9 m=1
	xcc01 (net12 out) prim_cpoly c=1p m=1
	mnm12 (net13 net56 vssa vssa) nmos1 l=180n w=1u m=1
	mnm11 (net56 net56 vssa vssa) nmos1 l=180n w=1u m=1
	mnb02 (net27 net27 net21 vssa) nmos1 l=180n w=1u m=1
	mnpd1 (net21 xpd vssa vssa) nmos1 l=180n w=1u m=1
	mn001 (out net13 vssa vssa) nmos1 l=180n w=1u m=1
	mnpd2 (net13 pd vssa vssa) nmos1 l=180n w=1u m=1
	mnc01 (net13 net69 net12 vssa) nmos1 l=2.4e-07n w=7.3e-07u m=1
	mpb02 (net27 net51 net158 vdda) pmos1 l=1.7e-07n w=1.0e-06u m=1
	mppd1 (net158 xpd vdda vdda) pmos1 l=180n w=1u m=1
	mps11 (net31 net158 vdda vdda) pmos1 l=180n w=1u m=1
	mpd11 (net56 inn net31 net31) pmos1 l=180n w=1u m=1
	mp001 (out net158 vdda vdda) pmos1 l=180n w=1u m=1
	mpd12 (net13 inp net31 net31) pmos1 l=180n w=1u m=1
	mpb01 (net158 net158 vdda vdda) pmos1 l=180n w=1u m=1
ends OPAMP1_variant207

subckt OPAMP1_variant208 inn inp out pd xpd vdda vssa
	xd1 (vssa vdda) prim_nwd AREA=4.9e-09 PJ=1.4e-05 m=1
	xi0 (vssa net69) prim_nd AREA=1e-12 PJ=4e-6 m=1
	xi3 (net51 vdda) prim_pd AREA=790e-15 PJ=3.3e-6 m=1
	xr0 (vssa vdda net51) prim_rdiffp l=2.1e-6 w=700e-9 m=1
	xr1 (vdda vdda net69) prim_rdiffp l=1.2e-07 w=1.2e-06 m=1
	xcc01 (net12 out) prim_cpoly c=9.2e-13p m=1
	mnm12 (net13 net56 vssa vssa) nmos1 l=2.4e-07n w=1.5e-06u m=1
	mnm11 (net56 net56 vssa vssa) nmos1 l=2.8e-07n w=9.4e-07u m=1
	mnb02 (net27 net27 net21 vssa) nmos1 l=180n w=1u m=1
	mnpd1 (net21 xpd vssa vssa) nmos1 l=180n w=1u m=1
	mn001 (out net13 vssa vssa) nmos1 l=180n w=1u m=1
	mnpd2 (net13 pd vssa vssa) nmos1 l=180n w=1u m=1
	mnc01 (net13 net69 net12 vssa) nmos1 l=180n w=1u m=1
	mpb02 (net27 net51 net158 vdda) pmos1 l=180n w=1u m=1
	mppd1 (net158 xpd vdda vdda) pmos1 l=180n w=1u m=1
	mps11 (net31 net158 vdda vdda) pmos1 l=180n w=1u m=1
	mpd11 (net56 inn net31 net31) pmos1 l=180n w=1u m=1
	mp001 (out net158 vdda vdda) pmos1 l=180n w=1u m=1
	mpd12 (net13 inp net31 net31) pmos1 l=180n w=1u m=1
	mpb01 (net158 net158 vdda vdda) pmos1 l=180n w=1u m=1
ends OPAMP1_variant208

subckt OPAMP1_variant209 inn inp out pd xpd vdda vssa
	xd1 (vssa vdda) prim_nwd AREA=6.13907e-9 PJ=476.6e-6 m=1
	xi0 (vssa net69) prim_nd AREA=3.0e-09 PJ=1.2e-05 m=1
	xi3 (net51 vdda) prim_pd AREA=790e-15 PJ=3.3e-6 m=1
	xr0 (vssa vdda net51) prim_rdiffp l=2.1e-6 w=700e-9 m=1
	xr1 (vdda vdda net69) prim_rdiffp l=2.1e-6 w=700e-9 m=1
	xcc01 (net12 out) prim_cpoly c=1p m=1
	mnm12 (net13 net56 vssa vssa) nmos1 l=1.1e-07n w=1.4e-06u m=1
	mnm11 (net56 net56 vssa vssa) nmos1 l=180n w=1u m=1
	mnb02 (net27 net27 net21 vssa) nmos1 l=1.6e-07n w=5.4e-07u m=1
	mnpd1 (net21 xpd vssa vssa) nmos1 l=180n w=1u m=1
	mn001 (out net13 vssa vssa) nmos1 l=2.6e-07n w=1.3e-06u m=1
	mnpd2 (net13 pd vssa vssa) nmos1 l=180n w=1u m=1
	mnc01 (net13 net69 net12 vssa) nmos1 l=180n w=1u m=1
	mpb02 (net27 net51 net158 vdda) pmos1 l=180n w=1u m=1
	mppd1 (net158 xpd vdda vdda) pmos1 l=180n w=1u m=1
	mps11 (net31 net158 vdda vdda) pmos1 l=180n w=1u m=1
	mpd11 (net56 inn net31 net31) pmos1 l=180n w=1u m=1
	mp001 (out net158 vdda vdda) pmos1 l=180n w=1u m=1
	mpd12 (net13 inp net31 net31) pmos1 l=2.3e-07n w=1.3e-06u m=1
	mpb01 (net158 net158 vdda vdda) pmos1 l=180n w=1u m=1
ends OPAMP1_variant209

subckt OPAMP1_variant210 inn inp out pd xpd vdda vssa
	xd1 (vssa vdda) prim_nwd AREA=6.13907e-9 PJ=476.6e-6 m=1
	xi0 (vssa net69) prim_nd AREA=1e-12 PJ=4e-6 m=1
	xi3 (net51 vdda) prim_pd AREA=790e-15 PJ=3.3e-6 m=1
	xr0 (vssa vdda net51) prim_rdiffp l=2.1e-6 w=700e-9 m=1
	xr1 (vdda vdda net69) prim_rdiffp l=2.1e-6 w=700e-9 m=1
	xcc01 (net12 out) prim_cpoly c=1p m=1
	mnm12 (net13 net56 vssa vssa) nmos1 l=180n w=1u m=1
	mnm11 (net56 net56 vssa vssa) nmos1 l=1.1e-07n w=1.8e-06u m=1
	mnb02 (net27 net27 net21 vssa) nmos1 l=180n w=1u m=1
	mnpd1 (net21 xpd vssa vssa) nmos1 l=180n w=1u m=1
	mn001 (out net13 vssa vssa) nmos1 l=180n w=1u m=1
	mnpd2 (net13 pd vssa vssa) nmos1 l=1.9e-07n w=1.8e-06u m=1
	mnc01 (net13 net69 net12 vssa) nmos1 l=180n w=1u m=1
	mpb02 (net27 net51 net158 vdda) pmos1 l=180n w=1u m=1
	mppd1 (net158 xpd vdda vdda) pmos1 l=1.5e-07n w=1.2e-06u m=1
	mps11 (net31 net158 vdda vdda) pmos1 l=180n w=1u m=1
	mpd11 (net56 inn net31 net31) pmos1 l=180n w=1u m=1
	mp001 (out net158 vdda vdda) pmos1 l=180n w=1u m=1
	mpd12 (net13 inp net31 net31) pmos1 l=180n w=1u m=1
	mpb01 (net158 net158 vdda vdda) pmos1 l=180n w=1u m=1
ends OPAMP1_variant210

subckt OPAMP1_variant211 inn inp out pd xpd vdda vssa
	xd1 (vssa vdda) prim_nwd AREA=6.13907e-9 PJ=476.6e-6 m=1
	xi0 (vssa net69) prim_nd AREA=1e-12 PJ=4e-6 m=1
	xi3 (net51 vdda) prim_pd AREA=790e-15 PJ=3.3e-6 m=1
	xr0 (vssa vdda net51) prim_rdiffp l=2.1e-6 w=700e-9 m=1
	xr1 (vdda vdda net69) prim_rdiffp l=1.0e-07 w=1.9e-06 m=1
	xcc01 (net12 out) prim_cpoly c=1p m=1
	mnm12 (net13 net56 vssa vssa) nmos1 l=180n w=1u m=1
	mnm11 (net56 net56 vssa vssa) nmos1 l=180n w=1u m=1
	mnb02 (net27 net27 net21 vssa) nmos1 l=180n w=1u m=1
	mnpd1 (net21 xpd vssa vssa) nmos1 l=180n w=1u m=1
	mn001 (out net13 vssa vssa) nmos1 l=180n w=1u m=1
	mnpd2 (net13 pd vssa vssa) nmos1 l=180n w=1u m=1
	mnc01 (net13 net69 net12 vssa) nmos1 l=1.4e-07n w=1.4e-06u m=1
	mpb02 (net27 net51 net158 vdda) pmos1 l=180n w=1u m=1
	mppd1 (net158 xpd vdda vdda) pmos1 l=180n w=1u m=1
	mps11 (net31 net158 vdda vdda) pmos1 l=180n w=1u m=1
	mpd11 (net56 inn net31 net31) pmos1 l=180n w=1u m=1
	mp001 (out net158 vdda vdda) pmos1 l=180n w=1u m=1
	mpd12 (net13 inp net31 net31) pmos1 l=180n w=1u m=1
	mpb01 (net158 net158 vdda vdda) pmos1 l=180n w=1u m=1
ends OPAMP1_variant211

subckt OPAMP1_variant212 inn inp out pd xpd vdda vssa
	xd1 (vssa vdda) prim_nwd AREA=6.13907e-9 PJ=476.6e-6 m=1
	xi0 (vssa net69) prim_nd AREA=1e-12 PJ=4e-6 m=1
	xi3 (net51 vdda) prim_pd AREA=790e-15 PJ=3.3e-6 m=1
	xr0 (vssa vdda net51) prim_rdiffp l=2.1e-6 w=700e-9 m=1
	xr1 (vdda vdda net69) prim_rdiffp l=2.1e-6 w=700e-9 m=1
	xcc01 (net12 out) prim_cpoly c=1p m=1
	mnm12 (net13 net56 vssa vssa) nmos1 l=180n w=1u m=1
	mnm11 (net56 net56 vssa vssa) nmos1 l=180n w=1u m=1
	mnb02 (net27 net27 net21 vssa) nmos1 l=2.9e-07n w=1.0e-06u m=1
	mnpd1 (net21 xpd vssa vssa) nmos1 l=2.7e-07n w=1.6e-06u m=1
	mn001 (out net13 vssa vssa) nmos1 l=180n w=1u m=1
	mnpd2 (net13 pd vssa vssa) nmos1 l=180n w=1u m=1
	mnc01 (net13 net69 net12 vssa) nmos1 l=180n w=1u m=1
	mpb02 (net27 net51 net158 vdda) pmos1 l=180n w=1u m=1
	mppd1 (net158 xpd vdda vdda) pmos1 l=3.0e-07n w=7.1e-07u m=1
	mps11 (net31 net158 vdda vdda) pmos1 l=180n w=1u m=1
	mpd11 (net56 inn net31 net31) pmos1 l=180n w=1u m=1
	mp001 (out net158 vdda vdda) pmos1 l=180n w=1u m=1
	mpd12 (net13 inp net31 net31) pmos1 l=180n w=1u m=1
	mpb01 (net158 net158 vdda vdda) pmos1 l=180n w=1u m=1
ends OPAMP1_variant212

subckt OPAMP1_variant213 inn inp out pd xpd vdda vssa
	xd1 (vssa vdda) prim_nwd AREA=6.13907e-9 PJ=476.6e-6 m=1
	xi0 (vssa net69) prim_nd AREA=1.0e-09 PJ=3.8e-05 m=1
	xi3 (net51 vdda) prim_pd AREA=790e-15 PJ=3.3e-6 m=1
	xr0 (vssa vdda net51) prim_rdiffp l=2.1e-6 w=700e-9 m=1
	xr1 (vdda vdda net69) prim_rdiffp l=2.1e-6 w=700e-9 m=1
	xcc01 (net12 out) prim_cpoly c=1p m=1
	mnm12 (net13 net56 vssa vssa) nmos1 l=180n w=1u m=1
	mnm11 (net56 net56 vssa vssa) nmos1 l=180n w=1u m=1
	mnb02 (net27 net27 net21 vssa) nmos1 l=180n w=1u m=1
	mnpd1 (net21 xpd vssa vssa) nmos1 l=180n w=1u m=1
	mn001 (out net13 vssa vssa) nmos1 l=180n w=1u m=1
	mnpd2 (net13 pd vssa vssa) nmos1 l=1.4e-07n w=9.6e-07u m=1
	mnc01 (net13 net69 net12 vssa) nmos1 l=180n w=1u m=1
	mpb02 (net27 net51 net158 vdda) pmos1 l=180n w=1u m=1
	mppd1 (net158 xpd vdda vdda) pmos1 l=180n w=1u m=1
	mps11 (net31 net158 vdda vdda) pmos1 l=180n w=1u m=1
	mpd11 (net56 inn net31 net31) pmos1 l=180n w=1u m=1
	mp001 (out net158 vdda vdda) pmos1 l=180n w=1u m=1
	mpd12 (net13 inp net31 net31) pmos1 l=180n w=1u m=1
	mpb01 (net158 net158 vdda vdda) pmos1 l=180n w=1u m=1
ends OPAMP1_variant213

subckt OPAMP1_variant214 inn inp out pd xpd vdda vssa
	xd1 (vssa vdda) prim_nwd AREA=6.13907e-9 PJ=476.6e-6 m=1
	xi0 (vssa net69) prim_nd AREA=1e-12 PJ=4e-6 m=1
	xi3 (net51 vdda) prim_pd AREA=790e-15 PJ=3.3e-6 m=1
	xr0 (vssa vdda net51) prim_rdiffp l=2.1e-6 w=700e-9 m=1
	xr1 (vdda vdda net69) prim_rdiffp l=2.1e-6 w=700e-9 m=1
	xcc01 (net12 out) prim_cpoly c=1p m=1
	mnm12 (net13 net56 vssa vssa) nmos1 l=180n w=1u m=1
	mnm11 (net56 net56 vssa vssa) nmos1 l=1.5e-07n w=1.1e-06u m=1
	mnb02 (net27 net27 net21 vssa) nmos1 l=180n w=1u m=1
	mnpd1 (net21 xpd vssa vssa) nmos1 l=1.4e-07n w=1.5e-06u m=1
	mn001 (out net13 vssa vssa) nmos1 l=180n w=1u m=1
	mnpd2 (net13 pd vssa vssa) nmos1 l=180n w=1u m=1
	mnc01 (net13 net69 net12 vssa) nmos1 l=180n w=1u m=1
	mpb02 (net27 net51 net158 vdda) pmos1 l=2.7e-07n w=1.3e-06u m=1
	mppd1 (net158 xpd vdda vdda) pmos1 l=180n w=1u m=1
	mps11 (net31 net158 vdda vdda) pmos1 l=180n w=1u m=1
	mpd11 (net56 inn net31 net31) pmos1 l=180n w=1u m=1
	mp001 (out net158 vdda vdda) pmos1 l=180n w=1u m=1
	mpd12 (net13 inp net31 net31) pmos1 l=180n w=1u m=1
	mpb01 (net158 net158 vdda vdda) pmos1 l=180n w=1u m=1
ends OPAMP1_variant214

subckt OPAMP1_variant215 inn inp out pd xpd vdda vssa
	xd1 (vssa vdda) prim_nwd AREA=6.13907e-9 PJ=476.6e-6 m=1
	xi0 (vssa net69) prim_nd AREA=7.1e-09 PJ=4.7e-05 m=1
	xi3 (net51 vdda) prim_pd AREA=6.0e-09 PJ=7.2e-05 m=1
	xr0 (vssa vdda net51) prim_rdiffp l=2.1e-6 w=700e-9 m=1
	xr1 (vdda vdda net69) prim_rdiffp l=2.1e-6 w=700e-9 m=1
	xcc01 (net12 out) prim_cpoly c=9.6e-13p m=1
	mnm12 (net13 net56 vssa vssa) nmos1 l=180n w=1u m=1
	mnm11 (net56 net56 vssa vssa) nmos1 l=180n w=1u m=1
	mnb02 (net27 net27 net21 vssa) nmos1 l=180n w=1u m=1
	mnpd1 (net21 xpd vssa vssa) nmos1 l=180n w=1u m=1
	mn001 (out net13 vssa vssa) nmos1 l=180n w=1u m=1
	mnpd2 (net13 pd vssa vssa) nmos1 l=180n w=1u m=1
	mnc01 (net13 net69 net12 vssa) nmos1 l=180n w=1u m=1
	mpb02 (net27 net51 net158 vdda) pmos1 l=180n w=1u m=1
	mppd1 (net158 xpd vdda vdda) pmos1 l=180n w=1u m=1
	mps11 (net31 net158 vdda vdda) pmos1 l=1.7e-07n w=1.2e-06u m=1
	mpd11 (net56 inn net31 net31) pmos1 l=180n w=1u m=1
	mp001 (out net158 vdda vdda) pmos1 l=180n w=1u m=1
	mpd12 (net13 inp net31 net31) pmos1 l=180n w=1u m=1
	mpb01 (net158 net158 vdda vdda) pmos1 l=180n w=1u m=1
ends OPAMP1_variant215

subckt OPAMP1_variant216 inn inp out pd xpd vdda vssa
	xd1 (vssa vdda) prim_nwd AREA=6.13907e-9 PJ=476.6e-6 m=1
	xi0 (vssa net69) prim_nd AREA=7.1e-09 PJ=9.5e-05 m=1
	xi3 (net51 vdda) prim_pd AREA=790e-15 PJ=3.3e-6 m=1
	xr0 (vssa vdda net51) prim_rdiffp l=2.1e-6 w=700e-9 m=1
	xr1 (vdda vdda net69) prim_rdiffp l=2.1e-6 w=700e-9 m=1
	xcc01 (net12 out) prim_cpoly c=1.9e-12p m=1
	mnm12 (net13 net56 vssa vssa) nmos1 l=2.9e-07n w=1.5e-06u m=1
	mnm11 (net56 net56 vssa vssa) nmos1 l=180n w=1u m=1
	mnb02 (net27 net27 net21 vssa) nmos1 l=180n w=1u m=1
	mnpd1 (net21 xpd vssa vssa) nmos1 l=180n w=1u m=1
	mn001 (out net13 vssa vssa) nmos1 l=180n w=1u m=1
	mnpd2 (net13 pd vssa vssa) nmos1 l=1.7e-07n w=1.6e-06u m=1
	mnc01 (net13 net69 net12 vssa) nmos1 l=180n w=1u m=1
	mpb02 (net27 net51 net158 vdda) pmos1 l=180n w=1u m=1
	mppd1 (net158 xpd vdda vdda) pmos1 l=180n w=1u m=1
	mps11 (net31 net158 vdda vdda) pmos1 l=180n w=1u m=1
	mpd11 (net56 inn net31 net31) pmos1 l=180n w=1u m=1
	mp001 (out net158 vdda vdda) pmos1 l=180n w=1u m=1
	mpd12 (net13 inp net31 net31) pmos1 l=180n w=1u m=1
	mpb01 (net158 net158 vdda vdda) pmos1 l=180n w=1u m=1
ends OPAMP1_variant216

subckt OPAMP1_variant217 inn inp out pd xpd vdda vssa
	xd1 (vssa vdda) prim_nwd AREA=6.3e-09 PJ=4.8e-05 m=1
	xi0 (vssa net69) prim_nd AREA=1e-12 PJ=4e-6 m=1
	xi3 (net51 vdda) prim_pd AREA=790e-15 PJ=3.3e-6 m=1
	xr0 (vssa vdda net51) prim_rdiffp l=2.1e-6 w=700e-9 m=1
	xr1 (vdda vdda net69) prim_rdiffp l=2.1e-6 w=700e-9 m=1
	xcc01 (net12 out) prim_cpoly c=1p m=1
	mnm12 (net13 net56 vssa vssa) nmos1 l=2.4e-07n w=1.7e-06u m=1
	mnm11 (net56 net56 vssa vssa) nmos1 l=180n w=1u m=1
	mnb02 (net27 net27 net21 vssa) nmos1 l=1.2e-07n w=1.7e-06u m=1
	mnpd1 (net21 xpd vssa vssa) nmos1 l=180n w=1u m=1
	mn001 (out net13 vssa vssa) nmos1 l=180n w=1u m=1
	mnpd2 (net13 pd vssa vssa) nmos1 l=180n w=1u m=1
	mnc01 (net13 net69 net12 vssa) nmos1 l=180n w=1u m=1
	mpb02 (net27 net51 net158 vdda) pmos1 l=180n w=1u m=1
	mppd1 (net158 xpd vdda vdda) pmos1 l=1.1e-07n w=1.5e-06u m=1
	mps11 (net31 net158 vdda vdda) pmos1 l=180n w=1u m=1
	mpd11 (net56 inn net31 net31) pmos1 l=180n w=1u m=1
	mp001 (out net158 vdda vdda) pmos1 l=180n w=1u m=1
	mpd12 (net13 inp net31 net31) pmos1 l=2.9e-07n w=1.1e-06u m=1
	mpb01 (net158 net158 vdda vdda) pmos1 l=180n w=1u m=1
ends OPAMP1_variant217

subckt OPAMP1_variant218 inn inp out pd xpd vdda vssa
	xd1 (vssa vdda) prim_nwd AREA=6.13907e-9 PJ=476.6e-6 m=1
	xi0 (vssa net69) prim_nd AREA=1e-12 PJ=4e-6 m=1
	xi3 (net51 vdda) prim_pd AREA=3.6e-09 PJ=4.2e-05 m=1
	xr0 (vssa vdda net51) prim_rdiffp l=2.1e-6 w=700e-9 m=1
	xr1 (vdda vdda net69) prim_rdiffp l=2.1e-6 w=700e-9 m=1
	xcc01 (net12 out) prim_cpoly c=1p m=1
	mnm12 (net13 net56 vssa vssa) nmos1 l=180n w=1u m=1
	mnm11 (net56 net56 vssa vssa) nmos1 l=180n w=1u m=1
	mnb02 (net27 net27 net21 vssa) nmos1 l=180n w=1u m=1
	mnpd1 (net21 xpd vssa vssa) nmos1 l=180n w=1u m=1
	mn001 (out net13 vssa vssa) nmos1 l=180n w=1u m=1
	mnpd2 (net13 pd vssa vssa) nmos1 l=180n w=1u m=1
	mnc01 (net13 net69 net12 vssa) nmos1 l=180n w=1u m=1
	mpb02 (net27 net51 net158 vdda) pmos1 l=180n w=1u m=1
	mppd1 (net158 xpd vdda vdda) pmos1 l=180n w=1u m=1
	mps11 (net31 net158 vdda vdda) pmos1 l=180n w=1u m=1
	mpd11 (net56 inn net31 net31) pmos1 l=180n w=1u m=1
	mp001 (out net158 vdda vdda) pmos1 l=2.1e-07n w=1.2e-06u m=1
	mpd12 (net13 inp net31 net31) pmos1 l=180n w=1u m=1
	mpb01 (net158 net158 vdda vdda) pmos1 l=180n w=1u m=1
ends OPAMP1_variant218

subckt OPAMP1_variant219 inn inp out pd xpd vdda vssa
	xd1 (vssa vdda) prim_nwd AREA=6.13907e-9 PJ=476.6e-6 m=1
	xi0 (vssa net69) prim_nd AREA=1e-12 PJ=4e-6 m=1
	xi3 (net51 vdda) prim_pd AREA=790e-15 PJ=3.3e-6 m=1
	xr0 (vssa vdda net51) prim_rdiffp l=2.1e-6 w=700e-9 m=1
	xr1 (vdda vdda net69) prim_rdiffp l=2.1e-6 w=700e-9 m=1
	xcc01 (net12 out) prim_cpoly c=1.8e-12p m=1
	mnm12 (net13 net56 vssa vssa) nmos1 l=180n w=1u m=1
	mnm11 (net56 net56 vssa vssa) nmos1 l=2.7e-07n w=7.7e-07u m=1
	mnb02 (net27 net27 net21 vssa) nmos1 l=180n w=1u m=1
	mnpd1 (net21 xpd vssa vssa) nmos1 l=180n w=1u m=1
	mn001 (out net13 vssa vssa) nmos1 l=180n w=1u m=1
	mnpd2 (net13 pd vssa vssa) nmos1 l=180n w=1u m=1
	mnc01 (net13 net69 net12 vssa) nmos1 l=180n w=1u m=1
	mpb02 (net27 net51 net158 vdda) pmos1 l=180n w=1u m=1
	mppd1 (net158 xpd vdda vdda) pmos1 l=2.3e-07n w=1.1e-06u m=1
	mps11 (net31 net158 vdda vdda) pmos1 l=180n w=1u m=1
	mpd11 (net56 inn net31 net31) pmos1 l=180n w=1u m=1
	mp001 (out net158 vdda vdda) pmos1 l=180n w=1u m=1
	mpd12 (net13 inp net31 net31) pmos1 l=1.5e-07n w=7.0e-07u m=1
	mpb01 (net158 net158 vdda vdda) pmos1 l=180n w=1u m=1
ends OPAMP1_variant219

subckt OPAMP1_variant220 inn inp out pd xpd vdda vssa
	xd1 (vssa vdda) prim_nwd AREA=6.13907e-9 PJ=476.6e-6 m=1
	xi0 (vssa net69) prim_nd AREA=1e-12 PJ=4e-6 m=1
	xi3 (net51 vdda) prim_pd AREA=790e-15 PJ=3.3e-6 m=1
	xr0 (vssa vdda net51) prim_rdiffp l=1.9e-07 w=1.7e-06 m=1
	xr1 (vdda vdda net69) prim_rdiffp l=2.1e-6 w=700e-9 m=1
	xcc01 (net12 out) prim_cpoly c=9.7e-13p m=1
	mnm12 (net13 net56 vssa vssa) nmos1 l=180n w=1u m=1
	mnm11 (net56 net56 vssa vssa) nmos1 l=180n w=1u m=1
	mnb02 (net27 net27 net21 vssa) nmos1 l=3.0e-07n w=1.9e-06u m=1
	mnpd1 (net21 xpd vssa vssa) nmos1 l=180n w=1u m=1
	mn001 (out net13 vssa vssa) nmos1 l=180n w=1u m=1
	mnpd2 (net13 pd vssa vssa) nmos1 l=1.7e-07n w=9.6e-07u m=1
	mnc01 (net13 net69 net12 vssa) nmos1 l=180n w=1u m=1
	mpb02 (net27 net51 net158 vdda) pmos1 l=180n w=1u m=1
	mppd1 (net158 xpd vdda vdda) pmos1 l=180n w=1u m=1
	mps11 (net31 net158 vdda vdda) pmos1 l=180n w=1u m=1
	mpd11 (net56 inn net31 net31) pmos1 l=180n w=1u m=1
	mp001 (out net158 vdda vdda) pmos1 l=180n w=1u m=1
	mpd12 (net13 inp net31 net31) pmos1 l=2.9e-07n w=1.7e-06u m=1
	mpb01 (net158 net158 vdda vdda) pmos1 l=180n w=1u m=1
ends OPAMP1_variant220

subckt OPAMP1_variant221 inn inp out pd xpd vdda vssa
	xd1 (vssa vdda) prim_nwd AREA=6.13907e-9 PJ=476.6e-6 m=1
	xi0 (vssa net69) prim_nd AREA=2.3e-09 PJ=7.3e-05 m=1
	xi3 (net51 vdda) prim_pd AREA=790e-15 PJ=3.3e-6 m=1
	xr0 (vssa vdda net51) prim_rdiffp l=2.1e-6 w=700e-9 m=1
	xr1 (vdda vdda net69) prim_rdiffp l=2.1e-6 w=700e-9 m=1
	xcc01 (net12 out) prim_cpoly c=1p m=1
	mnm12 (net13 net56 vssa vssa) nmos1 l=180n w=1u m=1
	mnm11 (net56 net56 vssa vssa) nmos1 l=180n w=1u m=1
	mnb02 (net27 net27 net21 vssa) nmos1 l=180n w=1u m=1
	mnpd1 (net21 xpd vssa vssa) nmos1 l=180n w=1u m=1
	mn001 (out net13 vssa vssa) nmos1 l=180n w=1u m=1
	mnpd2 (net13 pd vssa vssa) nmos1 l=180n w=1u m=1
	mnc01 (net13 net69 net12 vssa) nmos1 l=180n w=1u m=1
	mpb02 (net27 net51 net158 vdda) pmos1 l=180n w=1u m=1
	mppd1 (net158 xpd vdda vdda) pmos1 l=180n w=1u m=1
	mps11 (net31 net158 vdda vdda) pmos1 l=180n w=1u m=1
	mpd11 (net56 inn net31 net31) pmos1 l=180n w=1u m=1
	mp001 (out net158 vdda vdda) pmos1 l=180n w=1u m=1
	mpd12 (net13 inp net31 net31) pmos1 l=1.6e-07n w=8.8e-07u m=1
	mpb01 (net158 net158 vdda vdda) pmos1 l=180n w=1u m=1
ends OPAMP1_variant221

subckt OPAMP1_variant222 inn inp out pd xpd vdda vssa
	xd1 (vssa vdda) prim_nwd AREA=6.13907e-9 PJ=476.6e-6 m=1
	xi0 (vssa net69) prim_nd AREA=1e-12 PJ=4e-6 m=1
	xi3 (net51 vdda) prim_pd AREA=790e-15 PJ=3.3e-6 m=1
	xr0 (vssa vdda net51) prim_rdiffp l=2.3e-07 w=7.6e-07 m=1
	xr1 (vdda vdda net69) prim_rdiffp l=2.2e-07 w=8.8e-07 m=1
	xcc01 (net12 out) prim_cpoly c=1.5e-12p m=1
	mnm12 (net13 net56 vssa vssa) nmos1 l=2.8e-07n w=9.2e-07u m=1
	mnm11 (net56 net56 vssa vssa) nmos1 l=180n w=1u m=1
	mnb02 (net27 net27 net21 vssa) nmos1 l=180n w=1u m=1
	mnpd1 (net21 xpd vssa vssa) nmos1 l=180n w=1u m=1
	mn001 (out net13 vssa vssa) nmos1 l=180n w=1u m=1
	mnpd2 (net13 pd vssa vssa) nmos1 l=180n w=1u m=1
	mnc01 (net13 net69 net12 vssa) nmos1 l=180n w=1u m=1
	mpb02 (net27 net51 net158 vdda) pmos1 l=180n w=1u m=1
	mppd1 (net158 xpd vdda vdda) pmos1 l=180n w=1u m=1
	mps11 (net31 net158 vdda vdda) pmos1 l=180n w=1u m=1
	mpd11 (net56 inn net31 net31) pmos1 l=1.9e-07n w=6.5e-07u m=1
	mp001 (out net158 vdda vdda) pmos1 l=180n w=1u m=1
	mpd12 (net13 inp net31 net31) pmos1 l=180n w=1u m=1
	mpb01 (net158 net158 vdda vdda) pmos1 l=180n w=1u m=1
ends OPAMP1_variant222

subckt OPAMP1_variant223 inn inp out pd xpd vdda vssa
	xd1 (vssa vdda) prim_nwd AREA=6.13907e-9 PJ=476.6e-6 m=1
	xi0 (vssa net69) prim_nd AREA=1e-12 PJ=4e-6 m=1
	xi3 (net51 vdda) prim_pd AREA=790e-15 PJ=3.3e-6 m=1
	xr0 (vssa vdda net51) prim_rdiffp l=2.1e-6 w=700e-9 m=1
	xr1 (vdda vdda net69) prim_rdiffp l=2.1e-6 w=700e-9 m=1
	xcc01 (net12 out) prim_cpoly c=1p m=1
	mnm12 (net13 net56 vssa vssa) nmos1 l=180n w=1u m=1
	mnm11 (net56 net56 vssa vssa) nmos1 l=180n w=1u m=1
	mnb02 (net27 net27 net21 vssa) nmos1 l=1.7e-07n w=9.1e-07u m=1
	mnpd1 (net21 xpd vssa vssa) nmos1 l=180n w=1u m=1
	mn001 (out net13 vssa vssa) nmos1 l=180n w=1u m=1
	mnpd2 (net13 pd vssa vssa) nmos1 l=180n w=1u m=1
	mnc01 (net13 net69 net12 vssa) nmos1 l=180n w=1u m=1
	mpb02 (net27 net51 net158 vdda) pmos1 l=180n w=1u m=1
	mppd1 (net158 xpd vdda vdda) pmos1 l=180n w=1u m=1
	mps11 (net31 net158 vdda vdda) pmos1 l=2.1e-07n w=1.3e-06u m=1
	mpd11 (net56 inn net31 net31) pmos1 l=180n w=1u m=1
	mp001 (out net158 vdda vdda) pmos1 l=180n w=1u m=1
	mpd12 (net13 inp net31 net31) pmos1 l=180n w=1u m=1
	mpb01 (net158 net158 vdda vdda) pmos1 l=180n w=1u m=1
ends OPAMP1_variant223

subckt OPAMP1_variant224 inn inp out pd xpd vdda vssa
	xd1 (vssa vdda) prim_nwd AREA=6.13907e-9 PJ=476.6e-6 m=1
	xi0 (vssa net69) prim_nd AREA=1e-12 PJ=4e-6 m=1
	xi3 (net51 vdda) prim_pd AREA=790e-15 PJ=3.3e-6 m=1
	xr0 (vssa vdda net51) prim_rdiffp l=2.1e-6 w=700e-9 m=1
	xr1 (vdda vdda net69) prim_rdiffp l=2.1e-6 w=700e-9 m=1
	xcc01 (net12 out) prim_cpoly c=7.3e-13p m=1
	mnm12 (net13 net56 vssa vssa) nmos1 l=180n w=1u m=1
	mnm11 (net56 net56 vssa vssa) nmos1 l=180n w=1u m=1
	mnb02 (net27 net27 net21 vssa) nmos1 l=180n w=1u m=1
	mnpd1 (net21 xpd vssa vssa) nmos1 l=1.8e-07n w=1.6e-06u m=1
	mn001 (out net13 vssa vssa) nmos1 l=2.8e-07n w=6.3e-07u m=1
	mnpd2 (net13 pd vssa vssa) nmos1 l=180n w=1u m=1
	mnc01 (net13 net69 net12 vssa) nmos1 l=180n w=1u m=1
	mpb02 (net27 net51 net158 vdda) pmos1 l=180n w=1u m=1
	mppd1 (net158 xpd vdda vdda) pmos1 l=180n w=1u m=1
	mps11 (net31 net158 vdda vdda) pmos1 l=2.4e-07n w=6.3e-07u m=1
	mpd11 (net56 inn net31 net31) pmos1 l=180n w=1u m=1
	mp001 (out net158 vdda vdda) pmos1 l=2.1e-07n w=1.5e-06u m=1
	mpd12 (net13 inp net31 net31) pmos1 l=180n w=1u m=1
	mpb01 (net158 net158 vdda vdda) pmos1 l=180n w=1u m=1
ends OPAMP1_variant224

subckt OPAMP1_variant225 inn inp out pd xpd vdda vssa
	xd1 (vssa vdda) prim_nwd AREA=6.13907e-9 PJ=476.6e-6 m=1
	xi0 (vssa net69) prim_nd AREA=8.8e-09 PJ=3.2e-06 m=1
	xi3 (net51 vdda) prim_pd AREA=790e-15 PJ=3.3e-6 m=1
	xr0 (vssa vdda net51) prim_rdiffp l=2.0e-07 w=9.3e-07 m=1
	xr1 (vdda vdda net69) prim_rdiffp l=2.1e-6 w=700e-9 m=1
	xcc01 (net12 out) prim_cpoly c=1p m=1
	mnm12 (net13 net56 vssa vssa) nmos1 l=180n w=1u m=1
	mnm11 (net56 net56 vssa vssa) nmos1 l=180n w=1u m=1
	mnb02 (net27 net27 net21 vssa) nmos1 l=180n w=1u m=1
	mnpd1 (net21 xpd vssa vssa) nmos1 l=180n w=1u m=1
	mn001 (out net13 vssa vssa) nmos1 l=180n w=1u m=1
	mnpd2 (net13 pd vssa vssa) nmos1 l=180n w=1u m=1
	mnc01 (net13 net69 net12 vssa) nmos1 l=180n w=1u m=1
	mpb02 (net27 net51 net158 vdda) pmos1 l=180n w=1u m=1
	mppd1 (net158 xpd vdda vdda) pmos1 l=1.2e-07n w=9.8e-07u m=1
	mps11 (net31 net158 vdda vdda) pmos1 l=180n w=1u m=1
	mpd11 (net56 inn net31 net31) pmos1 l=180n w=1u m=1
	mp001 (out net158 vdda vdda) pmos1 l=180n w=1u m=1
	mpd12 (net13 inp net31 net31) pmos1 l=2.4e-07n w=1.6e-06u m=1
	mpb01 (net158 net158 vdda vdda) pmos1 l=180n w=1u m=1
ends OPAMP1_variant225

subckt OPAMP1_variant226 inn inp out pd xpd vdda vssa
	xd1 (vssa vdda) prim_nwd AREA=6.4e-09 PJ=6.4e-05 m=1
	xi0 (vssa net69) prim_nd AREA=1e-12 PJ=4e-6 m=1
	xi3 (net51 vdda) prim_pd AREA=790e-15 PJ=3.3e-6 m=1
	xr0 (vssa vdda net51) prim_rdiffp l=2.1e-6 w=700e-9 m=1
	xr1 (vdda vdda net69) prim_rdiffp l=2.1e-6 w=700e-9 m=1
	xcc01 (net12 out) prim_cpoly c=1p m=1
	mnm12 (net13 net56 vssa vssa) nmos1 l=180n w=1u m=1
	mnm11 (net56 net56 vssa vssa) nmos1 l=180n w=1u m=1
	mnb02 (net27 net27 net21 vssa) nmos1 l=180n w=1u m=1
	mnpd1 (net21 xpd vssa vssa) nmos1 l=1.9e-07n w=1.8e-06u m=1
	mn001 (out net13 vssa vssa) nmos1 l=180n w=1u m=1
	mnpd2 (net13 pd vssa vssa) nmos1 l=1.8e-07n w=1.1e-06u m=1
	mnc01 (net13 net69 net12 vssa) nmos1 l=180n w=1u m=1
	mpb02 (net27 net51 net158 vdda) pmos1 l=180n w=1u m=1
	mppd1 (net158 xpd vdda vdda) pmos1 l=180n w=1u m=1
	mps11 (net31 net158 vdda vdda) pmos1 l=2.3e-07n w=1.9e-06u m=1
	mpd11 (net56 inn net31 net31) pmos1 l=180n w=1u m=1
	mp001 (out net158 vdda vdda) pmos1 l=180n w=1u m=1
	mpd12 (net13 inp net31 net31) pmos1 l=180n w=1u m=1
	mpb01 (net158 net158 vdda vdda) pmos1 l=180n w=1u m=1
ends OPAMP1_variant226

subckt OPAMP1_variant227 inn inp out pd xpd vdda vssa
	xd1 (vssa vdda) prim_nwd AREA=6.13907e-9 PJ=476.6e-6 m=1
	xi0 (vssa net69) prim_nd AREA=1e-12 PJ=4e-6 m=1
	xi3 (net51 vdda) prim_pd AREA=790e-15 PJ=3.3e-6 m=1
	xr0 (vssa vdda net51) prim_rdiffp l=2.1e-6 w=700e-9 m=1
	xr1 (vdda vdda net69) prim_rdiffp l=2.2e-07 w=1.4e-06 m=1
	xcc01 (net12 out) prim_cpoly c=1p m=1
	mnm12 (net13 net56 vssa vssa) nmos1 l=180n w=1u m=1
	mnm11 (net56 net56 vssa vssa) nmos1 l=180n w=1u m=1
	mnb02 (net27 net27 net21 vssa) nmos1 l=180n w=1u m=1
	mnpd1 (net21 xpd vssa vssa) nmos1 l=180n w=1u m=1
	mn001 (out net13 vssa vssa) nmos1 l=180n w=1u m=1
	mnpd2 (net13 pd vssa vssa) nmos1 l=180n w=1u m=1
	mnc01 (net13 net69 net12 vssa) nmos1 l=180n w=1u m=1
	mpb02 (net27 net51 net158 vdda) pmos1 l=180n w=1u m=1
	mppd1 (net158 xpd vdda vdda) pmos1 l=180n w=1u m=1
	mps11 (net31 net158 vdda vdda) pmos1 l=180n w=1u m=1
	mpd11 (net56 inn net31 net31) pmos1 l=180n w=1u m=1
	mp001 (out net158 vdda vdda) pmos1 l=3.0e-07n w=8.4e-07u m=1
	mpd12 (net13 inp net31 net31) pmos1 l=2.8e-07n w=1.3e-06u m=1
	mpb01 (net158 net158 vdda vdda) pmos1 l=1.6e-07n w=1.7e-06u m=1
ends OPAMP1_variant227

subckt OPAMP1_variant228 inn inp out pd xpd vdda vssa
	xd1 (vssa vdda) prim_nwd AREA=6.13907e-9 PJ=476.6e-6 m=1
	xi0 (vssa net69) prim_nd AREA=1e-12 PJ=4e-6 m=1
	xi3 (net51 vdda) prim_pd AREA=790e-15 PJ=3.3e-6 m=1
	xr0 (vssa vdda net51) prim_rdiffp l=2.9e-07 w=6.3e-07 m=1
	xr1 (vdda vdda net69) prim_rdiffp l=1.9e-07 w=1.4e-06 m=1
	xcc01 (net12 out) prim_cpoly c=1p m=1
	mnm12 (net13 net56 vssa vssa) nmos1 l=180n w=1u m=1
	mnm11 (net56 net56 vssa vssa) nmos1 l=180n w=1u m=1
	mnb02 (net27 net27 net21 vssa) nmos1 l=180n w=1u m=1
	mnpd1 (net21 xpd vssa vssa) nmos1 l=180n w=1u m=1
	mn001 (out net13 vssa vssa) nmos1 l=180n w=1u m=1
	mnpd2 (net13 pd vssa vssa) nmos1 l=180n w=1u m=1
	mnc01 (net13 net69 net12 vssa) nmos1 l=180n w=1u m=1
	mpb02 (net27 net51 net158 vdda) pmos1 l=1.5e-07n w=1.8e-06u m=1
	mppd1 (net158 xpd vdda vdda) pmos1 l=180n w=1u m=1
	mps11 (net31 net158 vdda vdda) pmos1 l=180n w=1u m=1
	mpd11 (net56 inn net31 net31) pmos1 l=180n w=1u m=1
	mp001 (out net158 vdda vdda) pmos1 l=180n w=1u m=1
	mpd12 (net13 inp net31 net31) pmos1 l=180n w=1u m=1
	mpb01 (net158 net158 vdda vdda) pmos1 l=180n w=1u m=1
ends OPAMP1_variant228

subckt OPAMP1_variant229 inn inp out pd xpd vdda vssa
	xd1 (vssa vdda) prim_nwd AREA=6.13907e-9 PJ=476.6e-6 m=1
	xi0 (vssa net69) prim_nd AREA=1e-12 PJ=4e-6 m=1
	xi3 (net51 vdda) prim_pd AREA=790e-15 PJ=3.3e-6 m=1
	xr0 (vssa vdda net51) prim_rdiffp l=2.1e-6 w=700e-9 m=1
	xr1 (vdda vdda net69) prim_rdiffp l=2.1e-6 w=700e-9 m=1
	xcc01 (net12 out) prim_cpoly c=1p m=1
	mnm12 (net13 net56 vssa vssa) nmos1 l=180n w=1u m=1
	mnm11 (net56 net56 vssa vssa) nmos1 l=180n w=1u m=1
	mnb02 (net27 net27 net21 vssa) nmos1 l=1.5e-07n w=6.5e-07u m=1
	mnpd1 (net21 xpd vssa vssa) nmos1 l=180n w=1u m=1
	mn001 (out net13 vssa vssa) nmos1 l=180n w=1u m=1
	mnpd2 (net13 pd vssa vssa) nmos1 l=180n w=1u m=1
	mnc01 (net13 net69 net12 vssa) nmos1 l=1.8e-07n w=5.7e-07u m=1
	mpb02 (net27 net51 net158 vdda) pmos1 l=1.1e-07n w=1.4e-06u m=1
	mppd1 (net158 xpd vdda vdda) pmos1 l=180n w=1u m=1
	mps11 (net31 net158 vdda vdda) pmos1 l=180n w=1u m=1
	mpd11 (net56 inn net31 net31) pmos1 l=180n w=1u m=1
	mp001 (out net158 vdda vdda) pmos1 l=2.4e-07n w=1.6e-06u m=1
	mpd12 (net13 inp net31 net31) pmos1 l=2.1e-07n w=5.2e-07u m=1
	mpb01 (net158 net158 vdda vdda) pmos1 l=180n w=1u m=1
ends OPAMP1_variant229

subckt OPAMP1_variant230 inn inp out pd xpd vdda vssa
	xd1 (vssa vdda) prim_nwd AREA=6.13907e-9 PJ=476.6e-6 m=1
	xi0 (vssa net69) prim_nd AREA=1e-12 PJ=4e-6 m=1
	xi3 (net51 vdda) prim_pd AREA=790e-15 PJ=3.3e-6 m=1
	xr0 (vssa vdda net51) prim_rdiffp l=1.1e-07 w=1.8e-06 m=1
	xr1 (vdda vdda net69) prim_rdiffp l=2.1e-6 w=700e-9 m=1
	xcc01 (net12 out) prim_cpoly c=1p m=1
	mnm12 (net13 net56 vssa vssa) nmos1 l=180n w=1u m=1
	mnm11 (net56 net56 vssa vssa) nmos1 l=180n w=1u m=1
	mnb02 (net27 net27 net21 vssa) nmos1 l=180n w=1u m=1
	mnpd1 (net21 xpd vssa vssa) nmos1 l=180n w=1u m=1
	mn001 (out net13 vssa vssa) nmos1 l=180n w=1u m=1
	mnpd2 (net13 pd vssa vssa) nmos1 l=180n w=1u m=1
	mnc01 (net13 net69 net12 vssa) nmos1 l=180n w=1u m=1
	mpb02 (net27 net51 net158 vdda) pmos1 l=180n w=1u m=1
	mppd1 (net158 xpd vdda vdda) pmos1 l=180n w=1u m=1
	mps11 (net31 net158 vdda vdda) pmos1 l=180n w=1u m=1
	mpd11 (net56 inn net31 net31) pmos1 l=1.6e-07n w=1.7e-06u m=1
	mp001 (out net158 vdda vdda) pmos1 l=180n w=1u m=1
	mpd12 (net13 inp net31 net31) pmos1 l=180n w=1u m=1
	mpb01 (net158 net158 vdda vdda) pmos1 l=180n w=1u m=1
ends OPAMP1_variant230

subckt OPAMP1_variant231 inn inp out pd xpd vdda vssa
	xd1 (vssa vdda) prim_nwd AREA=6.13907e-9 PJ=476.6e-6 m=1
	xi0 (vssa net69) prim_nd AREA=1e-12 PJ=4e-6 m=1
	xi3 (net51 vdda) prim_pd AREA=790e-15 PJ=3.3e-6 m=1
	xr0 (vssa vdda net51) prim_rdiffp l=2.1e-6 w=700e-9 m=1
	xr1 (vdda vdda net69) prim_rdiffp l=2.1e-6 w=700e-9 m=1
	xcc01 (net12 out) prim_cpoly c=1p m=1
	mnm12 (net13 net56 vssa vssa) nmos1 l=180n w=1u m=1
	mnm11 (net56 net56 vssa vssa) nmos1 l=180n w=1u m=1
	mnb02 (net27 net27 net21 vssa) nmos1 l=180n w=1u m=1
	mnpd1 (net21 xpd vssa vssa) nmos1 l=180n w=1u m=1
	mn001 (out net13 vssa vssa) nmos1 l=180n w=1u m=1
	mnpd2 (net13 pd vssa vssa) nmos1 l=1.3e-07n w=8.3e-07u m=1
	mnc01 (net13 net69 net12 vssa) nmos1 l=180n w=1u m=1
	mpb02 (net27 net51 net158 vdda) pmos1 l=180n w=1u m=1
	mppd1 (net158 xpd vdda vdda) pmos1 l=180n w=1u m=1
	mps11 (net31 net158 vdda vdda) pmos1 l=180n w=1u m=1
	mpd11 (net56 inn net31 net31) pmos1 l=180n w=1u m=1
	mp001 (out net158 vdda vdda) pmos1 l=180n w=1u m=1
	mpd12 (net13 inp net31 net31) pmos1 l=1.5e-07n w=1.6e-06u m=1
	mpb01 (net158 net158 vdda vdda) pmos1 l=180n w=1u m=1
ends OPAMP1_variant231

subckt OPAMP1_variant232 inn inp out pd xpd vdda vssa
	xd1 (vssa vdda) prim_nwd AREA=6.13907e-9 PJ=476.6e-6 m=1
	xi0 (vssa net69) prim_nd AREA=1e-12 PJ=4e-6 m=1
	xi3 (net51 vdda) prim_pd AREA=790e-15 PJ=3.3e-6 m=1
	xr0 (vssa vdda net51) prim_rdiffp l=1.6e-07 w=1.6e-06 m=1
	xr1 (vdda vdda net69) prim_rdiffp l=3.0e-07 w=1.6e-06 m=1
	xcc01 (net12 out) prim_cpoly c=1p m=1
	mnm12 (net13 net56 vssa vssa) nmos1 l=180n w=1u m=1
	mnm11 (net56 net56 vssa vssa) nmos1 l=180n w=1u m=1
	mnb02 (net27 net27 net21 vssa) nmos1 l=180n w=1u m=1
	mnpd1 (net21 xpd vssa vssa) nmos1 l=2.0e-07n w=1.7e-06u m=1
	mn001 (out net13 vssa vssa) nmos1 l=180n w=1u m=1
	mnpd2 (net13 pd vssa vssa) nmos1 l=180n w=1u m=1
	mnc01 (net13 net69 net12 vssa) nmos1 l=180n w=1u m=1
	mpb02 (net27 net51 net158 vdda) pmos1 l=180n w=1u m=1
	mppd1 (net158 xpd vdda vdda) pmos1 l=180n w=1u m=1
	mps11 (net31 net158 vdda vdda) pmos1 l=1.8e-07n w=6.0e-07u m=1
	mpd11 (net56 inn net31 net31) pmos1 l=180n w=1u m=1
	mp001 (out net158 vdda vdda) pmos1 l=180n w=1u m=1
	mpd12 (net13 inp net31 net31) pmos1 l=180n w=1u m=1
	mpb01 (net158 net158 vdda vdda) pmos1 l=180n w=1u m=1
ends OPAMP1_variant232

subckt OPAMP1_variant233 inn inp out pd xpd vdda vssa
	xd1 (vssa vdda) prim_nwd AREA=6.13907e-9 PJ=476.6e-6 m=1
	xi0 (vssa net69) prim_nd AREA=6.1e-09 PJ=9.3e-05 m=1
	xi3 (net51 vdda) prim_pd AREA=790e-15 PJ=3.3e-6 m=1
	xr0 (vssa vdda net51) prim_rdiffp l=2.1e-6 w=700e-9 m=1
	xr1 (vdda vdda net69) prim_rdiffp l=2.1e-6 w=700e-9 m=1
	xcc01 (net12 out) prim_cpoly c=1p m=1
	mnm12 (net13 net56 vssa vssa) nmos1 l=180n w=1u m=1
	mnm11 (net56 net56 vssa vssa) nmos1 l=2.5e-07n w=7.7e-07u m=1
	mnb02 (net27 net27 net21 vssa) nmos1 l=180n w=1u m=1
	mnpd1 (net21 xpd vssa vssa) nmos1 l=180n w=1u m=1
	mn001 (out net13 vssa vssa) nmos1 l=180n w=1u m=1
	mnpd2 (net13 pd vssa vssa) nmos1 l=180n w=1u m=1
	mnc01 (net13 net69 net12 vssa) nmos1 l=180n w=1u m=1
	mpb02 (net27 net51 net158 vdda) pmos1 l=1.5e-07n w=1.7e-06u m=1
	mppd1 (net158 xpd vdda vdda) pmos1 l=2.7e-07n w=1.8e-06u m=1
	mps11 (net31 net158 vdda vdda) pmos1 l=180n w=1u m=1
	mpd11 (net56 inn net31 net31) pmos1 l=180n w=1u m=1
	mp001 (out net158 vdda vdda) pmos1 l=180n w=1u m=1
	mpd12 (net13 inp net31 net31) pmos1 l=180n w=1u m=1
	mpb01 (net158 net158 vdda vdda) pmos1 l=180n w=1u m=1
ends OPAMP1_variant233

subckt OPAMP1_variant234 inn inp out pd xpd vdda vssa
	xd1 (vssa vdda) prim_nwd AREA=6.13907e-9 PJ=476.6e-6 m=1
	xi0 (vssa net69) prim_nd AREA=1e-12 PJ=4e-6 m=1
	xi3 (net51 vdda) prim_pd AREA=790e-15 PJ=3.3e-6 m=1
	xr0 (vssa vdda net51) prim_rdiffp l=2.1e-6 w=700e-9 m=1
	xr1 (vdda vdda net69) prim_rdiffp l=2.1e-6 w=700e-9 m=1
	xcc01 (net12 out) prim_cpoly c=1p m=1
	mnm12 (net13 net56 vssa vssa) nmos1 l=180n w=1u m=1
	mnm11 (net56 net56 vssa vssa) nmos1 l=180n w=1u m=1
	mnb02 (net27 net27 net21 vssa) nmos1 l=180n w=1u m=1
	mnpd1 (net21 xpd vssa vssa) nmos1 l=2.9e-07n w=5.5e-07u m=1
	mn001 (out net13 vssa vssa) nmos1 l=180n w=1u m=1
	mnpd2 (net13 pd vssa vssa) nmos1 l=180n w=1u m=1
	mnc01 (net13 net69 net12 vssa) nmos1 l=180n w=1u m=1
	mpb02 (net27 net51 net158 vdda) pmos1 l=180n w=1u m=1
	mppd1 (net158 xpd vdda vdda) pmos1 l=180n w=1u m=1
	mps11 (net31 net158 vdda vdda) pmos1 l=2.4e-07n w=1.2e-06u m=1
	mpd11 (net56 inn net31 net31) pmos1 l=180n w=1u m=1
	mp001 (out net158 vdda vdda) pmos1 l=180n w=1u m=1
	mpd12 (net13 inp net31 net31) pmos1 l=180n w=1u m=1
	mpb01 (net158 net158 vdda vdda) pmos1 l=180n w=1u m=1
ends OPAMP1_variant234

subckt OPAMP1_variant235 inn inp out pd xpd vdda vssa
	xd1 (vssa vdda) prim_nwd AREA=6.5e-09 PJ=5.8e-05 m=1
	xi0 (vssa net69) prim_nd AREA=1e-12 PJ=4e-6 m=1
	xi3 (net51 vdda) prim_pd AREA=2.5e-09 PJ=6.3e-05 m=1
	xr0 (vssa vdda net51) prim_rdiffp l=2.1e-6 w=700e-9 m=1
	xr1 (vdda vdda net69) prim_rdiffp l=2.1e-6 w=700e-9 m=1
	xcc01 (net12 out) prim_cpoly c=8.6e-13p m=1
	mnm12 (net13 net56 vssa vssa) nmos1 l=180n w=1u m=1
	mnm11 (net56 net56 vssa vssa) nmos1 l=180n w=1u m=1
	mnb02 (net27 net27 net21 vssa) nmos1 l=180n w=1u m=1
	mnpd1 (net21 xpd vssa vssa) nmos1 l=180n w=1u m=1
	mn001 (out net13 vssa vssa) nmos1 l=180n w=1u m=1
	mnpd2 (net13 pd vssa vssa) nmos1 l=180n w=1u m=1
	mnc01 (net13 net69 net12 vssa) nmos1 l=180n w=1u m=1
	mpb02 (net27 net51 net158 vdda) pmos1 l=2.7e-07n w=1.1e-06u m=1
	mppd1 (net158 xpd vdda vdda) pmos1 l=180n w=1u m=1
	mps11 (net31 net158 vdda vdda) pmos1 l=180n w=1u m=1
	mpd11 (net56 inn net31 net31) pmos1 l=180n w=1u m=1
	mp001 (out net158 vdda vdda) pmos1 l=1.6e-07n w=1.4e-06u m=1
	mpd12 (net13 inp net31 net31) pmos1 l=180n w=1u m=1
	mpb01 (net158 net158 vdda vdda) pmos1 l=180n w=1u m=1
ends OPAMP1_variant235

subckt OPAMP1_variant236 inn inp out pd xpd vdda vssa
	xd1 (vssa vdda) prim_nwd AREA=6.13907e-9 PJ=476.6e-6 m=1
	xi0 (vssa net69) prim_nd AREA=1e-12 PJ=4e-6 m=1
	xi3 (net51 vdda) prim_pd AREA=790e-15 PJ=3.3e-6 m=1
	xr0 (vssa vdda net51) prim_rdiffp l=1.3e-07 w=1.7e-06 m=1
	xr1 (vdda vdda net69) prim_rdiffp l=2.1e-6 w=700e-9 m=1
	xcc01 (net12 out) prim_cpoly c=1p m=1
	mnm12 (net13 net56 vssa vssa) nmos1 l=180n w=1u m=1
	mnm11 (net56 net56 vssa vssa) nmos1 l=180n w=1u m=1
	mnb02 (net27 net27 net21 vssa) nmos1 l=180n w=1u m=1
	mnpd1 (net21 xpd vssa vssa) nmos1 l=180n w=1u m=1
	mn001 (out net13 vssa vssa) nmos1 l=180n w=1u m=1
	mnpd2 (net13 pd vssa vssa) nmos1 l=180n w=1u m=1
	mnc01 (net13 net69 net12 vssa) nmos1 l=2.9e-07n w=7.4e-07u m=1
	mpb02 (net27 net51 net158 vdda) pmos1 l=180n w=1u m=1
	mppd1 (net158 xpd vdda vdda) pmos1 l=2.3e-07n w=1.7e-06u m=1
	mps11 (net31 net158 vdda vdda) pmos1 l=180n w=1u m=1
	mpd11 (net56 inn net31 net31) pmos1 l=180n w=1u m=1
	mp001 (out net158 vdda vdda) pmos1 l=180n w=1u m=1
	mpd12 (net13 inp net31 net31) pmos1 l=180n w=1u m=1
	mpb01 (net158 net158 vdda vdda) pmos1 l=180n w=1u m=1
ends OPAMP1_variant236

subckt OPAMP1_variant237 inn inp out pd xpd vdda vssa
	xd1 (vssa vdda) prim_nwd AREA=6.13907e-9 PJ=476.6e-6 m=1
	xi0 (vssa net69) prim_nd AREA=1e-12 PJ=4e-6 m=1
	xi3 (net51 vdda) prim_pd AREA=790e-15 PJ=3.3e-6 m=1
	xr0 (vssa vdda net51) prim_rdiffp l=2.1e-6 w=700e-9 m=1
	xr1 (vdda vdda net69) prim_rdiffp l=2.1e-6 w=700e-9 m=1
	xcc01 (net12 out) prim_cpoly c=1p m=1
	mnm12 (net13 net56 vssa vssa) nmos1 l=180n w=1u m=1
	mnm11 (net56 net56 vssa vssa) nmos1 l=180n w=1u m=1
	mnb02 (net27 net27 net21 vssa) nmos1 l=2.6e-07n w=1.8e-06u m=1
	mnpd1 (net21 xpd vssa vssa) nmos1 l=180n w=1u m=1
	mn001 (out net13 vssa vssa) nmos1 l=180n w=1u m=1
	mnpd2 (net13 pd vssa vssa) nmos1 l=180n w=1u m=1
	mnc01 (net13 net69 net12 vssa) nmos1 l=180n w=1u m=1
	mpb02 (net27 net51 net158 vdda) pmos1 l=180n w=1u m=1
	mppd1 (net158 xpd vdda vdda) pmos1 l=2.1e-07n w=1.1e-06u m=1
	mps11 (net31 net158 vdda vdda) pmos1 l=180n w=1u m=1
	mpd11 (net56 inn net31 net31) pmos1 l=180n w=1u m=1
	mp001 (out net158 vdda vdda) pmos1 l=180n w=1u m=1
	mpd12 (net13 inp net31 net31) pmos1 l=180n w=1u m=1
	mpb01 (net158 net158 vdda vdda) pmos1 l=180n w=1u m=1
ends OPAMP1_variant237

subckt OPAMP1_variant238 inn inp out pd xpd vdda vssa
	xd1 (vssa vdda) prim_nwd AREA=6.13907e-9 PJ=476.6e-6 m=1
	xi0 (vssa net69) prim_nd AREA=1e-12 PJ=4e-6 m=1
	xi3 (net51 vdda) prim_pd AREA=790e-15 PJ=3.3e-6 m=1
	xr0 (vssa vdda net51) prim_rdiffp l=2.1e-6 w=700e-9 m=1
	xr1 (vdda vdda net69) prim_rdiffp l=2.1e-6 w=700e-9 m=1
	xcc01 (net12 out) prim_cpoly c=7.3e-13p m=1
	mnm12 (net13 net56 vssa vssa) nmos1 l=2.0e-07n w=7.4e-07u m=1
	mnm11 (net56 net56 vssa vssa) nmos1 l=180n w=1u m=1
	mnb02 (net27 net27 net21 vssa) nmos1 l=180n w=1u m=1
	mnpd1 (net21 xpd vssa vssa) nmos1 l=180n w=1u m=1
	mn001 (out net13 vssa vssa) nmos1 l=180n w=1u m=1
	mnpd2 (net13 pd vssa vssa) nmos1 l=180n w=1u m=1
	mnc01 (net13 net69 net12 vssa) nmos1 l=180n w=1u m=1
	mpb02 (net27 net51 net158 vdda) pmos1 l=180n w=1u m=1
	mppd1 (net158 xpd vdda vdda) pmos1 l=180n w=1u m=1
	mps11 (net31 net158 vdda vdda) pmos1 l=1.5e-07n w=1.6e-06u m=1
	mpd11 (net56 inn net31 net31) pmos1 l=180n w=1u m=1
	mp001 (out net158 vdda vdda) pmos1 l=1.2e-07n w=1.5e-06u m=1
	mpd12 (net13 inp net31 net31) pmos1 l=180n w=1u m=1
	mpb01 (net158 net158 vdda vdda) pmos1 l=180n w=1u m=1
ends OPAMP1_variant238

subckt OPAMP1_variant239 inn inp out pd xpd vdda vssa
	xd1 (vssa vdda) prim_nwd AREA=6.13907e-9 PJ=476.6e-6 m=1
	xi0 (vssa net69) prim_nd AREA=1e-12 PJ=4e-6 m=1
	xi3 (net51 vdda) prim_pd AREA=1.5e-10 PJ=1.3e-05 m=1
	xr0 (vssa vdda net51) prim_rdiffp l=2.1e-6 w=700e-9 m=1
	xr1 (vdda vdda net69) prim_rdiffp l=1.3e-07 w=7.3e-07 m=1
	xcc01 (net12 out) prim_cpoly c=1p m=1
	mnm12 (net13 net56 vssa vssa) nmos1 l=180n w=1u m=1
	mnm11 (net56 net56 vssa vssa) nmos1 l=180n w=1u m=1
	mnb02 (net27 net27 net21 vssa) nmos1 l=180n w=1u m=1
	mnpd1 (net21 xpd vssa vssa) nmos1 l=1.7e-07n w=5.2e-07u m=1
	mn001 (out net13 vssa vssa) nmos1 l=180n w=1u m=1
	mnpd2 (net13 pd vssa vssa) nmos1 l=180n w=1u m=1
	mnc01 (net13 net69 net12 vssa) nmos1 l=2.5e-07n w=1.5e-06u m=1
	mpb02 (net27 net51 net158 vdda) pmos1 l=180n w=1u m=1
	mppd1 (net158 xpd vdda vdda) pmos1 l=180n w=1u m=1
	mps11 (net31 net158 vdda vdda) pmos1 l=180n w=1u m=1
	mpd11 (net56 inn net31 net31) pmos1 l=180n w=1u m=1
	mp001 (out net158 vdda vdda) pmos1 l=180n w=1u m=1
	mpd12 (net13 inp net31 net31) pmos1 l=180n w=1u m=1
	mpb01 (net158 net158 vdda vdda) pmos1 l=180n w=1u m=1
ends OPAMP1_variant239

subckt OPAMP1_variant240 inn inp out pd xpd vdda vssa
	xd1 (vssa vdda) prim_nwd AREA=6.13907e-9 PJ=476.6e-6 m=1
	xi0 (vssa net69) prim_nd AREA=1e-12 PJ=4e-6 m=1
	xi3 (net51 vdda) prim_pd AREA=790e-15 PJ=3.3e-6 m=1
	xr0 (vssa vdda net51) prim_rdiffp l=2.1e-6 w=700e-9 m=1
	xr1 (vdda vdda net69) prim_rdiffp l=2.1e-6 w=700e-9 m=1
	xcc01 (net12 out) prim_cpoly c=1p m=1
	mnm12 (net13 net56 vssa vssa) nmos1 l=180n w=1u m=1
	mnm11 (net56 net56 vssa vssa) nmos1 l=180n w=1u m=1
	mnb02 (net27 net27 net21 vssa) nmos1 l=180n w=1u m=1
	mnpd1 (net21 xpd vssa vssa) nmos1 l=180n w=1u m=1
	mn001 (out net13 vssa vssa) nmos1 l=180n w=1u m=1
	mnpd2 (net13 pd vssa vssa) nmos1 l=180n w=1u m=1
	mnc01 (net13 net69 net12 vssa) nmos1 l=180n w=1u m=1
	mpb02 (net27 net51 net158 vdda) pmos1 l=180n w=1u m=1
	mppd1 (net158 xpd vdda vdda) pmos1 l=180n w=1u m=1
	mps11 (net31 net158 vdda vdda) pmos1 l=1.1e-07n w=7.7e-07u m=1
	mpd11 (net56 inn net31 net31) pmos1 l=180n w=1u m=1
	mp001 (out net158 vdda vdda) pmos1 l=180n w=1u m=1
	mpd12 (net13 inp net31 net31) pmos1 l=180n w=1u m=1
	mpb01 (net158 net158 vdda vdda) pmos1 l=1.5e-07n w=1.8e-06u m=1
ends OPAMP1_variant240

subckt OPAMP1_variant241 inn inp out pd xpd vdda vssa
	xd1 (vssa vdda) prim_nwd AREA=6.13907e-9 PJ=476.6e-6 m=1
	xi0 (vssa net69) prim_nd AREA=1e-12 PJ=4e-6 m=1
	xi3 (net51 vdda) prim_pd AREA=9.4e-09 PJ=9.7e-06 m=1
	xr0 (vssa vdda net51) prim_rdiffp l=2.1e-6 w=700e-9 m=1
	xr1 (vdda vdda net69) prim_rdiffp l=2.1e-6 w=700e-9 m=1
	xcc01 (net12 out) prim_cpoly c=1p m=1
	mnm12 (net13 net56 vssa vssa) nmos1 l=1.0e-07n w=5.3e-07u m=1
	mnm11 (net56 net56 vssa vssa) nmos1 l=180n w=1u m=1
	mnb02 (net27 net27 net21 vssa) nmos1 l=180n w=1u m=1
	mnpd1 (net21 xpd vssa vssa) nmos1 l=180n w=1u m=1
	mn001 (out net13 vssa vssa) nmos1 l=180n w=1u m=1
	mnpd2 (net13 pd vssa vssa) nmos1 l=2.0e-07n w=1.7e-06u m=1
	mnc01 (net13 net69 net12 vssa) nmos1 l=180n w=1u m=1
	mpb02 (net27 net51 net158 vdda) pmos1 l=180n w=1u m=1
	mppd1 (net158 xpd vdda vdda) pmos1 l=180n w=1u m=1
	mps11 (net31 net158 vdda vdda) pmos1 l=180n w=1u m=1
	mpd11 (net56 inn net31 net31) pmos1 l=180n w=1u m=1
	mp001 (out net158 vdda vdda) pmos1 l=180n w=1u m=1
	mpd12 (net13 inp net31 net31) pmos1 l=180n w=1u m=1
	mpb01 (net158 net158 vdda vdda) pmos1 l=1.4e-07n w=1.8e-06u m=1
ends OPAMP1_variant241

subckt OPAMP1_variant242 inn inp out pd xpd vdda vssa
	xd1 (vssa vdda) prim_nwd AREA=6.13907e-9 PJ=476.6e-6 m=1
	xi0 (vssa net69) prim_nd AREA=1e-12 PJ=4e-6 m=1
	xi3 (net51 vdda) prim_pd AREA=790e-15 PJ=3.3e-6 m=1
	xr0 (vssa vdda net51) prim_rdiffp l=2.1e-6 w=700e-9 m=1
	xr1 (vdda vdda net69) prim_rdiffp l=2.1e-6 w=700e-9 m=1
	xcc01 (net12 out) prim_cpoly c=1p m=1
	mnm12 (net13 net56 vssa vssa) nmos1 l=180n w=1u m=1
	mnm11 (net56 net56 vssa vssa) nmos1 l=180n w=1u m=1
	mnb02 (net27 net27 net21 vssa) nmos1 l=180n w=1u m=1
	mnpd1 (net21 xpd vssa vssa) nmos1 l=1.1e-07n w=1.7e-06u m=1
	mn001 (out net13 vssa vssa) nmos1 l=180n w=1u m=1
	mnpd2 (net13 pd vssa vssa) nmos1 l=180n w=1u m=1
	mnc01 (net13 net69 net12 vssa) nmos1 l=180n w=1u m=1
	mpb02 (net27 net51 net158 vdda) pmos1 l=180n w=1u m=1
	mppd1 (net158 xpd vdda vdda) pmos1 l=1.9e-07n w=1.4e-06u m=1
	mps11 (net31 net158 vdda vdda) pmos1 l=1.1e-07n w=1.5e-06u m=1
	mpd11 (net56 inn net31 net31) pmos1 l=180n w=1u m=1
	mp001 (out net158 vdda vdda) pmos1 l=180n w=1u m=1
	mpd12 (net13 inp net31 net31) pmos1 l=1.4e-07n w=1.4e-06u m=1
	mpb01 (net158 net158 vdda vdda) pmos1 l=180n w=1u m=1
ends OPAMP1_variant242

subckt OPAMP1_variant243 inn inp out pd xpd vdda vssa
	xd1 (vssa vdda) prim_nwd AREA=2.6e-09 PJ=2.9e-05 m=1
	xi0 (vssa net69) prim_nd AREA=1e-12 PJ=4e-6 m=1
	xi3 (net51 vdda) prim_pd AREA=790e-15 PJ=3.3e-6 m=1
	xr0 (vssa vdda net51) prim_rdiffp l=2.1e-6 w=700e-9 m=1
	xr1 (vdda vdda net69) prim_rdiffp l=2.1e-6 w=700e-9 m=1
	xcc01 (net12 out) prim_cpoly c=1p m=1
	mnm12 (net13 net56 vssa vssa) nmos1 l=180n w=1u m=1
	mnm11 (net56 net56 vssa vssa) nmos1 l=180n w=1u m=1
	mnb02 (net27 net27 net21 vssa) nmos1 l=180n w=1u m=1
	mnpd1 (net21 xpd vssa vssa) nmos1 l=180n w=1u m=1
	mn001 (out net13 vssa vssa) nmos1 l=180n w=1u m=1
	mnpd2 (net13 pd vssa vssa) nmos1 l=2.2e-07n w=1.1e-06u m=1
	mnc01 (net13 net69 net12 vssa) nmos1 l=180n w=1u m=1
	mpb02 (net27 net51 net158 vdda) pmos1 l=180n w=1u m=1
	mppd1 (net158 xpd vdda vdda) pmos1 l=1.5e-07n w=1.5e-06u m=1
	mps11 (net31 net158 vdda vdda) pmos1 l=180n w=1u m=1
	mpd11 (net56 inn net31 net31) pmos1 l=180n w=1u m=1
	mp001 (out net158 vdda vdda) pmos1 l=180n w=1u m=1
	mpd12 (net13 inp net31 net31) pmos1 l=2.6e-07n w=2.0e-06u m=1
	mpb01 (net158 net158 vdda vdda) pmos1 l=2.2e-07n w=1.2e-06u m=1
ends OPAMP1_variant243

subckt OPAMP1_variant244 inn inp out pd xpd vdda vssa
	xd1 (vssa vdda) prim_nwd AREA=6.13907e-9 PJ=476.6e-6 m=1
	xi0 (vssa net69) prim_nd AREA=1e-12 PJ=4e-6 m=1
	xi3 (net51 vdda) prim_pd AREA=790e-15 PJ=3.3e-6 m=1
	xr0 (vssa vdda net51) prim_rdiffp l=2.4e-07 w=1.1e-06 m=1
	xr1 (vdda vdda net69) prim_rdiffp l=2.1e-6 w=700e-9 m=1
	xcc01 (net12 out) prim_cpoly c=1p m=1
	mnm12 (net13 net56 vssa vssa) nmos1 l=180n w=1u m=1
	mnm11 (net56 net56 vssa vssa) nmos1 l=180n w=1u m=1
	mnb02 (net27 net27 net21 vssa) nmos1 l=180n w=1u m=1
	mnpd1 (net21 xpd vssa vssa) nmos1 l=180n w=1u m=1
	mn001 (out net13 vssa vssa) nmos1 l=180n w=1u m=1
	mnpd2 (net13 pd vssa vssa) nmos1 l=180n w=1u m=1
	mnc01 (net13 net69 net12 vssa) nmos1 l=180n w=1u m=1
	mpb02 (net27 net51 net158 vdda) pmos1 l=1.0e-07n w=9.9e-07u m=1
	mppd1 (net158 xpd vdda vdda) pmos1 l=180n w=1u m=1
	mps11 (net31 net158 vdda vdda) pmos1 l=180n w=1u m=1
	mpd11 (net56 inn net31 net31) pmos1 l=180n w=1u m=1
	mp001 (out net158 vdda vdda) pmos1 l=180n w=1u m=1
	mpd12 (net13 inp net31 net31) pmos1 l=180n w=1u m=1
	mpb01 (net158 net158 vdda vdda) pmos1 l=180n w=1u m=1
ends OPAMP1_variant244

subckt OPAMP1_variant245 inn inp out pd xpd vdda vssa
	xd1 (vssa vdda) prim_nwd AREA=6.13907e-9 PJ=476.6e-6 m=1
	xi0 (vssa net69) prim_nd AREA=1e-12 PJ=4e-6 m=1
	xi3 (net51 vdda) prim_pd AREA=790e-15 PJ=3.3e-6 m=1
	xr0 (vssa vdda net51) prim_rdiffp l=2.1e-6 w=700e-9 m=1
	xr1 (vdda vdda net69) prim_rdiffp l=2.2e-07 w=1.6e-06 m=1
	xcc01 (net12 out) prim_cpoly c=1p m=1
	mnm12 (net13 net56 vssa vssa) nmos1 l=2.4e-07n w=8.1e-07u m=1
	mnm11 (net56 net56 vssa vssa) nmos1 l=180n w=1u m=1
	mnb02 (net27 net27 net21 vssa) nmos1 l=180n w=1u m=1
	mnpd1 (net21 xpd vssa vssa) nmos1 l=180n w=1u m=1
	mn001 (out net13 vssa vssa) nmos1 l=180n w=1u m=1
	mnpd2 (net13 pd vssa vssa) nmos1 l=180n w=1u m=1
	mnc01 (net13 net69 net12 vssa) nmos1 l=180n w=1u m=1
	mpb02 (net27 net51 net158 vdda) pmos1 l=180n w=1u m=1
	mppd1 (net158 xpd vdda vdda) pmos1 l=180n w=1u m=1
	mps11 (net31 net158 vdda vdda) pmos1 l=180n w=1u m=1
	mpd11 (net56 inn net31 net31) pmos1 l=180n w=1u m=1
	mp001 (out net158 vdda vdda) pmos1 l=180n w=1u m=1
	mpd12 (net13 inp net31 net31) pmos1 l=1.1e-07n w=1.8e-06u m=1
	mpb01 (net158 net158 vdda vdda) pmos1 l=180n w=1u m=1
ends OPAMP1_variant245

subckt OPAMP1_variant246 inn inp out pd xpd vdda vssa
	xd1 (vssa vdda) prim_nwd AREA=6.13907e-9 PJ=476.6e-6 m=1
	xi0 (vssa net69) prim_nd AREA=1e-12 PJ=4e-6 m=1
	xi3 (net51 vdda) prim_pd AREA=790e-15 PJ=3.3e-6 m=1
	xr0 (vssa vdda net51) prim_rdiffp l=2.9e-07 w=1.0e-06 m=1
	xr1 (vdda vdda net69) prim_rdiffp l=2.1e-6 w=700e-9 m=1
	xcc01 (net12 out) prim_cpoly c=1p m=1
	mnm12 (net13 net56 vssa vssa) nmos1 l=1.7e-07n w=2.0e-06u m=1
	mnm11 (net56 net56 vssa vssa) nmos1 l=180n w=1u m=1
	mnb02 (net27 net27 net21 vssa) nmos1 l=1.9e-07n w=1.6e-06u m=1
	mnpd1 (net21 xpd vssa vssa) nmos1 l=180n w=1u m=1
	mn001 (out net13 vssa vssa) nmos1 l=180n w=1u m=1
	mnpd2 (net13 pd vssa vssa) nmos1 l=180n w=1u m=1
	mnc01 (net13 net69 net12 vssa) nmos1 l=2.8e-07n w=1.7e-06u m=1
	mpb02 (net27 net51 net158 vdda) pmos1 l=180n w=1u m=1
	mppd1 (net158 xpd vdda vdda) pmos1 l=180n w=1u m=1
	mps11 (net31 net158 vdda vdda) pmos1 l=180n w=1u m=1
	mpd11 (net56 inn net31 net31) pmos1 l=180n w=1u m=1
	mp001 (out net158 vdda vdda) pmos1 l=180n w=1u m=1
	mpd12 (net13 inp net31 net31) pmos1 l=180n w=1u m=1
	mpb01 (net158 net158 vdda vdda) pmos1 l=180n w=1u m=1
ends OPAMP1_variant246

subckt OPAMP1_variant247 inn inp out pd xpd vdda vssa
	xd1 (vssa vdda) prim_nwd AREA=6.13907e-9 PJ=476.6e-6 m=1
	xi0 (vssa net69) prim_nd AREA=1e-12 PJ=4e-6 m=1
	xi3 (net51 vdda) prim_pd AREA=790e-15 PJ=3.3e-6 m=1
	xr0 (vssa vdda net51) prim_rdiffp l=2.1e-6 w=700e-9 m=1
	xr1 (vdda vdda net69) prim_rdiffp l=2.1e-6 w=700e-9 m=1
	xcc01 (net12 out) prim_cpoly c=1p m=1
	mnm12 (net13 net56 vssa vssa) nmos1 l=180n w=1u m=1
	mnm11 (net56 net56 vssa vssa) nmos1 l=180n w=1u m=1
	mnb02 (net27 net27 net21 vssa) nmos1 l=180n w=1u m=1
	mnpd1 (net21 xpd vssa vssa) nmos1 l=180n w=1u m=1
	mn001 (out net13 vssa vssa) nmos1 l=180n w=1u m=1
	mnpd2 (net13 pd vssa vssa) nmos1 l=180n w=1u m=1
	mnc01 (net13 net69 net12 vssa) nmos1 l=180n w=1u m=1
	mpb02 (net27 net51 net158 vdda) pmos1 l=180n w=1u m=1
	mppd1 (net158 xpd vdda vdda) pmos1 l=2.4e-07n w=1.5e-06u m=1
	mps11 (net31 net158 vdda vdda) pmos1 l=180n w=1u m=1
	mpd11 (net56 inn net31 net31) pmos1 l=180n w=1u m=1
	mp001 (out net158 vdda vdda) pmos1 l=180n w=1u m=1
	mpd12 (net13 inp net31 net31) pmos1 l=1.4e-07n w=1.4e-06u m=1
	mpb01 (net158 net158 vdda vdda) pmos1 l=180n w=1u m=1
ends OPAMP1_variant247

subckt OPAMP1_variant248 inn inp out pd xpd vdda vssa
	xd1 (vssa vdda) prim_nwd AREA=6.13907e-9 PJ=476.6e-6 m=1
	xi0 (vssa net69) prim_nd AREA=1e-12 PJ=4e-6 m=1
	xi3 (net51 vdda) prim_pd AREA=790e-15 PJ=3.3e-6 m=1
	xr0 (vssa vdda net51) prim_rdiffp l=2.1e-6 w=700e-9 m=1
	xr1 (vdda vdda net69) prim_rdiffp l=1.8e-07 w=1.4e-06 m=1
	xcc01 (net12 out) prim_cpoly c=8.2e-13p m=1
	mnm12 (net13 net56 vssa vssa) nmos1 l=180n w=1u m=1
	mnm11 (net56 net56 vssa vssa) nmos1 l=180n w=1u m=1
	mnb02 (net27 net27 net21 vssa) nmos1 l=180n w=1u m=1
	mnpd1 (net21 xpd vssa vssa) nmos1 l=180n w=1u m=1
	mn001 (out net13 vssa vssa) nmos1 l=180n w=1u m=1
	mnpd2 (net13 pd vssa vssa) nmos1 l=180n w=1u m=1
	mnc01 (net13 net69 net12 vssa) nmos1 l=2.6e-07n w=5.8e-07u m=1
	mpb02 (net27 net51 net158 vdda) pmos1 l=180n w=1u m=1
	mppd1 (net158 xpd vdda vdda) pmos1 l=180n w=1u m=1
	mps11 (net31 net158 vdda vdda) pmos1 l=180n w=1u m=1
	mpd11 (net56 inn net31 net31) pmos1 l=180n w=1u m=1
	mp001 (out net158 vdda vdda) pmos1 l=180n w=1u m=1
	mpd12 (net13 inp net31 net31) pmos1 l=180n w=1u m=1
	mpb01 (net158 net158 vdda vdda) pmos1 l=180n w=1u m=1
ends OPAMP1_variant248

subckt OPAMP1_variant249 inn inp out pd xpd vdda vssa
	xd1 (vssa vdda) prim_nwd AREA=6.4e-09 PJ=2.8e-05 m=1
	xi0 (vssa net69) prim_nd AREA=1e-12 PJ=4e-6 m=1
	xi3 (net51 vdda) prim_pd AREA=790e-15 PJ=3.3e-6 m=1
	xr0 (vssa vdda net51) prim_rdiffp l=2.1e-6 w=700e-9 m=1
	xr1 (vdda vdda net69) prim_rdiffp l=2.1e-6 w=700e-9 m=1
	xcc01 (net12 out) prim_cpoly c=5.7e-13p m=1
	mnm12 (net13 net56 vssa vssa) nmos1 l=2.1e-07n w=8.7e-07u m=1
	mnm11 (net56 net56 vssa vssa) nmos1 l=180n w=1u m=1
	mnb02 (net27 net27 net21 vssa) nmos1 l=180n w=1u m=1
	mnpd1 (net21 xpd vssa vssa) nmos1 l=180n w=1u m=1
	mn001 (out net13 vssa vssa) nmos1 l=180n w=1u m=1
	mnpd2 (net13 pd vssa vssa) nmos1 l=180n w=1u m=1
	mnc01 (net13 net69 net12 vssa) nmos1 l=1.4e-07n w=1.7e-06u m=1
	mpb02 (net27 net51 net158 vdda) pmos1 l=180n w=1u m=1
	mppd1 (net158 xpd vdda vdda) pmos1 l=180n w=1u m=1
	mps11 (net31 net158 vdda vdda) pmos1 l=180n w=1u m=1
	mpd11 (net56 inn net31 net31) pmos1 l=180n w=1u m=1
	mp001 (out net158 vdda vdda) pmos1 l=180n w=1u m=1
	mpd12 (net13 inp net31 net31) pmos1 l=180n w=1u m=1
	mpb01 (net158 net158 vdda vdda) pmos1 l=180n w=1u m=1
ends OPAMP1_variant249

subckt OPAMP1_variant250 inn inp out pd xpd vdda vssa
	xd1 (vssa vdda) prim_nwd AREA=6.13907e-9 PJ=476.6e-6 m=1
	xi0 (vssa net69) prim_nd AREA=1e-12 PJ=4e-6 m=1
	xi3 (net51 vdda) prim_pd AREA=7.7e-09 PJ=6.7e-05 m=1
	xr0 (vssa vdda net51) prim_rdiffp l=2.1e-6 w=700e-9 m=1
	xr1 (vdda vdda net69) prim_rdiffp l=2.5e-07 w=1.5e-06 m=1
	xcc01 (net12 out) prim_cpoly c=1p m=1
	mnm12 (net13 net56 vssa vssa) nmos1 l=2.1e-07n w=1.4e-06u m=1
	mnm11 (net56 net56 vssa vssa) nmos1 l=1.1e-07n w=1.4e-06u m=1
	mnb02 (net27 net27 net21 vssa) nmos1 l=180n w=1u m=1
	mnpd1 (net21 xpd vssa vssa) nmos1 l=180n w=1u m=1
	mn001 (out net13 vssa vssa) nmos1 l=180n w=1u m=1
	mnpd2 (net13 pd vssa vssa) nmos1 l=180n w=1u m=1
	mnc01 (net13 net69 net12 vssa) nmos1 l=180n w=1u m=1
	mpb02 (net27 net51 net158 vdda) pmos1 l=180n w=1u m=1
	mppd1 (net158 xpd vdda vdda) pmos1 l=180n w=1u m=1
	mps11 (net31 net158 vdda vdda) pmos1 l=180n w=1u m=1
	mpd11 (net56 inn net31 net31) pmos1 l=180n w=1u m=1
	mp001 (out net158 vdda vdda) pmos1 l=180n w=1u m=1
	mpd12 (net13 inp net31 net31) pmos1 l=1.1e-07n w=5.6e-07u m=1
	mpb01 (net158 net158 vdda vdda) pmos1 l=180n w=1u m=1
ends OPAMP1_variant250

subckt OPAMP1_variant251 inn inp out pd xpd vdda vssa
	xd1 (vssa vdda) prim_nwd AREA=6.13907e-9 PJ=476.6e-6 m=1
	xi0 (vssa net69) prim_nd AREA=1e-12 PJ=4e-6 m=1
	xi3 (net51 vdda) prim_pd AREA=8.5e-09 PJ=1.8e-05 m=1
	xr0 (vssa vdda net51) prim_rdiffp l=2.1e-6 w=700e-9 m=1
	xr1 (vdda vdda net69) prim_rdiffp l=2.1e-6 w=700e-9 m=1
	xcc01 (net12 out) prim_cpoly c=1p m=1
	mnm12 (net13 net56 vssa vssa) nmos1 l=180n w=1u m=1
	mnm11 (net56 net56 vssa vssa) nmos1 l=1.4e-07n w=8.0e-07u m=1
	mnb02 (net27 net27 net21 vssa) nmos1 l=180n w=1u m=1
	mnpd1 (net21 xpd vssa vssa) nmos1 l=180n w=1u m=1
	mn001 (out net13 vssa vssa) nmos1 l=180n w=1u m=1
	mnpd2 (net13 pd vssa vssa) nmos1 l=2.9e-07n w=6.8e-07u m=1
	mnc01 (net13 net69 net12 vssa) nmos1 l=180n w=1u m=1
	mpb02 (net27 net51 net158 vdda) pmos1 l=180n w=1u m=1
	mppd1 (net158 xpd vdda vdda) pmos1 l=2.9e-07n w=2.0e-06u m=1
	mps11 (net31 net158 vdda vdda) pmos1 l=180n w=1u m=1
	mpd11 (net56 inn net31 net31) pmos1 l=1.1e-07n w=2.0e-06u m=1
	mp001 (out net158 vdda vdda) pmos1 l=180n w=1u m=1
	mpd12 (net13 inp net31 net31) pmos1 l=180n w=1u m=1
	mpb01 (net158 net158 vdda vdda) pmos1 l=180n w=1u m=1
ends OPAMP1_variant251

subckt OPAMP1_variant252 inn inp out pd xpd vdda vssa
	xd1 (vssa vdda) prim_nwd AREA=6.13907e-9 PJ=476.6e-6 m=1
	xi0 (vssa net69) prim_nd AREA=1e-12 PJ=4e-6 m=1
	xi3 (net51 vdda) prim_pd AREA=790e-15 PJ=3.3e-6 m=1
	xr0 (vssa vdda net51) prim_rdiffp l=2.1e-6 w=700e-9 m=1
	xr1 (vdda vdda net69) prim_rdiffp l=2.7e-07 w=5.7e-07 m=1
	xcc01 (net12 out) prim_cpoly c=1.1e-12p m=1
	mnm12 (net13 net56 vssa vssa) nmos1 l=180n w=1u m=1
	mnm11 (net56 net56 vssa vssa) nmos1 l=180n w=1u m=1
	mnb02 (net27 net27 net21 vssa) nmos1 l=2.0e-07n w=1.0e-06u m=1
	mnpd1 (net21 xpd vssa vssa) nmos1 l=180n w=1u m=1
	mn001 (out net13 vssa vssa) nmos1 l=180n w=1u m=1
	mnpd2 (net13 pd vssa vssa) nmos1 l=1.7e-07n w=1.3e-06u m=1
	mnc01 (net13 net69 net12 vssa) nmos1 l=180n w=1u m=1
	mpb02 (net27 net51 net158 vdda) pmos1 l=180n w=1u m=1
	mppd1 (net158 xpd vdda vdda) pmos1 l=180n w=1u m=1
	mps11 (net31 net158 vdda vdda) pmos1 l=180n w=1u m=1
	mpd11 (net56 inn net31 net31) pmos1 l=1.2e-07n w=1.8e-06u m=1
	mp001 (out net158 vdda vdda) pmos1 l=180n w=1u m=1
	mpd12 (net13 inp net31 net31) pmos1 l=180n w=1u m=1
	mpb01 (net158 net158 vdda vdda) pmos1 l=180n w=1u m=1
ends OPAMP1_variant252

subckt OPAMP1_variant253 inn inp out pd xpd vdda vssa
	xd1 (vssa vdda) prim_nwd AREA=6.13907e-9 PJ=476.6e-6 m=1
	xi0 (vssa net69) prim_nd AREA=1e-12 PJ=4e-6 m=1
	xi3 (net51 vdda) prim_pd AREA=790e-15 PJ=3.3e-6 m=1
	xr0 (vssa vdda net51) prim_rdiffp l=2.1e-6 w=700e-9 m=1
	xr1 (vdda vdda net69) prim_rdiffp l=2.1e-6 w=700e-9 m=1
	xcc01 (net12 out) prim_cpoly c=1p m=1
	mnm12 (net13 net56 vssa vssa) nmos1 l=180n w=1u m=1
	mnm11 (net56 net56 vssa vssa) nmos1 l=180n w=1u m=1
	mnb02 (net27 net27 net21 vssa) nmos1 l=180n w=1u m=1
	mnpd1 (net21 xpd vssa vssa) nmos1 l=180n w=1u m=1
	mn001 (out net13 vssa vssa) nmos1 l=180n w=1u m=1
	mnpd2 (net13 pd vssa vssa) nmos1 l=180n w=1u m=1
	mnc01 (net13 net69 net12 vssa) nmos1 l=1.6e-07n w=1.4e-06u m=1
	mpb02 (net27 net51 net158 vdda) pmos1 l=180n w=1u m=1
	mppd1 (net158 xpd vdda vdda) pmos1 l=1.4e-07n w=1.3e-06u m=1
	mps11 (net31 net158 vdda vdda) pmos1 l=180n w=1u m=1
	mpd11 (net56 inn net31 net31) pmos1 l=180n w=1u m=1
	mp001 (out net158 vdda vdda) pmos1 l=1.6e-07n w=6.0e-07u m=1
	mpd12 (net13 inp net31 net31) pmos1 l=180n w=1u m=1
	mpb01 (net158 net158 vdda vdda) pmos1 l=180n w=1u m=1
ends OPAMP1_variant253

subckt OPAMP1_variant254 inn inp out pd xpd vdda vssa
	xd1 (vssa vdda) prim_nwd AREA=6.13907e-9 PJ=476.6e-6 m=1
	xi0 (vssa net69) prim_nd AREA=9.5e-10 PJ=8.9e-05 m=1
	xi3 (net51 vdda) prim_pd AREA=790e-15 PJ=3.3e-6 m=1
	xr0 (vssa vdda net51) prim_rdiffp l=2.1e-6 w=700e-9 m=1
	xr1 (vdda vdda net69) prim_rdiffp l=2.1e-6 w=700e-9 m=1
	xcc01 (net12 out) prim_cpoly c=1p m=1
	mnm12 (net13 net56 vssa vssa) nmos1 l=180n w=1u m=1
	mnm11 (net56 net56 vssa vssa) nmos1 l=180n w=1u m=1
	mnb02 (net27 net27 net21 vssa) nmos1 l=180n w=1u m=1
	mnpd1 (net21 xpd vssa vssa) nmos1 l=180n w=1u m=1
	mn001 (out net13 vssa vssa) nmos1 l=180n w=1u m=1
	mnpd2 (net13 pd vssa vssa) nmos1 l=180n w=1u m=1
	mnc01 (net13 net69 net12 vssa) nmos1 l=180n w=1u m=1
	mpb02 (net27 net51 net158 vdda) pmos1 l=2.0e-07n w=1.2e-06u m=1
	mppd1 (net158 xpd vdda vdda) pmos1 l=180n w=1u m=1
	mps11 (net31 net158 vdda vdda) pmos1 l=180n w=1u m=1
	mpd11 (net56 inn net31 net31) pmos1 l=180n w=1u m=1
	mp001 (out net158 vdda vdda) pmos1 l=180n w=1u m=1
	mpd12 (net13 inp net31 net31) pmos1 l=180n w=1u m=1
	mpb01 (net158 net158 vdda vdda) pmos1 l=180n w=1u m=1
ends OPAMP1_variant254

subckt OPAMP1_variant255 inn inp out pd xpd vdda vssa
	xd1 (vssa vdda) prim_nwd AREA=6.13907e-9 PJ=476.6e-6 m=1
	xi0 (vssa net69) prim_nd AREA=1e-12 PJ=4e-6 m=1
	xi3 (net51 vdda) prim_pd AREA=8.7e-09 PJ=2.4e-06 m=1
	xr0 (vssa vdda net51) prim_rdiffp l=2.1e-6 w=700e-9 m=1
	xr1 (vdda vdda net69) prim_rdiffp l=2.1e-6 w=700e-9 m=1
	xcc01 (net12 out) prim_cpoly c=1p m=1
	mnm12 (net13 net56 vssa vssa) nmos1 l=180n w=1u m=1
	mnm11 (net56 net56 vssa vssa) nmos1 l=2.9e-07n w=1.8e-06u m=1
	mnb02 (net27 net27 net21 vssa) nmos1 l=180n w=1u m=1
	mnpd1 (net21 xpd vssa vssa) nmos1 l=180n w=1u m=1
	mn001 (out net13 vssa vssa) nmos1 l=180n w=1u m=1
	mnpd2 (net13 pd vssa vssa) nmos1 l=180n w=1u m=1
	mnc01 (net13 net69 net12 vssa) nmos1 l=180n w=1u m=1
	mpb02 (net27 net51 net158 vdda) pmos1 l=2.9e-07n w=1.2e-06u m=1
	mppd1 (net158 xpd vdda vdda) pmos1 l=2.1e-07n w=1.2e-06u m=1
	mps11 (net31 net158 vdda vdda) pmos1 l=2.0e-07n w=1.9e-06u m=1
	mpd11 (net56 inn net31 net31) pmos1 l=180n w=1u m=1
	mp001 (out net158 vdda vdda) pmos1 l=180n w=1u m=1
	mpd12 (net13 inp net31 net31) pmos1 l=180n w=1u m=1
	mpb01 (net158 net158 vdda vdda) pmos1 l=180n w=1u m=1
ends OPAMP1_variant255

subckt OPAMP1_variant256 inn inp out pd xpd vdda vssa
	xd1 (vssa vdda) prim_nwd AREA=6.13907e-9 PJ=476.6e-6 m=1
	xi0 (vssa net69) prim_nd AREA=5.8e-09 PJ=7.2e-05 m=1
	xi3 (net51 vdda) prim_pd AREA=6.2e-09 PJ=9.1e-05 m=1
	xr0 (vssa vdda net51) prim_rdiffp l=1.0e-07 w=1.5e-06 m=1
	xr1 (vdda vdda net69) prim_rdiffp l=2.1e-6 w=700e-9 m=1
	xcc01 (net12 out) prim_cpoly c=1p m=1
	mnm12 (net13 net56 vssa vssa) nmos1 l=180n w=1u m=1
	mnm11 (net56 net56 vssa vssa) nmos1 l=180n w=1u m=1
	mnb02 (net27 net27 net21 vssa) nmos1 l=2.2e-07n w=1.2e-06u m=1
	mnpd1 (net21 xpd vssa vssa) nmos1 l=180n w=1u m=1
	mn001 (out net13 vssa vssa) nmos1 l=180n w=1u m=1
	mnpd2 (net13 pd vssa vssa) nmos1 l=180n w=1u m=1
	mnc01 (net13 net69 net12 vssa) nmos1 l=180n w=1u m=1
	mpb02 (net27 net51 net158 vdda) pmos1 l=180n w=1u m=1
	mppd1 (net158 xpd vdda vdda) pmos1 l=2.9e-07n w=1.6e-06u m=1
	mps11 (net31 net158 vdda vdda) pmos1 l=180n w=1u m=1
	mpd11 (net56 inn net31 net31) pmos1 l=180n w=1u m=1
	mp001 (out net158 vdda vdda) pmos1 l=180n w=1u m=1
	mpd12 (net13 inp net31 net31) pmos1 l=180n w=1u m=1
	mpb01 (net158 net158 vdda vdda) pmos1 l=180n w=1u m=1
ends OPAMP1_variant256

subckt OPAMP1_variant257 inn inp out pd xpd vdda vssa
	xd1 (vssa vdda) prim_nwd AREA=6.13907e-9 PJ=476.6e-6 m=1
	xi0 (vssa net69) prim_nd AREA=1e-12 PJ=4e-6 m=1
	xi3 (net51 vdda) prim_pd AREA=790e-15 PJ=3.3e-6 m=1
	xr0 (vssa vdda net51) prim_rdiffp l=2.1e-6 w=700e-9 m=1
	xr1 (vdda vdda net69) prim_rdiffp l=2.1e-6 w=700e-9 m=1
	xcc01 (net12 out) prim_cpoly c=1p m=1
	mnm12 (net13 net56 vssa vssa) nmos1 l=1.9e-07n w=6.7e-07u m=1
	mnm11 (net56 net56 vssa vssa) nmos1 l=180n w=1u m=1
	mnb02 (net27 net27 net21 vssa) nmos1 l=180n w=1u m=1
	mnpd1 (net21 xpd vssa vssa) nmos1 l=2.0e-07n w=8.8e-07u m=1
	mn001 (out net13 vssa vssa) nmos1 l=180n w=1u m=1
	mnpd2 (net13 pd vssa vssa) nmos1 l=180n w=1u m=1
	mnc01 (net13 net69 net12 vssa) nmos1 l=180n w=1u m=1
	mpb02 (net27 net51 net158 vdda) pmos1 l=2.4e-07n w=1.2e-06u m=1
	mppd1 (net158 xpd vdda vdda) pmos1 l=180n w=1u m=1
	mps11 (net31 net158 vdda vdda) pmos1 l=1.1e-07n w=1.3e-06u m=1
	mpd11 (net56 inn net31 net31) pmos1 l=180n w=1u m=1
	mp001 (out net158 vdda vdda) pmos1 l=180n w=1u m=1
	mpd12 (net13 inp net31 net31) pmos1 l=180n w=1u m=1
	mpb01 (net158 net158 vdda vdda) pmos1 l=180n w=1u m=1
ends OPAMP1_variant257

subckt OPAMP1_variant258 inn inp out pd xpd vdda vssa
	xd1 (vssa vdda) prim_nwd AREA=6.13907e-9 PJ=476.6e-6 m=1
	xi0 (vssa net69) prim_nd AREA=1e-12 PJ=4e-6 m=1
	xi3 (net51 vdda) prim_pd AREA=790e-15 PJ=3.3e-6 m=1
	xr0 (vssa vdda net51) prim_rdiffp l=3.0e-07 w=2.0e-06 m=1
	xr1 (vdda vdda net69) prim_rdiffp l=2.1e-6 w=700e-9 m=1
	xcc01 (net12 out) prim_cpoly c=1p m=1
	mnm12 (net13 net56 vssa vssa) nmos1 l=180n w=1u m=1
	mnm11 (net56 net56 vssa vssa) nmos1 l=180n w=1u m=1
	mnb02 (net27 net27 net21 vssa) nmos1 l=180n w=1u m=1
	mnpd1 (net21 xpd vssa vssa) nmos1 l=1.5e-07n w=1.1e-06u m=1
	mn001 (out net13 vssa vssa) nmos1 l=180n w=1u m=1
	mnpd2 (net13 pd vssa vssa) nmos1 l=180n w=1u m=1
	mnc01 (net13 net69 net12 vssa) nmos1 l=180n w=1u m=1
	mpb02 (net27 net51 net158 vdda) pmos1 l=180n w=1u m=1
	mppd1 (net158 xpd vdda vdda) pmos1 l=180n w=1u m=1
	mps11 (net31 net158 vdda vdda) pmos1 l=180n w=1u m=1
	mpd11 (net56 inn net31 net31) pmos1 l=2.9e-07n w=9.3e-07u m=1
	mp001 (out net158 vdda vdda) pmos1 l=180n w=1u m=1
	mpd12 (net13 inp net31 net31) pmos1 l=180n w=1u m=1
	mpb01 (net158 net158 vdda vdda) pmos1 l=1.5e-07n w=1.9e-06u m=1
ends OPAMP1_variant258

subckt OPAMP1_variant259 inn inp out pd xpd vdda vssa
	xd1 (vssa vdda) prim_nwd AREA=6.13907e-9 PJ=476.6e-6 m=1
	xi0 (vssa net69) prim_nd AREA=1e-12 PJ=4e-6 m=1
	xi3 (net51 vdda) prim_pd AREA=790e-15 PJ=3.3e-6 m=1
	xr0 (vssa vdda net51) prim_rdiffp l=2.1e-6 w=700e-9 m=1
	xr1 (vdda vdda net69) prim_rdiffp l=2.1e-6 w=700e-9 m=1
	xcc01 (net12 out) prim_cpoly c=1p m=1
	mnm12 (net13 net56 vssa vssa) nmos1 l=180n w=1u m=1
	mnm11 (net56 net56 vssa vssa) nmos1 l=180n w=1u m=1
	mnb02 (net27 net27 net21 vssa) nmos1 l=180n w=1u m=1
	mnpd1 (net21 xpd vssa vssa) nmos1 l=2.8e-07n w=1.5e-06u m=1
	mn001 (out net13 vssa vssa) nmos1 l=180n w=1u m=1
	mnpd2 (net13 pd vssa vssa) nmos1 l=1.8e-07n w=9.9e-07u m=1
	mnc01 (net13 net69 net12 vssa) nmos1 l=180n w=1u m=1
	mpb02 (net27 net51 net158 vdda) pmos1 l=180n w=1u m=1
	mppd1 (net158 xpd vdda vdda) pmos1 l=2.3e-07n w=1.1e-06u m=1
	mps11 (net31 net158 vdda vdda) pmos1 l=2.0e-07n w=1.2e-06u m=1
	mpd11 (net56 inn net31 net31) pmos1 l=180n w=1u m=1
	mp001 (out net158 vdda vdda) pmos1 l=2.5e-07n w=1.2e-06u m=1
	mpd12 (net13 inp net31 net31) pmos1 l=180n w=1u m=1
	mpb01 (net158 net158 vdda vdda) pmos1 l=180n w=1u m=1
ends OPAMP1_variant259

subckt OPAMP1_variant260 inn inp out pd xpd vdda vssa
	xd1 (vssa vdda) prim_nwd AREA=6.13907e-9 PJ=476.6e-6 m=1
	xi0 (vssa net69) prim_nd AREA=1e-12 PJ=4e-6 m=1
	xi3 (net51 vdda) prim_pd AREA=9.6e-09 PJ=8.3e-05 m=1
	xr0 (vssa vdda net51) prim_rdiffp l=2.1e-6 w=700e-9 m=1
	xr1 (vdda vdda net69) prim_rdiffp l=2.1e-6 w=700e-9 m=1
	xcc01 (net12 out) prim_cpoly c=1p m=1
	mnm12 (net13 net56 vssa vssa) nmos1 l=180n w=1u m=1
	mnm11 (net56 net56 vssa vssa) nmos1 l=180n w=1u m=1
	mnb02 (net27 net27 net21 vssa) nmos1 l=180n w=1u m=1
	mnpd1 (net21 xpd vssa vssa) nmos1 l=1.3e-07n w=1.7e-06u m=1
	mn001 (out net13 vssa vssa) nmos1 l=180n w=1u m=1
	mnpd2 (net13 pd vssa vssa) nmos1 l=180n w=1u m=1
	mnc01 (net13 net69 net12 vssa) nmos1 l=180n w=1u m=1
	mpb02 (net27 net51 net158 vdda) pmos1 l=180n w=1u m=1
	mppd1 (net158 xpd vdda vdda) pmos1 l=180n w=1u m=1
	mps11 (net31 net158 vdda vdda) pmos1 l=180n w=1u m=1
	mpd11 (net56 inn net31 net31) pmos1 l=180n w=1u m=1
	mp001 (out net158 vdda vdda) pmos1 l=180n w=1u m=1
	mpd12 (net13 inp net31 net31) pmos1 l=180n w=1u m=1
	mpb01 (net158 net158 vdda vdda) pmos1 l=180n w=1u m=1
ends OPAMP1_variant260

subckt OPAMP1_variant261 inn inp out pd xpd vdda vssa
	xd1 (vssa vdda) prim_nwd AREA=7.4e-09 PJ=6.4e-05 m=1
	xi0 (vssa net69) prim_nd AREA=1e-12 PJ=4e-6 m=1
	xi3 (net51 vdda) prim_pd AREA=3.8e-09 PJ=5.2e-06 m=1
	xr0 (vssa vdda net51) prim_rdiffp l=2.1e-6 w=700e-9 m=1
	xr1 (vdda vdda net69) prim_rdiffp l=2.1e-6 w=700e-9 m=1
	xcc01 (net12 out) prim_cpoly c=1p m=1
	mnm12 (net13 net56 vssa vssa) nmos1 l=180n w=1u m=1
	mnm11 (net56 net56 vssa vssa) nmos1 l=180n w=1u m=1
	mnb02 (net27 net27 net21 vssa) nmos1 l=180n w=1u m=1
	mnpd1 (net21 xpd vssa vssa) nmos1 l=180n w=1u m=1
	mn001 (out net13 vssa vssa) nmos1 l=180n w=1u m=1
	mnpd2 (net13 pd vssa vssa) nmos1 l=180n w=1u m=1
	mnc01 (net13 net69 net12 vssa) nmos1 l=180n w=1u m=1
	mpb02 (net27 net51 net158 vdda) pmos1 l=1.1e-07n w=9.5e-07u m=1
	mppd1 (net158 xpd vdda vdda) pmos1 l=180n w=1u m=1
	mps11 (net31 net158 vdda vdda) pmos1 l=180n w=1u m=1
	mpd11 (net56 inn net31 net31) pmos1 l=180n w=1u m=1
	mp001 (out net158 vdda vdda) pmos1 l=2.3e-07n w=1.0e-06u m=1
	mpd12 (net13 inp net31 net31) pmos1 l=180n w=1u m=1
	mpb01 (net158 net158 vdda vdda) pmos1 l=180n w=1u m=1
ends OPAMP1_variant261

subckt OPAMP1_variant262 inn inp out pd xpd vdda vssa
	xd1 (vssa vdda) prim_nwd AREA=6.13907e-9 PJ=476.6e-6 m=1
	xi0 (vssa net69) prim_nd AREA=1e-12 PJ=4e-6 m=1
	xi3 (net51 vdda) prim_pd AREA=790e-15 PJ=3.3e-6 m=1
	xr0 (vssa vdda net51) prim_rdiffp l=2.1e-6 w=700e-9 m=1
	xr1 (vdda vdda net69) prim_rdiffp l=2.1e-6 w=700e-9 m=1
	xcc01 (net12 out) prim_cpoly c=1p m=1
	mnm12 (net13 net56 vssa vssa) nmos1 l=180n w=1u m=1
	mnm11 (net56 net56 vssa vssa) nmos1 l=2.0e-07n w=6.0e-07u m=1
	mnb02 (net27 net27 net21 vssa) nmos1 l=180n w=1u m=1
	mnpd1 (net21 xpd vssa vssa) nmos1 l=180n w=1u m=1
	mn001 (out net13 vssa vssa) nmos1 l=180n w=1u m=1
	mnpd2 (net13 pd vssa vssa) nmos1 l=180n w=1u m=1
	mnc01 (net13 net69 net12 vssa) nmos1 l=3.0e-07n w=1.1e-06u m=1
	mpb02 (net27 net51 net158 vdda) pmos1 l=180n w=1u m=1
	mppd1 (net158 xpd vdda vdda) pmos1 l=1.8e-07n w=1.4e-06u m=1
	mps11 (net31 net158 vdda vdda) pmos1 l=180n w=1u m=1
	mpd11 (net56 inn net31 net31) pmos1 l=1.6e-07n w=1.2e-06u m=1
	mp001 (out net158 vdda vdda) pmos1 l=180n w=1u m=1
	mpd12 (net13 inp net31 net31) pmos1 l=2.3e-07n w=1.8e-06u m=1
	mpb01 (net158 net158 vdda vdda) pmos1 l=180n w=1u m=1
ends OPAMP1_variant262

subckt OPAMP1_variant263 inn inp out pd xpd vdda vssa
	xd1 (vssa vdda) prim_nwd AREA=6.13907e-9 PJ=476.6e-6 m=1
	xi0 (vssa net69) prim_nd AREA=7.4e-09 PJ=5.0e-05 m=1
	xi3 (net51 vdda) prim_pd AREA=790e-15 PJ=3.3e-6 m=1
	xr0 (vssa vdda net51) prim_rdiffp l=1.2e-07 w=6.7e-07 m=1
	xr1 (vdda vdda net69) prim_rdiffp l=1.1e-07 w=1.9e-06 m=1
	xcc01 (net12 out) prim_cpoly c=1p m=1
	mnm12 (net13 net56 vssa vssa) nmos1 l=180n w=1u m=1
	mnm11 (net56 net56 vssa vssa) nmos1 l=180n w=1u m=1
	mnb02 (net27 net27 net21 vssa) nmos1 l=180n w=1u m=1
	mnpd1 (net21 xpd vssa vssa) nmos1 l=180n w=1u m=1
	mn001 (out net13 vssa vssa) nmos1 l=1.2e-07n w=1.5e-06u m=1
	mnpd2 (net13 pd vssa vssa) nmos1 l=180n w=1u m=1
	mnc01 (net13 net69 net12 vssa) nmos1 l=180n w=1u m=1
	mpb02 (net27 net51 net158 vdda) pmos1 l=180n w=1u m=1
	mppd1 (net158 xpd vdda vdda) pmos1 l=180n w=1u m=1
	mps11 (net31 net158 vdda vdda) pmos1 l=180n w=1u m=1
	mpd11 (net56 inn net31 net31) pmos1 l=180n w=1u m=1
	mp001 (out net158 vdda vdda) pmos1 l=180n w=1u m=1
	mpd12 (net13 inp net31 net31) pmos1 l=180n w=1u m=1
	mpb01 (net158 net158 vdda vdda) pmos1 l=180n w=1u m=1
ends OPAMP1_variant263

subckt OPAMP1_variant264 inn inp out pd xpd vdda vssa
	xd1 (vssa vdda) prim_nwd AREA=6.13907e-9 PJ=476.6e-6 m=1
	xi0 (vssa net69) prim_nd AREA=1e-12 PJ=4e-6 m=1
	xi3 (net51 vdda) prim_pd AREA=790e-15 PJ=3.3e-6 m=1
	xr0 (vssa vdda net51) prim_rdiffp l=2.1e-6 w=700e-9 m=1
	xr1 (vdda vdda net69) prim_rdiffp l=2.1e-6 w=700e-9 m=1
	xcc01 (net12 out) prim_cpoly c=1p m=1
	mnm12 (net13 net56 vssa vssa) nmos1 l=180n w=1u m=1
	mnm11 (net56 net56 vssa vssa) nmos1 l=180n w=1u m=1
	mnb02 (net27 net27 net21 vssa) nmos1 l=180n w=1u m=1
	mnpd1 (net21 xpd vssa vssa) nmos1 l=180n w=1u m=1
	mn001 (out net13 vssa vssa) nmos1 l=1.7e-07n w=8.0e-07u m=1
	mnpd2 (net13 pd vssa vssa) nmos1 l=180n w=1u m=1
	mnc01 (net13 net69 net12 vssa) nmos1 l=180n w=1u m=1
	mpb02 (net27 net51 net158 vdda) pmos1 l=180n w=1u m=1
	mppd1 (net158 xpd vdda vdda) pmos1 l=1.4e-07n w=8.5e-07u m=1
	mps11 (net31 net158 vdda vdda) pmos1 l=180n w=1u m=1
	mpd11 (net56 inn net31 net31) pmos1 l=180n w=1u m=1
	mp001 (out net158 vdda vdda) pmos1 l=1.8e-07n w=1.1e-06u m=1
	mpd12 (net13 inp net31 net31) pmos1 l=180n w=1u m=1
	mpb01 (net158 net158 vdda vdda) pmos1 l=180n w=1u m=1
ends OPAMP1_variant264

subckt OPAMP1_variant265 inn inp out pd xpd vdda vssa
	xd1 (vssa vdda) prim_nwd AREA=5.4e-09 PJ=3.0e-05 m=1
	xi0 (vssa net69) prim_nd AREA=1e-12 PJ=4e-6 m=1
	xi3 (net51 vdda) prim_pd AREA=790e-15 PJ=3.3e-6 m=1
	xr0 (vssa vdda net51) prim_rdiffp l=2.1e-6 w=700e-9 m=1
	xr1 (vdda vdda net69) prim_rdiffp l=2.1e-6 w=700e-9 m=1
	xcc01 (net12 out) prim_cpoly c=1p m=1
	mnm12 (net13 net56 vssa vssa) nmos1 l=2.4e-07n w=1.7e-06u m=1
	mnm11 (net56 net56 vssa vssa) nmos1 l=180n w=1u m=1
	mnb02 (net27 net27 net21 vssa) nmos1 l=180n w=1u m=1
	mnpd1 (net21 xpd vssa vssa) nmos1 l=180n w=1u m=1
	mn001 (out net13 vssa vssa) nmos1 l=180n w=1u m=1
	mnpd2 (net13 pd vssa vssa) nmos1 l=180n w=1u m=1
	mnc01 (net13 net69 net12 vssa) nmos1 l=180n w=1u m=1
	mpb02 (net27 net51 net158 vdda) pmos1 l=2.8e-07n w=1.5e-06u m=1
	mppd1 (net158 xpd vdda vdda) pmos1 l=180n w=1u m=1
	mps11 (net31 net158 vdda vdda) pmos1 l=180n w=1u m=1
	mpd11 (net56 inn net31 net31) pmos1 l=180n w=1u m=1
	mp001 (out net158 vdda vdda) pmos1 l=180n w=1u m=1
	mpd12 (net13 inp net31 net31) pmos1 l=180n w=1u m=1
	mpb01 (net158 net158 vdda vdda) pmos1 l=180n w=1u m=1
ends OPAMP1_variant265

subckt OPAMP1_variant266 inn inp out pd xpd vdda vssa
	xd1 (vssa vdda) prim_nwd AREA=6.13907e-9 PJ=476.6e-6 m=1
	xi0 (vssa net69) prim_nd AREA=1e-12 PJ=4e-6 m=1
	xi3 (net51 vdda) prim_pd AREA=9.9e-09 PJ=4.3e-05 m=1
	xr0 (vssa vdda net51) prim_rdiffp l=3.0e-07 w=8.8e-07 m=1
	xr1 (vdda vdda net69) prim_rdiffp l=2.1e-6 w=700e-9 m=1
	xcc01 (net12 out) prim_cpoly c=2.0e-12p m=1
	mnm12 (net13 net56 vssa vssa) nmos1 l=180n w=1u m=1
	mnm11 (net56 net56 vssa vssa) nmos1 l=180n w=1u m=1
	mnb02 (net27 net27 net21 vssa) nmos1 l=180n w=1u m=1
	mnpd1 (net21 xpd vssa vssa) nmos1 l=180n w=1u m=1
	mn001 (out net13 vssa vssa) nmos1 l=180n w=1u m=1
	mnpd2 (net13 pd vssa vssa) nmos1 l=180n w=1u m=1
	mnc01 (net13 net69 net12 vssa) nmos1 l=180n w=1u m=1
	mpb02 (net27 net51 net158 vdda) pmos1 l=180n w=1u m=1
	mppd1 (net158 xpd vdda vdda) pmos1 l=3.0e-07n w=1.5e-06u m=1
	mps11 (net31 net158 vdda vdda) pmos1 l=180n w=1u m=1
	mpd11 (net56 inn net31 net31) pmos1 l=2.0e-07n w=6.3e-07u m=1
	mp001 (out net158 vdda vdda) pmos1 l=180n w=1u m=1
	mpd12 (net13 inp net31 net31) pmos1 l=180n w=1u m=1
	mpb01 (net158 net158 vdda vdda) pmos1 l=180n w=1u m=1
ends OPAMP1_variant266

subckt OPAMP1_variant267 inn inp out pd xpd vdda vssa
	xd1 (vssa vdda) prim_nwd AREA=6.13907e-9 PJ=476.6e-6 m=1
	xi0 (vssa net69) prim_nd AREA=1e-12 PJ=4e-6 m=1
	xi3 (net51 vdda) prim_pd AREA=790e-15 PJ=3.3e-6 m=1
	xr0 (vssa vdda net51) prim_rdiffp l=2.1e-6 w=700e-9 m=1
	xr1 (vdda vdda net69) prim_rdiffp l=2.1e-6 w=700e-9 m=1
	xcc01 (net12 out) prim_cpoly c=1p m=1
	mnm12 (net13 net56 vssa vssa) nmos1 l=3.0e-07n w=9.6e-07u m=1
	mnm11 (net56 net56 vssa vssa) nmos1 l=180n w=1u m=1
	mnb02 (net27 net27 net21 vssa) nmos1 l=180n w=1u m=1
	mnpd1 (net21 xpd vssa vssa) nmos1 l=180n w=1u m=1
	mn001 (out net13 vssa vssa) nmos1 l=2.8e-07n w=1.5e-06u m=1
	mnpd2 (net13 pd vssa vssa) nmos1 l=180n w=1u m=1
	mnc01 (net13 net69 net12 vssa) nmos1 l=180n w=1u m=1
	mpb02 (net27 net51 net158 vdda) pmos1 l=180n w=1u m=1
	mppd1 (net158 xpd vdda vdda) pmos1 l=180n w=1u m=1
	mps11 (net31 net158 vdda vdda) pmos1 l=180n w=1u m=1
	mpd11 (net56 inn net31 net31) pmos1 l=180n w=1u m=1
	mp001 (out net158 vdda vdda) pmos1 l=180n w=1u m=1
	mpd12 (net13 inp net31 net31) pmos1 l=180n w=1u m=1
	mpb01 (net158 net158 vdda vdda) pmos1 l=180n w=1u m=1
ends OPAMP1_variant267

subckt OPAMP1_variant268 inn inp out pd xpd vdda vssa
	xd1 (vssa vdda) prim_nwd AREA=6.13907e-9 PJ=476.6e-6 m=1
	xi0 (vssa net69) prim_nd AREA=1e-12 PJ=4e-6 m=1
	xi3 (net51 vdda) prim_pd AREA=790e-15 PJ=3.3e-6 m=1
	xr0 (vssa vdda net51) prim_rdiffp l=1.1e-07 w=1.0e-06 m=1
	xr1 (vdda vdda net69) prim_rdiffp l=2.1e-6 w=700e-9 m=1
	xcc01 (net12 out) prim_cpoly c=1p m=1
	mnm12 (net13 net56 vssa vssa) nmos1 l=180n w=1u m=1
	mnm11 (net56 net56 vssa vssa) nmos1 l=180n w=1u m=1
	mnb02 (net27 net27 net21 vssa) nmos1 l=1.9e-07n w=1.3e-06u m=1
	mnpd1 (net21 xpd vssa vssa) nmos1 l=180n w=1u m=1
	mn001 (out net13 vssa vssa) nmos1 l=180n w=1u m=1
	mnpd2 (net13 pd vssa vssa) nmos1 l=180n w=1u m=1
	mnc01 (net13 net69 net12 vssa) nmos1 l=180n w=1u m=1
	mpb02 (net27 net51 net158 vdda) pmos1 l=180n w=1u m=1
	mppd1 (net158 xpd vdda vdda) pmos1 l=1.2e-07n w=1.7e-06u m=1
	mps11 (net31 net158 vdda vdda) pmos1 l=180n w=1u m=1
	mpd11 (net56 inn net31 net31) pmos1 l=180n w=1u m=1
	mp001 (out net158 vdda vdda) pmos1 l=180n w=1u m=1
	mpd12 (net13 inp net31 net31) pmos1 l=180n w=1u m=1
	mpb01 (net158 net158 vdda vdda) pmos1 l=2.2e-07n w=1.6e-06u m=1
ends OPAMP1_variant268

subckt OPAMP1_variant269 inn inp out pd xpd vdda vssa
	xd1 (vssa vdda) prim_nwd AREA=6.13907e-9 PJ=476.6e-6 m=1
	xi0 (vssa net69) prim_nd AREA=1e-12 PJ=4e-6 m=1
	xi3 (net51 vdda) prim_pd AREA=790e-15 PJ=3.3e-6 m=1
	xr0 (vssa vdda net51) prim_rdiffp l=2.1e-6 w=700e-9 m=1
	xr1 (vdda vdda net69) prim_rdiffp l=2.1e-6 w=700e-9 m=1
	xcc01 (net12 out) prim_cpoly c=1p m=1
	mnm12 (net13 net56 vssa vssa) nmos1 l=180n w=1u m=1
	mnm11 (net56 net56 vssa vssa) nmos1 l=180n w=1u m=1
	mnb02 (net27 net27 net21 vssa) nmos1 l=1.4e-07n w=1.8e-06u m=1
	mnpd1 (net21 xpd vssa vssa) nmos1 l=180n w=1u m=1
	mn001 (out net13 vssa vssa) nmos1 l=180n w=1u m=1
	mnpd2 (net13 pd vssa vssa) nmos1 l=1.4e-07n w=1.1e-06u m=1
	mnc01 (net13 net69 net12 vssa) nmos1 l=2.3e-07n w=1.5e-06u m=1
	mpb02 (net27 net51 net158 vdda) pmos1 l=180n w=1u m=1
	mppd1 (net158 xpd vdda vdda) pmos1 l=180n w=1u m=1
	mps11 (net31 net158 vdda vdda) pmos1 l=180n w=1u m=1
	mpd11 (net56 inn net31 net31) pmos1 l=180n w=1u m=1
	mp001 (out net158 vdda vdda) pmos1 l=2.0e-07n w=2.0e-06u m=1
	mpd12 (net13 inp net31 net31) pmos1 l=180n w=1u m=1
	mpb01 (net158 net158 vdda vdda) pmos1 l=2.9e-07n w=1.3e-06u m=1
ends OPAMP1_variant269

subckt OPAMP1_variant270 inn inp out pd xpd vdda vssa
	xd1 (vssa vdda) prim_nwd AREA=6.13907e-9 PJ=476.6e-6 m=1
	xi0 (vssa net69) prim_nd AREA=1e-12 PJ=4e-6 m=1
	xi3 (net51 vdda) prim_pd AREA=790e-15 PJ=3.3e-6 m=1
	xr0 (vssa vdda net51) prim_rdiffp l=2.1e-6 w=700e-9 m=1
	xr1 (vdda vdda net69) prim_rdiffp l=1.9e-07 w=6.6e-07 m=1
	xcc01 (net12 out) prim_cpoly c=1p m=1
	mnm12 (net13 net56 vssa vssa) nmos1 l=180n w=1u m=1
	mnm11 (net56 net56 vssa vssa) nmos1 l=1.7e-07n w=1.3e-06u m=1
	mnb02 (net27 net27 net21 vssa) nmos1 l=180n w=1u m=1
	mnpd1 (net21 xpd vssa vssa) nmos1 l=180n w=1u m=1
	mn001 (out net13 vssa vssa) nmos1 l=180n w=1u m=1
	mnpd2 (net13 pd vssa vssa) nmos1 l=180n w=1u m=1
	mnc01 (net13 net69 net12 vssa) nmos1 l=180n w=1u m=1
	mpb02 (net27 net51 net158 vdda) pmos1 l=180n w=1u m=1
	mppd1 (net158 xpd vdda vdda) pmos1 l=1.8e-07n w=7.8e-07u m=1
	mps11 (net31 net158 vdda vdda) pmos1 l=2.5e-07n w=1.8e-06u m=1
	mpd11 (net56 inn net31 net31) pmos1 l=180n w=1u m=1
	mp001 (out net158 vdda vdda) pmos1 l=180n w=1u m=1
	mpd12 (net13 inp net31 net31) pmos1 l=180n w=1u m=1
	mpb01 (net158 net158 vdda vdda) pmos1 l=180n w=1u m=1
ends OPAMP1_variant270

subckt OPAMP1_variant271 inn inp out pd xpd vdda vssa
	xd1 (vssa vdda) prim_nwd AREA=6.13907e-9 PJ=476.6e-6 m=1
	xi0 (vssa net69) prim_nd AREA=1e-12 PJ=4e-6 m=1
	xi3 (net51 vdda) prim_pd AREA=5.4e-10 PJ=6.5e-05 m=1
	xr0 (vssa vdda net51) prim_rdiffp l=2.1e-6 w=700e-9 m=1
	xr1 (vdda vdda net69) prim_rdiffp l=2.1e-6 w=700e-9 m=1
	xcc01 (net12 out) prim_cpoly c=1p m=1
	mnm12 (net13 net56 vssa vssa) nmos1 l=180n w=1u m=1
	mnm11 (net56 net56 vssa vssa) nmos1 l=180n w=1u m=1
	mnb02 (net27 net27 net21 vssa) nmos1 l=180n w=1u m=1
	mnpd1 (net21 xpd vssa vssa) nmos1 l=180n w=1u m=1
	mn001 (out net13 vssa vssa) nmos1 l=180n w=1u m=1
	mnpd2 (net13 pd vssa vssa) nmos1 l=180n w=1u m=1
	mnc01 (net13 net69 net12 vssa) nmos1 l=180n w=1u m=1
	mpb02 (net27 net51 net158 vdda) pmos1 l=180n w=1u m=1
	mppd1 (net158 xpd vdda vdda) pmos1 l=180n w=1u m=1
	mps11 (net31 net158 vdda vdda) pmos1 l=180n w=1u m=1
	mpd11 (net56 inn net31 net31) pmos1 l=2.5e-07n w=1.3e-06u m=1
	mp001 (out net158 vdda vdda) pmos1 l=2.4e-07n w=8.3e-07u m=1
	mpd12 (net13 inp net31 net31) pmos1 l=180n w=1u m=1
	mpb01 (net158 net158 vdda vdda) pmos1 l=180n w=1u m=1
ends OPAMP1_variant271

subckt OPAMP1_variant272 inn inp out pd xpd vdda vssa
	xd1 (vssa vdda) prim_nwd AREA=6.13907e-9 PJ=476.6e-6 m=1
	xi0 (vssa net69) prim_nd AREA=1e-12 PJ=4e-6 m=1
	xi3 (net51 vdda) prim_pd AREA=790e-15 PJ=3.3e-6 m=1
	xr0 (vssa vdda net51) prim_rdiffp l=2.1e-6 w=700e-9 m=1
	xr1 (vdda vdda net69) prim_rdiffp l=2.1e-6 w=700e-9 m=1
	xcc01 (net12 out) prim_cpoly c=1p m=1
	mnm12 (net13 net56 vssa vssa) nmos1 l=180n w=1u m=1
	mnm11 (net56 net56 vssa vssa) nmos1 l=2.3e-07n w=9.8e-07u m=1
	mnb02 (net27 net27 net21 vssa) nmos1 l=180n w=1u m=1
	mnpd1 (net21 xpd vssa vssa) nmos1 l=180n w=1u m=1
	mn001 (out net13 vssa vssa) nmos1 l=180n w=1u m=1
	mnpd2 (net13 pd vssa vssa) nmos1 l=180n w=1u m=1
	mnc01 (net13 net69 net12 vssa) nmos1 l=180n w=1u m=1
	mpb02 (net27 net51 net158 vdda) pmos1 l=1.6e-07n w=6.8e-07u m=1
	mppd1 (net158 xpd vdda vdda) pmos1 l=180n w=1u m=1
	mps11 (net31 net158 vdda vdda) pmos1 l=180n w=1u m=1
	mpd11 (net56 inn net31 net31) pmos1 l=180n w=1u m=1
	mp001 (out net158 vdda vdda) pmos1 l=180n w=1u m=1
	mpd12 (net13 inp net31 net31) pmos1 l=180n w=1u m=1
	mpb01 (net158 net158 vdda vdda) pmos1 l=180n w=1u m=1
ends OPAMP1_variant272

subckt OPAMP1_variant273 inn inp out pd xpd vdda vssa
	xd1 (vssa vdda) prim_nwd AREA=6.13907e-9 PJ=476.6e-6 m=1
	xi0 (vssa net69) prim_nd AREA=1e-12 PJ=4e-6 m=1
	xi3 (net51 vdda) prim_pd AREA=790e-15 PJ=3.3e-6 m=1
	xr0 (vssa vdda net51) prim_rdiffp l=2.1e-6 w=700e-9 m=1
	xr1 (vdda vdda net69) prim_rdiffp l=2.1e-6 w=700e-9 m=1
	xcc01 (net12 out) prim_cpoly c=1p m=1
	mnm12 (net13 net56 vssa vssa) nmos1 l=2.1e-07n w=7.1e-07u m=1
	mnm11 (net56 net56 vssa vssa) nmos1 l=180n w=1u m=1
	mnb02 (net27 net27 net21 vssa) nmos1 l=180n w=1u m=1
	mnpd1 (net21 xpd vssa vssa) nmos1 l=180n w=1u m=1
	mn001 (out net13 vssa vssa) nmos1 l=1.3e-07n w=5.1e-07u m=1
	mnpd2 (net13 pd vssa vssa) nmos1 l=1.1e-07n w=1.2e-06u m=1
	mnc01 (net13 net69 net12 vssa) nmos1 l=180n w=1u m=1
	mpb02 (net27 net51 net158 vdda) pmos1 l=180n w=1u m=1
	mppd1 (net158 xpd vdda vdda) pmos1 l=180n w=1u m=1
	mps11 (net31 net158 vdda vdda) pmos1 l=1.0e-07n w=1.2e-06u m=1
	mpd11 (net56 inn net31 net31) pmos1 l=180n w=1u m=1
	mp001 (out net158 vdda vdda) pmos1 l=180n w=1u m=1
	mpd12 (net13 inp net31 net31) pmos1 l=180n w=1u m=1
	mpb01 (net158 net158 vdda vdda) pmos1 l=180n w=1u m=1
ends OPAMP1_variant273

subckt OPAMP1_variant274 inn inp out pd xpd vdda vssa
	xd1 (vssa vdda) prim_nwd AREA=6.13907e-9 PJ=476.6e-6 m=1
	xi0 (vssa net69) prim_nd AREA=8.4e-09 PJ=6.5e-05 m=1
	xi3 (net51 vdda) prim_pd AREA=9.0e-09 PJ=9.1e-05 m=1
	xr0 (vssa vdda net51) prim_rdiffp l=2.1e-6 w=700e-9 m=1
	xr1 (vdda vdda net69) prim_rdiffp l=2.9e-07 w=1.8e-06 m=1
	xcc01 (net12 out) prim_cpoly c=1p m=1
	mnm12 (net13 net56 vssa vssa) nmos1 l=180n w=1u m=1
	mnm11 (net56 net56 vssa vssa) nmos1 l=1.1e-07n w=1.6e-06u m=1
	mnb02 (net27 net27 net21 vssa) nmos1 l=180n w=1u m=1
	mnpd1 (net21 xpd vssa vssa) nmos1 l=180n w=1u m=1
	mn001 (out net13 vssa vssa) nmos1 l=180n w=1u m=1
	mnpd2 (net13 pd vssa vssa) nmos1 l=180n w=1u m=1
	mnc01 (net13 net69 net12 vssa) nmos1 l=180n w=1u m=1
	mpb02 (net27 net51 net158 vdda) pmos1 l=180n w=1u m=1
	mppd1 (net158 xpd vdda vdda) pmos1 l=180n w=1u m=1
	mps11 (net31 net158 vdda vdda) pmos1 l=180n w=1u m=1
	mpd11 (net56 inn net31 net31) pmos1 l=180n w=1u m=1
	mp001 (out net158 vdda vdda) pmos1 l=180n w=1u m=1
	mpd12 (net13 inp net31 net31) pmos1 l=1.8e-07n w=1.3e-06u m=1
	mpb01 (net158 net158 vdda vdda) pmos1 l=180n w=1u m=1
ends OPAMP1_variant274

subckt OPAMP1_variant275 inn inp out pd xpd vdda vssa
	xd1 (vssa vdda) prim_nwd AREA=6.13907e-9 PJ=476.6e-6 m=1
	xi0 (vssa net69) prim_nd AREA=1e-12 PJ=4e-6 m=1
	xi3 (net51 vdda) prim_pd AREA=8.7e-09 PJ=1.2e-05 m=1
	xr0 (vssa vdda net51) prim_rdiffp l=1.1e-07 w=1.4e-06 m=1
	xr1 (vdda vdda net69) prim_rdiffp l=2.1e-6 w=700e-9 m=1
	xcc01 (net12 out) prim_cpoly c=1p m=1
	mnm12 (net13 net56 vssa vssa) nmos1 l=180n w=1u m=1
	mnm11 (net56 net56 vssa vssa) nmos1 l=180n w=1u m=1
	mnb02 (net27 net27 net21 vssa) nmos1 l=180n w=1u m=1
	mnpd1 (net21 xpd vssa vssa) nmos1 l=180n w=1u m=1
	mn001 (out net13 vssa vssa) nmos1 l=180n w=1u m=1
	mnpd2 (net13 pd vssa vssa) nmos1 l=180n w=1u m=1
	mnc01 (net13 net69 net12 vssa) nmos1 l=180n w=1u m=1
	mpb02 (net27 net51 net158 vdda) pmos1 l=180n w=1u m=1
	mppd1 (net158 xpd vdda vdda) pmos1 l=180n w=1u m=1
	mps11 (net31 net158 vdda vdda) pmos1 l=180n w=1u m=1
	mpd11 (net56 inn net31 net31) pmos1 l=180n w=1u m=1
	mp001 (out net158 vdda vdda) pmos1 l=180n w=1u m=1
	mpd12 (net13 inp net31 net31) pmos1 l=1.1e-07n w=7.1e-07u m=1
	mpb01 (net158 net158 vdda vdda) pmos1 l=180n w=1u m=1
ends OPAMP1_variant275

subckt OPAMP1_variant276 inn inp out pd xpd vdda vssa
	xd1 (vssa vdda) prim_nwd AREA=6.13907e-9 PJ=476.6e-6 m=1
	xi0 (vssa net69) prim_nd AREA=1e-12 PJ=4e-6 m=1
	xi3 (net51 vdda) prim_pd AREA=790e-15 PJ=3.3e-6 m=1
	xr0 (vssa vdda net51) prim_rdiffp l=2.1e-6 w=700e-9 m=1
	xr1 (vdda vdda net69) prim_rdiffp l=2.1e-6 w=700e-9 m=1
	xcc01 (net12 out) prim_cpoly c=8.0e-13p m=1
	mnm12 (net13 net56 vssa vssa) nmos1 l=180n w=1u m=1
	mnm11 (net56 net56 vssa vssa) nmos1 l=180n w=1u m=1
	mnb02 (net27 net27 net21 vssa) nmos1 l=180n w=1u m=1
	mnpd1 (net21 xpd vssa vssa) nmos1 l=180n w=1u m=1
	mn001 (out net13 vssa vssa) nmos1 l=180n w=1u m=1
	mnpd2 (net13 pd vssa vssa) nmos1 l=180n w=1u m=1
	mnc01 (net13 net69 net12 vssa) nmos1 l=180n w=1u m=1
	mpb02 (net27 net51 net158 vdda) pmos1 l=180n w=1u m=1
	mppd1 (net158 xpd vdda vdda) pmos1 l=180n w=1u m=1
	mps11 (net31 net158 vdda vdda) pmos1 l=180n w=1u m=1
	mpd11 (net56 inn net31 net31) pmos1 l=180n w=1u m=1
	mp001 (out net158 vdda vdda) pmos1 l=180n w=1u m=1
	mpd12 (net13 inp net31 net31) pmos1 l=1.4e-07n w=2.0e-06u m=1
	mpb01 (net158 net158 vdda vdda) pmos1 l=2.7e-07n w=9.9e-07u m=1
ends OPAMP1_variant276

subckt OPAMP1_variant277 inn inp out pd xpd vdda vssa
	xd1 (vssa vdda) prim_nwd AREA=6.13907e-9 PJ=476.6e-6 m=1
	xi0 (vssa net69) prim_nd AREA=1e-12 PJ=4e-6 m=1
	xi3 (net51 vdda) prim_pd AREA=790e-15 PJ=3.3e-6 m=1
	xr0 (vssa vdda net51) prim_rdiffp l=2.1e-6 w=700e-9 m=1
	xr1 (vdda vdda net69) prim_rdiffp l=2.1e-6 w=700e-9 m=1
	xcc01 (net12 out) prim_cpoly c=1p m=1
	mnm12 (net13 net56 vssa vssa) nmos1 l=180n w=1u m=1
	mnm11 (net56 net56 vssa vssa) nmos1 l=180n w=1u m=1
	mnb02 (net27 net27 net21 vssa) nmos1 l=1.5e-07n w=1.2e-06u m=1
	mnpd1 (net21 xpd vssa vssa) nmos1 l=180n w=1u m=1
	mn001 (out net13 vssa vssa) nmos1 l=180n w=1u m=1
	mnpd2 (net13 pd vssa vssa) nmos1 l=180n w=1u m=1
	mnc01 (net13 net69 net12 vssa) nmos1 l=180n w=1u m=1
	mpb02 (net27 net51 net158 vdda) pmos1 l=2.4e-07n w=1.0e-06u m=1
	mppd1 (net158 xpd vdda vdda) pmos1 l=180n w=1u m=1
	mps11 (net31 net158 vdda vdda) pmos1 l=180n w=1u m=1
	mpd11 (net56 inn net31 net31) pmos1 l=180n w=1u m=1
	mp001 (out net158 vdda vdda) pmos1 l=180n w=1u m=1
	mpd12 (net13 inp net31 net31) pmos1 l=1.9e-07n w=9.6e-07u m=1
	mpb01 (net158 net158 vdda vdda) pmos1 l=1.9e-07n w=1.3e-06u m=1
ends OPAMP1_variant277

subckt OPAMP1_variant278 inn inp out pd xpd vdda vssa
	xd1 (vssa vdda) prim_nwd AREA=6.13907e-9 PJ=476.6e-6 m=1
	xi0 (vssa net69) prim_nd AREA=1e-12 PJ=4e-6 m=1
	xi3 (net51 vdda) prim_pd AREA=790e-15 PJ=3.3e-6 m=1
	xr0 (vssa vdda net51) prim_rdiffp l=2.1e-6 w=700e-9 m=1
	xr1 (vdda vdda net69) prim_rdiffp l=2.1e-6 w=700e-9 m=1
	xcc01 (net12 out) prim_cpoly c=1p m=1
	mnm12 (net13 net56 vssa vssa) nmos1 l=180n w=1u m=1
	mnm11 (net56 net56 vssa vssa) nmos1 l=1.0e-07n w=1.9e-06u m=1
	mnb02 (net27 net27 net21 vssa) nmos1 l=180n w=1u m=1
	mnpd1 (net21 xpd vssa vssa) nmos1 l=2.7e-07n w=1.6e-06u m=1
	mn001 (out net13 vssa vssa) nmos1 l=1.9e-07n w=1.1e-06u m=1
	mnpd2 (net13 pd vssa vssa) nmos1 l=180n w=1u m=1
	mnc01 (net13 net69 net12 vssa) nmos1 l=180n w=1u m=1
	mpb02 (net27 net51 net158 vdda) pmos1 l=180n w=1u m=1
	mppd1 (net158 xpd vdda vdda) pmos1 l=180n w=1u m=1
	mps11 (net31 net158 vdda vdda) pmos1 l=180n w=1u m=1
	mpd11 (net56 inn net31 net31) pmos1 l=180n w=1u m=1
	mp001 (out net158 vdda vdda) pmos1 l=2.3e-07n w=1.0e-06u m=1
	mpd12 (net13 inp net31 net31) pmos1 l=180n w=1u m=1
	mpb01 (net158 net158 vdda vdda) pmos1 l=180n w=1u m=1
ends OPAMP1_variant278

subckt OPAMP1_variant279 inn inp out pd xpd vdda vssa
	xd1 (vssa vdda) prim_nwd AREA=6.13907e-9 PJ=476.6e-6 m=1
	xi0 (vssa net69) prim_nd AREA=1e-12 PJ=4e-6 m=1
	xi3 (net51 vdda) prim_pd AREA=7.3e-10 PJ=7.7e-06 m=1
	xr0 (vssa vdda net51) prim_rdiffp l=2.1e-6 w=700e-9 m=1
	xr1 (vdda vdda net69) prim_rdiffp l=2.1e-6 w=700e-9 m=1
	xcc01 (net12 out) prim_cpoly c=1p m=1
	mnm12 (net13 net56 vssa vssa) nmos1 l=180n w=1u m=1
	mnm11 (net56 net56 vssa vssa) nmos1 l=180n w=1u m=1
	mnb02 (net27 net27 net21 vssa) nmos1 l=2.1e-07n w=7.2e-07u m=1
	mnpd1 (net21 xpd vssa vssa) nmos1 l=180n w=1u m=1
	mn001 (out net13 vssa vssa) nmos1 l=180n w=1u m=1
	mnpd2 (net13 pd vssa vssa) nmos1 l=180n w=1u m=1
	mnc01 (net13 net69 net12 vssa) nmos1 l=180n w=1u m=1
	mpb02 (net27 net51 net158 vdda) pmos1 l=180n w=1u m=1
	mppd1 (net158 xpd vdda vdda) pmos1 l=180n w=1u m=1
	mps11 (net31 net158 vdda vdda) pmos1 l=180n w=1u m=1
	mpd11 (net56 inn net31 net31) pmos1 l=180n w=1u m=1
	mp001 (out net158 vdda vdda) pmos1 l=180n w=1u m=1
	mpd12 (net13 inp net31 net31) pmos1 l=180n w=1u m=1
	mpb01 (net158 net158 vdda vdda) pmos1 l=180n w=1u m=1
ends OPAMP1_variant279

subckt OPAMP1_variant280 inn inp out pd xpd vdda vssa
	xd1 (vssa vdda) prim_nwd AREA=6.13907e-9 PJ=476.6e-6 m=1
	xi0 (vssa net69) prim_nd AREA=1e-12 PJ=4e-6 m=1
	xi3 (net51 vdda) prim_pd AREA=790e-15 PJ=3.3e-6 m=1
	xr0 (vssa vdda net51) prim_rdiffp l=2.1e-6 w=700e-9 m=1
	xr1 (vdda vdda net69) prim_rdiffp l=2.4e-07 w=6.9e-07 m=1
	xcc01 (net12 out) prim_cpoly c=1p m=1
	mnm12 (net13 net56 vssa vssa) nmos1 l=180n w=1u m=1
	mnm11 (net56 net56 vssa vssa) nmos1 l=180n w=1u m=1
	mnb02 (net27 net27 net21 vssa) nmos1 l=180n w=1u m=1
	mnpd1 (net21 xpd vssa vssa) nmos1 l=1.3e-07n w=1.2e-06u m=1
	mn001 (out net13 vssa vssa) nmos1 l=180n w=1u m=1
	mnpd2 (net13 pd vssa vssa) nmos1 l=180n w=1u m=1
	mnc01 (net13 net69 net12 vssa) nmos1 l=180n w=1u m=1
	mpb02 (net27 net51 net158 vdda) pmos1 l=1.3e-07n w=1.5e-06u m=1
	mppd1 (net158 xpd vdda vdda) pmos1 l=2.5e-07n w=7.9e-07u m=1
	mps11 (net31 net158 vdda vdda) pmos1 l=180n w=1u m=1
	mpd11 (net56 inn net31 net31) pmos1 l=180n w=1u m=1
	mp001 (out net158 vdda vdda) pmos1 l=180n w=1u m=1
	mpd12 (net13 inp net31 net31) pmos1 l=180n w=1u m=1
	mpb01 (net158 net158 vdda vdda) pmos1 l=180n w=1u m=1
ends OPAMP1_variant280

subckt OPAMP1_variant281 inn inp out pd xpd vdda vssa
	xd1 (vssa vdda) prim_nwd AREA=6.13907e-9 PJ=476.6e-6 m=1
	xi0 (vssa net69) prim_nd AREA=1e-12 PJ=4e-6 m=1
	xi3 (net51 vdda) prim_pd AREA=9.4e-09 PJ=5.1e-05 m=1
	xr0 (vssa vdda net51) prim_rdiffp l=2.1e-6 w=700e-9 m=1
	xr1 (vdda vdda net69) prim_rdiffp l=2.1e-6 w=700e-9 m=1
	xcc01 (net12 out) prim_cpoly c=1p m=1
	mnm12 (net13 net56 vssa vssa) nmos1 l=180n w=1u m=1
	mnm11 (net56 net56 vssa vssa) nmos1 l=180n w=1u m=1
	mnb02 (net27 net27 net21 vssa) nmos1 l=180n w=1u m=1
	mnpd1 (net21 xpd vssa vssa) nmos1 l=180n w=1u m=1
	mn001 (out net13 vssa vssa) nmos1 l=180n w=1u m=1
	mnpd2 (net13 pd vssa vssa) nmos1 l=180n w=1u m=1
	mnc01 (net13 net69 net12 vssa) nmos1 l=180n w=1u m=1
	mpb02 (net27 net51 net158 vdda) pmos1 l=180n w=1u m=1
	mppd1 (net158 xpd vdda vdda) pmos1 l=180n w=1u m=1
	mps11 (net31 net158 vdda vdda) pmos1 l=2.1e-07n w=1.4e-06u m=1
	mpd11 (net56 inn net31 net31) pmos1 l=180n w=1u m=1
	mp001 (out net158 vdda vdda) pmos1 l=180n w=1u m=1
	mpd12 (net13 inp net31 net31) pmos1 l=180n w=1u m=1
	mpb01 (net158 net158 vdda vdda) pmos1 l=180n w=1u m=1
ends OPAMP1_variant281

subckt OPAMP1_variant282 inn inp out pd xpd vdda vssa
	xd1 (vssa vdda) prim_nwd AREA=6.13907e-9 PJ=476.6e-6 m=1
	xi0 (vssa net69) prim_nd AREA=1e-12 PJ=4e-6 m=1
	xi3 (net51 vdda) prim_pd AREA=7.6e-10 PJ=3.7e-05 m=1
	xr0 (vssa vdda net51) prim_rdiffp l=2.1e-6 w=700e-9 m=1
	xr1 (vdda vdda net69) prim_rdiffp l=2.1e-6 w=700e-9 m=1
	xcc01 (net12 out) prim_cpoly c=1p m=1
	mnm12 (net13 net56 vssa vssa) nmos1 l=180n w=1u m=1
	mnm11 (net56 net56 vssa vssa) nmos1 l=180n w=1u m=1
	mnb02 (net27 net27 net21 vssa) nmos1 l=180n w=1u m=1
	mnpd1 (net21 xpd vssa vssa) nmos1 l=180n w=1u m=1
	mn001 (out net13 vssa vssa) nmos1 l=180n w=1u m=1
	mnpd2 (net13 pd vssa vssa) nmos1 l=180n w=1u m=1
	mnc01 (net13 net69 net12 vssa) nmos1 l=180n w=1u m=1
	mpb02 (net27 net51 net158 vdda) pmos1 l=180n w=1u m=1
	mppd1 (net158 xpd vdda vdda) pmos1 l=180n w=1u m=1
	mps11 (net31 net158 vdda vdda) pmos1 l=180n w=1u m=1
	mpd11 (net56 inn net31 net31) pmos1 l=1.9e-07n w=1.1e-06u m=1
	mp001 (out net158 vdda vdda) pmos1 l=180n w=1u m=1
	mpd12 (net13 inp net31 net31) pmos1 l=2.6e-07n w=1.7e-06u m=1
	mpb01 (net158 net158 vdda vdda) pmos1 l=1.4e-07n w=1.6e-06u m=1
ends OPAMP1_variant282

subckt OPAMP1_variant283 inn inp out pd xpd vdda vssa
	xd1 (vssa vdda) prim_nwd AREA=6.13907e-9 PJ=476.6e-6 m=1
	xi0 (vssa net69) prim_nd AREA=1e-12 PJ=4e-6 m=1
	xi3 (net51 vdda) prim_pd AREA=790e-15 PJ=3.3e-6 m=1
	xr0 (vssa vdda net51) prim_rdiffp l=2.1e-6 w=700e-9 m=1
	xr1 (vdda vdda net69) prim_rdiffp l=2.1e-6 w=700e-9 m=1
	xcc01 (net12 out) prim_cpoly c=1p m=1
	mnm12 (net13 net56 vssa vssa) nmos1 l=180n w=1u m=1
	mnm11 (net56 net56 vssa vssa) nmos1 l=180n w=1u m=1
	mnb02 (net27 net27 net21 vssa) nmos1 l=180n w=1u m=1
	mnpd1 (net21 xpd vssa vssa) nmos1 l=180n w=1u m=1
	mn001 (out net13 vssa vssa) nmos1 l=180n w=1u m=1
	mnpd2 (net13 pd vssa vssa) nmos1 l=180n w=1u m=1
	mnc01 (net13 net69 net12 vssa) nmos1 l=180n w=1u m=1
	mpb02 (net27 net51 net158 vdda) pmos1 l=180n w=1u m=1
	mppd1 (net158 xpd vdda vdda) pmos1 l=180n w=1u m=1
	mps11 (net31 net158 vdda vdda) pmos1 l=2.3e-07n w=8.6e-07u m=1
	mpd11 (net56 inn net31 net31) pmos1 l=2.2e-07n w=1.0e-06u m=1
	mp001 (out net158 vdda vdda) pmos1 l=180n w=1u m=1
	mpd12 (net13 inp net31 net31) pmos1 l=180n w=1u m=1
	mpb01 (net158 net158 vdda vdda) pmos1 l=180n w=1u m=1
ends OPAMP1_variant283

subckt OPAMP1_variant284 inn inp out pd xpd vdda vssa
	xd1 (vssa vdda) prim_nwd AREA=6.13907e-9 PJ=476.6e-6 m=1
	xi0 (vssa net69) prim_nd AREA=3.9e-09 PJ=6.3e-05 m=1
	xi3 (net51 vdda) prim_pd AREA=790e-15 PJ=3.3e-6 m=1
	xr0 (vssa vdda net51) prim_rdiffp l=2.1e-6 w=700e-9 m=1
	xr1 (vdda vdda net69) prim_rdiffp l=2.1e-6 w=700e-9 m=1
	xcc01 (net12 out) prim_cpoly c=1.9e-12p m=1
	mnm12 (net13 net56 vssa vssa) nmos1 l=180n w=1u m=1
	mnm11 (net56 net56 vssa vssa) nmos1 l=180n w=1u m=1
	mnb02 (net27 net27 net21 vssa) nmos1 l=1.7e-07n w=6.8e-07u m=1
	mnpd1 (net21 xpd vssa vssa) nmos1 l=180n w=1u m=1
	mn001 (out net13 vssa vssa) nmos1 l=180n w=1u m=1
	mnpd2 (net13 pd vssa vssa) nmos1 l=180n w=1u m=1
	mnc01 (net13 net69 net12 vssa) nmos1 l=180n w=1u m=1
	mpb02 (net27 net51 net158 vdda) pmos1 l=180n w=1u m=1
	mppd1 (net158 xpd vdda vdda) pmos1 l=180n w=1u m=1
	mps11 (net31 net158 vdda vdda) pmos1 l=180n w=1u m=1
	mpd11 (net56 inn net31 net31) pmos1 l=180n w=1u m=1
	mp001 (out net158 vdda vdda) pmos1 l=180n w=1u m=1
	mpd12 (net13 inp net31 net31) pmos1 l=180n w=1u m=1
	mpb01 (net158 net158 vdda vdda) pmos1 l=180n w=1u m=1
ends OPAMP1_variant284

subckt OPAMP1_variant285 inn inp out pd xpd vdda vssa
	xd1 (vssa vdda) prim_nwd AREA=6.13907e-9 PJ=476.6e-6 m=1
	xi0 (vssa net69) prim_nd AREA=1e-12 PJ=4e-6 m=1
	xi3 (net51 vdda) prim_pd AREA=790e-15 PJ=3.3e-6 m=1
	xr0 (vssa vdda net51) prim_rdiffp l=2.1e-6 w=700e-9 m=1
	xr1 (vdda vdda net69) prim_rdiffp l=2.1e-6 w=700e-9 m=1
	xcc01 (net12 out) prim_cpoly c=1p m=1
	mnm12 (net13 net56 vssa vssa) nmos1 l=1.3e-07n w=1.0e-06u m=1
	mnm11 (net56 net56 vssa vssa) nmos1 l=2.9e-07n w=1.1e-06u m=1
	mnb02 (net27 net27 net21 vssa) nmos1 l=180n w=1u m=1
	mnpd1 (net21 xpd vssa vssa) nmos1 l=180n w=1u m=1
	mn001 (out net13 vssa vssa) nmos1 l=180n w=1u m=1
	mnpd2 (net13 pd vssa vssa) nmos1 l=1.4e-07n w=1.5e-06u m=1
	mnc01 (net13 net69 net12 vssa) nmos1 l=1.6e-07n w=1.8e-06u m=1
	mpb02 (net27 net51 net158 vdda) pmos1 l=180n w=1u m=1
	mppd1 (net158 xpd vdda vdda) pmos1 l=180n w=1u m=1
	mps11 (net31 net158 vdda vdda) pmos1 l=180n w=1u m=1
	mpd11 (net56 inn net31 net31) pmos1 l=180n w=1u m=1
	mp001 (out net158 vdda vdda) pmos1 l=180n w=1u m=1
	mpd12 (net13 inp net31 net31) pmos1 l=180n w=1u m=1
	mpb01 (net158 net158 vdda vdda) pmos1 l=180n w=1u m=1
ends OPAMP1_variant285

subckt OPAMP1_variant286 inn inp out pd xpd vdda vssa
	xd1 (vssa vdda) prim_nwd AREA=9.7e-09 PJ=9.6e-05 m=1
	xi0 (vssa net69) prim_nd AREA=1e-12 PJ=4e-6 m=1
	xi3 (net51 vdda) prim_pd AREA=5.6e-09 PJ=5.5e-05 m=1
	xr0 (vssa vdda net51) prim_rdiffp l=2.1e-6 w=700e-9 m=1
	xr1 (vdda vdda net69) prim_rdiffp l=2.1e-6 w=700e-9 m=1
	xcc01 (net12 out) prim_cpoly c=1.8e-12p m=1
	mnm12 (net13 net56 vssa vssa) nmos1 l=1.5e-07n w=1.3e-06u m=1
	mnm11 (net56 net56 vssa vssa) nmos1 l=180n w=1u m=1
	mnb02 (net27 net27 net21 vssa) nmos1 l=180n w=1u m=1
	mnpd1 (net21 xpd vssa vssa) nmos1 l=180n w=1u m=1
	mn001 (out net13 vssa vssa) nmos1 l=2.7e-07n w=1.2e-06u m=1
	mnpd2 (net13 pd vssa vssa) nmos1 l=180n w=1u m=1
	mnc01 (net13 net69 net12 vssa) nmos1 l=180n w=1u m=1
	mpb02 (net27 net51 net158 vdda) pmos1 l=180n w=1u m=1
	mppd1 (net158 xpd vdda vdda) pmos1 l=180n w=1u m=1
	mps11 (net31 net158 vdda vdda) pmos1 l=180n w=1u m=1
	mpd11 (net56 inn net31 net31) pmos1 l=180n w=1u m=1
	mp001 (out net158 vdda vdda) pmos1 l=180n w=1u m=1
	mpd12 (net13 inp net31 net31) pmos1 l=180n w=1u m=1
	mpb01 (net158 net158 vdda vdda) pmos1 l=180n w=1u m=1
ends OPAMP1_variant286

subckt OPAMP1_variant287 inn inp out pd xpd vdda vssa
	xd1 (vssa vdda) prim_nwd AREA=5.9e-09 PJ=4.8e-05 m=1
	xi0 (vssa net69) prim_nd AREA=1e-12 PJ=4e-6 m=1
	xi3 (net51 vdda) prim_pd AREA=790e-15 PJ=3.3e-6 m=1
	xr0 (vssa vdda net51) prim_rdiffp l=2.1e-6 w=700e-9 m=1
	xr1 (vdda vdda net69) prim_rdiffp l=2.1e-6 w=700e-9 m=1
	xcc01 (net12 out) prim_cpoly c=1p m=1
	mnm12 (net13 net56 vssa vssa) nmos1 l=180n w=1u m=1
	mnm11 (net56 net56 vssa vssa) nmos1 l=180n w=1u m=1
	mnb02 (net27 net27 net21 vssa) nmos1 l=1.6e-07n w=1.3e-06u m=1
	mnpd1 (net21 xpd vssa vssa) nmos1 l=1.5e-07n w=1.9e-06u m=1
	mn001 (out net13 vssa vssa) nmos1 l=1.9e-07n w=1.7e-06u m=1
	mnpd2 (net13 pd vssa vssa) nmos1 l=180n w=1u m=1
	mnc01 (net13 net69 net12 vssa) nmos1 l=180n w=1u m=1
	mpb02 (net27 net51 net158 vdda) pmos1 l=180n w=1u m=1
	mppd1 (net158 xpd vdda vdda) pmos1 l=180n w=1u m=1
	mps11 (net31 net158 vdda vdda) pmos1 l=180n w=1u m=1
	mpd11 (net56 inn net31 net31) pmos1 l=180n w=1u m=1
	mp001 (out net158 vdda vdda) pmos1 l=180n w=1u m=1
	mpd12 (net13 inp net31 net31) pmos1 l=180n w=1u m=1
	mpb01 (net158 net158 vdda vdda) pmos1 l=180n w=1u m=1
ends OPAMP1_variant287

subckt OPAMP1_variant288 inn inp out pd xpd vdda vssa
	xd1 (vssa vdda) prim_nwd AREA=6.13907e-9 PJ=476.6e-6 m=1
	xi0 (vssa net69) prim_nd AREA=1e-12 PJ=4e-6 m=1
	xi3 (net51 vdda) prim_pd AREA=790e-15 PJ=3.3e-6 m=1
	xr0 (vssa vdda net51) prim_rdiffp l=2.1e-6 w=700e-9 m=1
	xr1 (vdda vdda net69) prim_rdiffp l=2.1e-6 w=700e-9 m=1
	xcc01 (net12 out) prim_cpoly c=1p m=1
	mnm12 (net13 net56 vssa vssa) nmos1 l=180n w=1u m=1
	mnm11 (net56 net56 vssa vssa) nmos1 l=1.5e-07n w=7.4e-07u m=1
	mnb02 (net27 net27 net21 vssa) nmos1 l=180n w=1u m=1
	mnpd1 (net21 xpd vssa vssa) nmos1 l=180n w=1u m=1
	mn001 (out net13 vssa vssa) nmos1 l=180n w=1u m=1
	mnpd2 (net13 pd vssa vssa) nmos1 l=180n w=1u m=1
	mnc01 (net13 net69 net12 vssa) nmos1 l=180n w=1u m=1
	mpb02 (net27 net51 net158 vdda) pmos1 l=180n w=1u m=1
	mppd1 (net158 xpd vdda vdda) pmos1 l=180n w=1u m=1
	mps11 (net31 net158 vdda vdda) pmos1 l=180n w=1u m=1
	mpd11 (net56 inn net31 net31) pmos1 l=180n w=1u m=1
	mp001 (out net158 vdda vdda) pmos1 l=180n w=1u m=1
	mpd12 (net13 inp net31 net31) pmos1 l=180n w=1u m=1
	mpb01 (net158 net158 vdda vdda) pmos1 l=2.3e-07n w=1.4e-06u m=1
ends OPAMP1_variant288

subckt OPAMP1_variant289 inn inp out pd xpd vdda vssa
	xd1 (vssa vdda) prim_nwd AREA=6.13907e-9 PJ=476.6e-6 m=1
	xi0 (vssa net69) prim_nd AREA=1e-12 PJ=4e-6 m=1
	xi3 (net51 vdda) prim_pd AREA=790e-15 PJ=3.3e-6 m=1
	xr0 (vssa vdda net51) prim_rdiffp l=2.1e-07 w=1.4e-06 m=1
	xr1 (vdda vdda net69) prim_rdiffp l=2.1e-6 w=700e-9 m=1
	xcc01 (net12 out) prim_cpoly c=1p m=1
	mnm12 (net13 net56 vssa vssa) nmos1 l=180n w=1u m=1
	mnm11 (net56 net56 vssa vssa) nmos1 l=180n w=1u m=1
	mnb02 (net27 net27 net21 vssa) nmos1 l=180n w=1u m=1
	mnpd1 (net21 xpd vssa vssa) nmos1 l=180n w=1u m=1
	mn001 (out net13 vssa vssa) nmos1 l=180n w=1u m=1
	mnpd2 (net13 pd vssa vssa) nmos1 l=180n w=1u m=1
	mnc01 (net13 net69 net12 vssa) nmos1 l=180n w=1u m=1
	mpb02 (net27 net51 net158 vdda) pmos1 l=180n w=1u m=1
	mppd1 (net158 xpd vdda vdda) pmos1 l=1.8e-07n w=5.8e-07u m=1
	mps11 (net31 net158 vdda vdda) pmos1 l=1.6e-07n w=1.8e-06u m=1
	mpd11 (net56 inn net31 net31) pmos1 l=180n w=1u m=1
	mp001 (out net158 vdda vdda) pmos1 l=2.5e-07n w=9.6e-07u m=1
	mpd12 (net13 inp net31 net31) pmos1 l=180n w=1u m=1
	mpb01 (net158 net158 vdda vdda) pmos1 l=180n w=1u m=1
ends OPAMP1_variant289

subckt OPAMP1_variant290 inn inp out pd xpd vdda vssa
	xd1 (vssa vdda) prim_nwd AREA=6.13907e-9 PJ=476.6e-6 m=1
	xi0 (vssa net69) prim_nd AREA=6.3e-09 PJ=3.4e-05 m=1
	xi3 (net51 vdda) prim_pd AREA=790e-15 PJ=3.3e-6 m=1
	xr0 (vssa vdda net51) prim_rdiffp l=2.1e-6 w=700e-9 m=1
	xr1 (vdda vdda net69) prim_rdiffp l=2.1e-6 w=700e-9 m=1
	xcc01 (net12 out) prim_cpoly c=1.7e-12p m=1
	mnm12 (net13 net56 vssa vssa) nmos1 l=180n w=1u m=1
	mnm11 (net56 net56 vssa vssa) nmos1 l=180n w=1u m=1
	mnb02 (net27 net27 net21 vssa) nmos1 l=180n w=1u m=1
	mnpd1 (net21 xpd vssa vssa) nmos1 l=180n w=1u m=1
	mn001 (out net13 vssa vssa) nmos1 l=180n w=1u m=1
	mnpd2 (net13 pd vssa vssa) nmos1 l=180n w=1u m=1
	mnc01 (net13 net69 net12 vssa) nmos1 l=180n w=1u m=1
	mpb02 (net27 net51 net158 vdda) pmos1 l=180n w=1u m=1
	mppd1 (net158 xpd vdda vdda) pmos1 l=180n w=1u m=1
	mps11 (net31 net158 vdda vdda) pmos1 l=2.8e-07n w=7.4e-07u m=1
	mpd11 (net56 inn net31 net31) pmos1 l=180n w=1u m=1
	mp001 (out net158 vdda vdda) pmos1 l=180n w=1u m=1
	mpd12 (net13 inp net31 net31) pmos1 l=180n w=1u m=1
	mpb01 (net158 net158 vdda vdda) pmos1 l=180n w=1u m=1
ends OPAMP1_variant290

subckt OPAMP1_variant291 inn inp out pd xpd vdda vssa
	xd1 (vssa vdda) prim_nwd AREA=3.1e-09 PJ=2.5e-05 m=1
	xi0 (vssa net69) prim_nd AREA=1e-12 PJ=4e-6 m=1
	xi3 (net51 vdda) prim_pd AREA=790e-15 PJ=3.3e-6 m=1
	xr0 (vssa vdda net51) prim_rdiffp l=2.1e-6 w=700e-9 m=1
	xr1 (vdda vdda net69) prim_rdiffp l=2.1e-6 w=700e-9 m=1
	xcc01 (net12 out) prim_cpoly c=1p m=1
	mnm12 (net13 net56 vssa vssa) nmos1 l=180n w=1u m=1
	mnm11 (net56 net56 vssa vssa) nmos1 l=180n w=1u m=1
	mnb02 (net27 net27 net21 vssa) nmos1 l=180n w=1u m=1
	mnpd1 (net21 xpd vssa vssa) nmos1 l=180n w=1u m=1
	mn001 (out net13 vssa vssa) nmos1 l=2.9e-07n w=9.7e-07u m=1
	mnpd2 (net13 pd vssa vssa) nmos1 l=180n w=1u m=1
	mnc01 (net13 net69 net12 vssa) nmos1 l=180n w=1u m=1
	mpb02 (net27 net51 net158 vdda) pmos1 l=1.4e-07n w=1.4e-06u m=1
	mppd1 (net158 xpd vdda vdda) pmos1 l=180n w=1u m=1
	mps11 (net31 net158 vdda vdda) pmos1 l=180n w=1u m=1
	mpd11 (net56 inn net31 net31) pmos1 l=180n w=1u m=1
	mp001 (out net158 vdda vdda) pmos1 l=180n w=1u m=1
	mpd12 (net13 inp net31 net31) pmos1 l=180n w=1u m=1
	mpb01 (net158 net158 vdda vdda) pmos1 l=1.4e-07n w=1.6e-06u m=1
ends OPAMP1_variant291

subckt OPAMP1_variant292 inn inp out pd xpd vdda vssa
	xd1 (vssa vdda) prim_nwd AREA=3.6e-09 PJ=1.9e-05 m=1
	xi0 (vssa net69) prim_nd AREA=5.5e-10 PJ=5.4e-05 m=1
	xi3 (net51 vdda) prim_pd AREA=790e-15 PJ=3.3e-6 m=1
	xr0 (vssa vdda net51) prim_rdiffp l=2.1e-6 w=700e-9 m=1
	xr1 (vdda vdda net69) prim_rdiffp l=2.1e-6 w=700e-9 m=1
	xcc01 (net12 out) prim_cpoly c=1p m=1
	mnm12 (net13 net56 vssa vssa) nmos1 l=180n w=1u m=1
	mnm11 (net56 net56 vssa vssa) nmos1 l=180n w=1u m=1
	mnb02 (net27 net27 net21 vssa) nmos1 l=180n w=1u m=1
	mnpd1 (net21 xpd vssa vssa) nmos1 l=180n w=1u m=1
	mn001 (out net13 vssa vssa) nmos1 l=1.4e-07n w=1.1e-06u m=1
	mnpd2 (net13 pd vssa vssa) nmos1 l=180n w=1u m=1
	mnc01 (net13 net69 net12 vssa) nmos1 l=180n w=1u m=1
	mpb02 (net27 net51 net158 vdda) pmos1 l=180n w=1u m=1
	mppd1 (net158 xpd vdda vdda) pmos1 l=180n w=1u m=1
	mps11 (net31 net158 vdda vdda) pmos1 l=180n w=1u m=1
	mpd11 (net56 inn net31 net31) pmos1 l=180n w=1u m=1
	mp001 (out net158 vdda vdda) pmos1 l=180n w=1u m=1
	mpd12 (net13 inp net31 net31) pmos1 l=180n w=1u m=1
	mpb01 (net158 net158 vdda vdda) pmos1 l=180n w=1u m=1
ends OPAMP1_variant292

subckt OPAMP1_variant293 inn inp out pd xpd vdda vssa
	xd1 (vssa vdda) prim_nwd AREA=6.3e-09 PJ=4.9e-05 m=1
	xi0 (vssa net69) prim_nd AREA=1e-12 PJ=4e-6 m=1
	xi3 (net51 vdda) prim_pd AREA=790e-15 PJ=3.3e-6 m=1
	xr0 (vssa vdda net51) prim_rdiffp l=2.1e-6 w=700e-9 m=1
	xr1 (vdda vdda net69) prim_rdiffp l=2.1e-6 w=700e-9 m=1
	xcc01 (net12 out) prim_cpoly c=1p m=1
	mnm12 (net13 net56 vssa vssa) nmos1 l=180n w=1u m=1
	mnm11 (net56 net56 vssa vssa) nmos1 l=180n w=1u m=1
	mnb02 (net27 net27 net21 vssa) nmos1 l=2.6e-07n w=2.0e-06u m=1
	mnpd1 (net21 xpd vssa vssa) nmos1 l=180n w=1u m=1
	mn001 (out net13 vssa vssa) nmos1 l=180n w=1u m=1
	mnpd2 (net13 pd vssa vssa) nmos1 l=1.5e-07n w=1.6e-06u m=1
	mnc01 (net13 net69 net12 vssa) nmos1 l=180n w=1u m=1
	mpb02 (net27 net51 net158 vdda) pmos1 l=180n w=1u m=1
	mppd1 (net158 xpd vdda vdda) pmos1 l=180n w=1u m=1
	mps11 (net31 net158 vdda vdda) pmos1 l=180n w=1u m=1
	mpd11 (net56 inn net31 net31) pmos1 l=180n w=1u m=1
	mp001 (out net158 vdda vdda) pmos1 l=180n w=1u m=1
	mpd12 (net13 inp net31 net31) pmos1 l=180n w=1u m=1
	mpb01 (net158 net158 vdda vdda) pmos1 l=180n w=1u m=1
ends OPAMP1_variant293

subckt OPAMP1_variant294 inn inp out pd xpd vdda vssa
	xd1 (vssa vdda) prim_nwd AREA=6.13907e-9 PJ=476.6e-6 m=1
	xi0 (vssa net69) prim_nd AREA=1e-12 PJ=4e-6 m=1
	xi3 (net51 vdda) prim_pd AREA=790e-15 PJ=3.3e-6 m=1
	xr0 (vssa vdda net51) prim_rdiffp l=2.1e-6 w=700e-9 m=1
	xr1 (vdda vdda net69) prim_rdiffp l=2.1e-6 w=700e-9 m=1
	xcc01 (net12 out) prim_cpoly c=1p m=1
	mnm12 (net13 net56 vssa vssa) nmos1 l=2.3e-07n w=1.8e-06u m=1
	mnm11 (net56 net56 vssa vssa) nmos1 l=180n w=1u m=1
	mnb02 (net27 net27 net21 vssa) nmos1 l=180n w=1u m=1
	mnpd1 (net21 xpd vssa vssa) nmos1 l=180n w=1u m=1
	mn001 (out net13 vssa vssa) nmos1 l=180n w=1u m=1
	mnpd2 (net13 pd vssa vssa) nmos1 l=180n w=1u m=1
	mnc01 (net13 net69 net12 vssa) nmos1 l=1.6e-07n w=7.3e-07u m=1
	mpb02 (net27 net51 net158 vdda) pmos1 l=180n w=1u m=1
	mppd1 (net158 xpd vdda vdda) pmos1 l=180n w=1u m=1
	mps11 (net31 net158 vdda vdda) pmos1 l=180n w=1u m=1
	mpd11 (net56 inn net31 net31) pmos1 l=180n w=1u m=1
	mp001 (out net158 vdda vdda) pmos1 l=180n w=1u m=1
	mpd12 (net13 inp net31 net31) pmos1 l=180n w=1u m=1
	mpb01 (net158 net158 vdda vdda) pmos1 l=180n w=1u m=1
ends OPAMP1_variant294

subckt OPAMP1_variant295 inn inp out pd xpd vdda vssa
	xd1 (vssa vdda) prim_nwd AREA=6.13907e-9 PJ=476.6e-6 m=1
	xi0 (vssa net69) prim_nd AREA=1e-12 PJ=4e-6 m=1
	xi3 (net51 vdda) prim_pd AREA=790e-15 PJ=3.3e-6 m=1
	xr0 (vssa vdda net51) prim_rdiffp l=2.1e-6 w=700e-9 m=1
	xr1 (vdda vdda net69) prim_rdiffp l=2.1e-6 w=700e-9 m=1
	xcc01 (net12 out) prim_cpoly c=1.1e-12p m=1
	mnm12 (net13 net56 vssa vssa) nmos1 l=180n w=1u m=1
	mnm11 (net56 net56 vssa vssa) nmos1 l=180n w=1u m=1
	mnb02 (net27 net27 net21 vssa) nmos1 l=180n w=1u m=1
	mnpd1 (net21 xpd vssa vssa) nmos1 l=180n w=1u m=1
	mn001 (out net13 vssa vssa) nmos1 l=180n w=1u m=1
	mnpd2 (net13 pd vssa vssa) nmos1 l=180n w=1u m=1
	mnc01 (net13 net69 net12 vssa) nmos1 l=1.9e-07n w=1.5e-06u m=1
	mpb02 (net27 net51 net158 vdda) pmos1 l=180n w=1u m=1
	mppd1 (net158 xpd vdda vdda) pmos1 l=180n w=1u m=1
	mps11 (net31 net158 vdda vdda) pmos1 l=180n w=1u m=1
	mpd11 (net56 inn net31 net31) pmos1 l=180n w=1u m=1
	mp001 (out net158 vdda vdda) pmos1 l=180n w=1u m=1
	mpd12 (net13 inp net31 net31) pmos1 l=2.0e-07n w=9.9e-07u m=1
	mpb01 (net158 net158 vdda vdda) pmos1 l=180n w=1u m=1
ends OPAMP1_variant295

subckt OPAMP1_variant296 inn inp out pd xpd vdda vssa
	xd1 (vssa vdda) prim_nwd AREA=6.13907e-9 PJ=476.6e-6 m=1
	xi0 (vssa net69) prim_nd AREA=1e-12 PJ=4e-6 m=1
	xi3 (net51 vdda) prim_pd AREA=790e-15 PJ=3.3e-6 m=1
	xr0 (vssa vdda net51) prim_rdiffp l=2.1e-6 w=700e-9 m=1
	xr1 (vdda vdda net69) prim_rdiffp l=2.1e-6 w=700e-9 m=1
	xcc01 (net12 out) prim_cpoly c=1.5e-12p m=1
	mnm12 (net13 net56 vssa vssa) nmos1 l=180n w=1u m=1
	mnm11 (net56 net56 vssa vssa) nmos1 l=180n w=1u m=1
	mnb02 (net27 net27 net21 vssa) nmos1 l=2.6e-07n w=7.4e-07u m=1
	mnpd1 (net21 xpd vssa vssa) nmos1 l=1.3e-07n w=1.4e-06u m=1
	mn001 (out net13 vssa vssa) nmos1 l=180n w=1u m=1
	mnpd2 (net13 pd vssa vssa) nmos1 l=180n w=1u m=1
	mnc01 (net13 net69 net12 vssa) nmos1 l=180n w=1u m=1
	mpb02 (net27 net51 net158 vdda) pmos1 l=1.3e-07n w=1.1e-06u m=1
	mppd1 (net158 xpd vdda vdda) pmos1 l=180n w=1u m=1
	mps11 (net31 net158 vdda vdda) pmos1 l=180n w=1u m=1
	mpd11 (net56 inn net31 net31) pmos1 l=180n w=1u m=1
	mp001 (out net158 vdda vdda) pmos1 l=180n w=1u m=1
	mpd12 (net13 inp net31 net31) pmos1 l=180n w=1u m=1
	mpb01 (net158 net158 vdda vdda) pmos1 l=180n w=1u m=1
ends OPAMP1_variant296

subckt OPAMP1_variant297 inn inp out pd xpd vdda vssa
	xd1 (vssa vdda) prim_nwd AREA=6.13907e-9 PJ=476.6e-6 m=1
	xi0 (vssa net69) prim_nd AREA=1e-12 PJ=4e-6 m=1
	xi3 (net51 vdda) prim_pd AREA=790e-15 PJ=3.3e-6 m=1
	xr0 (vssa vdda net51) prim_rdiffp l=2.1e-6 w=700e-9 m=1
	xr1 (vdda vdda net69) prim_rdiffp l=2.1e-6 w=700e-9 m=1
	xcc01 (net12 out) prim_cpoly c=1p m=1
	mnm12 (net13 net56 vssa vssa) nmos1 l=180n w=1u m=1
	mnm11 (net56 net56 vssa vssa) nmos1 l=180n w=1u m=1
	mnb02 (net27 net27 net21 vssa) nmos1 l=180n w=1u m=1
	mnpd1 (net21 xpd vssa vssa) nmos1 l=180n w=1u m=1
	mn001 (out net13 vssa vssa) nmos1 l=180n w=1u m=1
	mnpd2 (net13 pd vssa vssa) nmos1 l=180n w=1u m=1
	mnc01 (net13 net69 net12 vssa) nmos1 l=180n w=1u m=1
	mpb02 (net27 net51 net158 vdda) pmos1 l=180n w=1u m=1
	mppd1 (net158 xpd vdda vdda) pmos1 l=1.3e-07n w=5.2e-07u m=1
	mps11 (net31 net158 vdda vdda) pmos1 l=180n w=1u m=1
	mpd11 (net56 inn net31 net31) pmos1 l=180n w=1u m=1
	mp001 (out net158 vdda vdda) pmos1 l=1.3e-07n w=1.2e-06u m=1
	mpd12 (net13 inp net31 net31) pmos1 l=180n w=1u m=1
	mpb01 (net158 net158 vdda vdda) pmos1 l=180n w=1u m=1
ends OPAMP1_variant297

subckt OPAMP1_variant298 inn inp out pd xpd vdda vssa
	xd1 (vssa vdda) prim_nwd AREA=6.13907e-9 PJ=476.6e-6 m=1
	xi0 (vssa net69) prim_nd AREA=1e-12 PJ=4e-6 m=1
	xi3 (net51 vdda) prim_pd AREA=790e-15 PJ=3.3e-6 m=1
	xr0 (vssa vdda net51) prim_rdiffp l=2.1e-6 w=700e-9 m=1
	xr1 (vdda vdda net69) prim_rdiffp l=2.1e-6 w=700e-9 m=1
	xcc01 (net12 out) prim_cpoly c=1p m=1
	mnm12 (net13 net56 vssa vssa) nmos1 l=180n w=1u m=1
	mnm11 (net56 net56 vssa vssa) nmos1 l=180n w=1u m=1
	mnb02 (net27 net27 net21 vssa) nmos1 l=180n w=1u m=1
	mnpd1 (net21 xpd vssa vssa) nmos1 l=1.9e-07n w=1.3e-06u m=1
	mn001 (out net13 vssa vssa) nmos1 l=180n w=1u m=1
	mnpd2 (net13 pd vssa vssa) nmos1 l=180n w=1u m=1
	mnc01 (net13 net69 net12 vssa) nmos1 l=180n w=1u m=1
	mpb02 (net27 net51 net158 vdda) pmos1 l=1.2e-07n w=9.5e-07u m=1
	mppd1 (net158 xpd vdda vdda) pmos1 l=180n w=1u m=1
	mps11 (net31 net158 vdda vdda) pmos1 l=180n w=1u m=1
	mpd11 (net56 inn net31 net31) pmos1 l=180n w=1u m=1
	mp001 (out net158 vdda vdda) pmos1 l=2.4e-07n w=1.8e-06u m=1
	mpd12 (net13 inp net31 net31) pmos1 l=180n w=1u m=1
	mpb01 (net158 net158 vdda vdda) pmos1 l=180n w=1u m=1
ends OPAMP1_variant298

subckt OPAMP1_variant299 inn inp out pd xpd vdda vssa
	xd1 (vssa vdda) prim_nwd AREA=9.5e-09 PJ=8.0e-05 m=1
	xi0 (vssa net69) prim_nd AREA=1e-12 PJ=4e-6 m=1
	xi3 (net51 vdda) prim_pd AREA=1.4e-09 PJ=9.6e-05 m=1
	xr0 (vssa vdda net51) prim_rdiffp l=2.1e-6 w=700e-9 m=1
	xr1 (vdda vdda net69) prim_rdiffp l=2.4e-07 w=1.4e-06 m=1
	xcc01 (net12 out) prim_cpoly c=1p m=1
	mnm12 (net13 net56 vssa vssa) nmos1 l=180n w=1u m=1
	mnm11 (net56 net56 vssa vssa) nmos1 l=180n w=1u m=1
	mnb02 (net27 net27 net21 vssa) nmos1 l=180n w=1u m=1
	mnpd1 (net21 xpd vssa vssa) nmos1 l=180n w=1u m=1
	mn001 (out net13 vssa vssa) nmos1 l=180n w=1u m=1
	mnpd2 (net13 pd vssa vssa) nmos1 l=180n w=1u m=1
	mnc01 (net13 net69 net12 vssa) nmos1 l=180n w=1u m=1
	mpb02 (net27 net51 net158 vdda) pmos1 l=180n w=1u m=1
	mppd1 (net158 xpd vdda vdda) pmos1 l=180n w=1u m=1
	mps11 (net31 net158 vdda vdda) pmos1 l=180n w=1u m=1
	mpd11 (net56 inn net31 net31) pmos1 l=2.2e-07n w=6.2e-07u m=1
	mp001 (out net158 vdda vdda) pmos1 l=180n w=1u m=1
	mpd12 (net13 inp net31 net31) pmos1 l=180n w=1u m=1
	mpb01 (net158 net158 vdda vdda) pmos1 l=180n w=1u m=1
ends OPAMP1_variant299

subckt OPAMP1_variant300 inn inp out pd xpd vdda vssa
	xd1 (vssa vdda) prim_nwd AREA=6.13907e-9 PJ=476.6e-6 m=1
	xi0 (vssa net69) prim_nd AREA=1e-12 PJ=4e-6 m=1
	xi3 (net51 vdda) prim_pd AREA=790e-15 PJ=3.3e-6 m=1
	xr0 (vssa vdda net51) prim_rdiffp l=2.5e-07 w=8.8e-07 m=1
	xr1 (vdda vdda net69) prim_rdiffp l=2.1e-6 w=700e-9 m=1
	xcc01 (net12 out) prim_cpoly c=1p m=1
	mnm12 (net13 net56 vssa vssa) nmos1 l=180n w=1u m=1
	mnm11 (net56 net56 vssa vssa) nmos1 l=180n w=1u m=1
	mnb02 (net27 net27 net21 vssa) nmos1 l=180n w=1u m=1
	mnpd1 (net21 xpd vssa vssa) nmos1 l=180n w=1u m=1
	mn001 (out net13 vssa vssa) nmos1 l=180n w=1u m=1
	mnpd2 (net13 pd vssa vssa) nmos1 l=180n w=1u m=1
	mnc01 (net13 net69 net12 vssa) nmos1 l=180n w=1u m=1
	mpb02 (net27 net51 net158 vdda) pmos1 l=180n w=1u m=1
	mppd1 (net158 xpd vdda vdda) pmos1 l=1.1e-07n w=1.8e-06u m=1
	mps11 (net31 net158 vdda vdda) pmos1 l=180n w=1u m=1
	mpd11 (net56 inn net31 net31) pmos1 l=180n w=1u m=1
	mp001 (out net158 vdda vdda) pmos1 l=2.7e-07n w=1.8e-06u m=1
	mpd12 (net13 inp net31 net31) pmos1 l=180n w=1u m=1
	mpb01 (net158 net158 vdda vdda) pmos1 l=1.7e-07n w=7.3e-07u m=1
ends OPAMP1_variant300

subckt OPAMP1_variant301 inn inp out pd xpd vdda vssa
	xd1 (vssa vdda) prim_nwd AREA=6.13907e-9 PJ=476.6e-6 m=1
	xi0 (vssa net69) prim_nd AREA=5.3e-09 PJ=9.3e-05 m=1
	xi3 (net51 vdda) prim_pd AREA=790e-15 PJ=3.3e-6 m=1
	xr0 (vssa vdda net51) prim_rdiffp l=2.1e-6 w=700e-9 m=1
	xr1 (vdda vdda net69) prim_rdiffp l=2.1e-6 w=700e-9 m=1
	xcc01 (net12 out) prim_cpoly c=1p m=1
	mnm12 (net13 net56 vssa vssa) nmos1 l=1.2e-07n w=1.8e-06u m=1
	mnm11 (net56 net56 vssa vssa) nmos1 l=180n w=1u m=1
	mnb02 (net27 net27 net21 vssa) nmos1 l=180n w=1u m=1
	mnpd1 (net21 xpd vssa vssa) nmos1 l=180n w=1u m=1
	mn001 (out net13 vssa vssa) nmos1 l=180n w=1u m=1
	mnpd2 (net13 pd vssa vssa) nmos1 l=180n w=1u m=1
	mnc01 (net13 net69 net12 vssa) nmos1 l=180n w=1u m=1
	mpb02 (net27 net51 net158 vdda) pmos1 l=180n w=1u m=1
	mppd1 (net158 xpd vdda vdda) pmos1 l=180n w=1u m=1
	mps11 (net31 net158 vdda vdda) pmos1 l=180n w=1u m=1
	mpd11 (net56 inn net31 net31) pmos1 l=180n w=1u m=1
	mp001 (out net158 vdda vdda) pmos1 l=180n w=1u m=1
	mpd12 (net13 inp net31 net31) pmos1 l=180n w=1u m=1
	mpb01 (net158 net158 vdda vdda) pmos1 l=180n w=1u m=1
ends OPAMP1_variant301

subckt OPAMP1_variant302 inn inp out pd xpd vdda vssa
	xd1 (vssa vdda) prim_nwd AREA=9.6e-09 PJ=3.1e-05 m=1
	xi0 (vssa net69) prim_nd AREA=1e-12 PJ=4e-6 m=1
	xi3 (net51 vdda) prim_pd AREA=790e-15 PJ=3.3e-6 m=1
	xr0 (vssa vdda net51) prim_rdiffp l=2.1e-6 w=700e-9 m=1
	xr1 (vdda vdda net69) prim_rdiffp l=2.1e-6 w=700e-9 m=1
	xcc01 (net12 out) prim_cpoly c=1p m=1
	mnm12 (net13 net56 vssa vssa) nmos1 l=180n w=1u m=1
	mnm11 (net56 net56 vssa vssa) nmos1 l=1.4e-07n w=8.7e-07u m=1
	mnb02 (net27 net27 net21 vssa) nmos1 l=180n w=1u m=1
	mnpd1 (net21 xpd vssa vssa) nmos1 l=180n w=1u m=1
	mn001 (out net13 vssa vssa) nmos1 l=180n w=1u m=1
	mnpd2 (net13 pd vssa vssa) nmos1 l=180n w=1u m=1
	mnc01 (net13 net69 net12 vssa) nmos1 l=180n w=1u m=1
	mpb02 (net27 net51 net158 vdda) pmos1 l=180n w=1u m=1
	mppd1 (net158 xpd vdda vdda) pmos1 l=180n w=1u m=1
	mps11 (net31 net158 vdda vdda) pmos1 l=180n w=1u m=1
	mpd11 (net56 inn net31 net31) pmos1 l=180n w=1u m=1
	mp001 (out net158 vdda vdda) pmos1 l=2.0e-07n w=1.2e-06u m=1
	mpd12 (net13 inp net31 net31) pmos1 l=2.1e-07n w=1.4e-06u m=1
	mpb01 (net158 net158 vdda vdda) pmos1 l=180n w=1u m=1
ends OPAMP1_variant302

subckt OPAMP1_variant303 inn inp out pd xpd vdda vssa
	xd1 (vssa vdda) prim_nwd AREA=6.13907e-9 PJ=476.6e-6 m=1
	xi0 (vssa net69) prim_nd AREA=6.5e-09 PJ=8.6e-05 m=1
	xi3 (net51 vdda) prim_pd AREA=790e-15 PJ=3.3e-6 m=1
	xr0 (vssa vdda net51) prim_rdiffp l=2.1e-6 w=700e-9 m=1
	xr1 (vdda vdda net69) prim_rdiffp l=2.1e-6 w=700e-9 m=1
	xcc01 (net12 out) prim_cpoly c=1p m=1
	mnm12 (net13 net56 vssa vssa) nmos1 l=180n w=1u m=1
	mnm11 (net56 net56 vssa vssa) nmos1 l=180n w=1u m=1
	mnb02 (net27 net27 net21 vssa) nmos1 l=180n w=1u m=1
	mnpd1 (net21 xpd vssa vssa) nmos1 l=180n w=1u m=1
	mn001 (out net13 vssa vssa) nmos1 l=180n w=1u m=1
	mnpd2 (net13 pd vssa vssa) nmos1 l=180n w=1u m=1
	mnc01 (net13 net69 net12 vssa) nmos1 l=2.4e-07n w=7.3e-07u m=1
	mpb02 (net27 net51 net158 vdda) pmos1 l=180n w=1u m=1
	mppd1 (net158 xpd vdda vdda) pmos1 l=180n w=1u m=1
	mps11 (net31 net158 vdda vdda) pmos1 l=180n w=1u m=1
	mpd11 (net56 inn net31 net31) pmos1 l=180n w=1u m=1
	mp001 (out net158 vdda vdda) pmos1 l=180n w=1u m=1
	mpd12 (net13 inp net31 net31) pmos1 l=180n w=1u m=1
	mpb01 (net158 net158 vdda vdda) pmos1 l=1.1e-07n w=1.2e-06u m=1
ends OPAMP1_variant303

subckt OPAMP1_variant304 inn inp out pd xpd vdda vssa
	xd1 (vssa vdda) prim_nwd AREA=6.13907e-9 PJ=476.6e-6 m=1
	xi0 (vssa net69) prim_nd AREA=5.9e-10 PJ=8.3e-05 m=1
	xi3 (net51 vdda) prim_pd AREA=790e-15 PJ=3.3e-6 m=1
	xr0 (vssa vdda net51) prim_rdiffp l=2.1e-6 w=700e-9 m=1
	xr1 (vdda vdda net69) prim_rdiffp l=2.1e-6 w=700e-9 m=1
	xcc01 (net12 out) prim_cpoly c=1p m=1
	mnm12 (net13 net56 vssa vssa) nmos1 l=180n w=1u m=1
	mnm11 (net56 net56 vssa vssa) nmos1 l=180n w=1u m=1
	mnb02 (net27 net27 net21 vssa) nmos1 l=180n w=1u m=1
	mnpd1 (net21 xpd vssa vssa) nmos1 l=180n w=1u m=1
	mn001 (out net13 vssa vssa) nmos1 l=180n w=1u m=1
	mnpd2 (net13 pd vssa vssa) nmos1 l=180n w=1u m=1
	mnc01 (net13 net69 net12 vssa) nmos1 l=180n w=1u m=1
	mpb02 (net27 net51 net158 vdda) pmos1 l=2.0e-07n w=1.6e-06u m=1
	mppd1 (net158 xpd vdda vdda) pmos1 l=180n w=1u m=1
	mps11 (net31 net158 vdda vdda) pmos1 l=180n w=1u m=1
	mpd11 (net56 inn net31 net31) pmos1 l=180n w=1u m=1
	mp001 (out net158 vdda vdda) pmos1 l=180n w=1u m=1
	mpd12 (net13 inp net31 net31) pmos1 l=180n w=1u m=1
	mpb01 (net158 net158 vdda vdda) pmos1 l=180n w=1u m=1
ends OPAMP1_variant304

subckt OPAMP1_variant305 inn inp out pd xpd vdda vssa
	xd1 (vssa vdda) prim_nwd AREA=6.13907e-9 PJ=476.6e-6 m=1
	xi0 (vssa net69) prim_nd AREA=1e-12 PJ=4e-6 m=1
	xi3 (net51 vdda) prim_pd AREA=790e-15 PJ=3.3e-6 m=1
	xr0 (vssa vdda net51) prim_rdiffp l=2.1e-6 w=700e-9 m=1
	xr1 (vdda vdda net69) prim_rdiffp l=2.3e-07 w=1.7e-06 m=1
	xcc01 (net12 out) prim_cpoly c=1p m=1
	mnm12 (net13 net56 vssa vssa) nmos1 l=180n w=1u m=1
	mnm11 (net56 net56 vssa vssa) nmos1 l=180n w=1u m=1
	mnb02 (net27 net27 net21 vssa) nmos1 l=180n w=1u m=1
	mnpd1 (net21 xpd vssa vssa) nmos1 l=180n w=1u m=1
	mn001 (out net13 vssa vssa) nmos1 l=180n w=1u m=1
	mnpd2 (net13 pd vssa vssa) nmos1 l=180n w=1u m=1
	mnc01 (net13 net69 net12 vssa) nmos1 l=180n w=1u m=1
	mpb02 (net27 net51 net158 vdda) pmos1 l=180n w=1u m=1
	mppd1 (net158 xpd vdda vdda) pmos1 l=180n w=1u m=1
	mps11 (net31 net158 vdda vdda) pmos1 l=180n w=1u m=1
	mpd11 (net56 inn net31 net31) pmos1 l=180n w=1u m=1
	mp001 (out net158 vdda vdda) pmos1 l=1.6e-07n w=1.4e-06u m=1
	mpd12 (net13 inp net31 net31) pmos1 l=180n w=1u m=1
	mpb01 (net158 net158 vdda vdda) pmos1 l=180n w=1u m=1
ends OPAMP1_variant305

subckt OPAMP1_variant306 inn inp out pd xpd vdda vssa
	xd1 (vssa vdda) prim_nwd AREA=6.13907e-9 PJ=476.6e-6 m=1
	xi0 (vssa net69) prim_nd AREA=7.2e-10 PJ=4.4e-05 m=1
	xi3 (net51 vdda) prim_pd AREA=790e-15 PJ=3.3e-6 m=1
	xr0 (vssa vdda net51) prim_rdiffp l=2.1e-6 w=700e-9 m=1
	xr1 (vdda vdda net69) prim_rdiffp l=2.1e-6 w=700e-9 m=1
	xcc01 (net12 out) prim_cpoly c=1p m=1
	mnm12 (net13 net56 vssa vssa) nmos1 l=180n w=1u m=1
	mnm11 (net56 net56 vssa vssa) nmos1 l=180n w=1u m=1
	mnb02 (net27 net27 net21 vssa) nmos1 l=180n w=1u m=1
	mnpd1 (net21 xpd vssa vssa) nmos1 l=1.3e-07n w=1.2e-06u m=1
	mn001 (out net13 vssa vssa) nmos1 l=2.3e-07n w=1.6e-06u m=1
	mnpd2 (net13 pd vssa vssa) nmos1 l=180n w=1u m=1
	mnc01 (net13 net69 net12 vssa) nmos1 l=180n w=1u m=1
	mpb02 (net27 net51 net158 vdda) pmos1 l=1.7e-07n w=1.6e-06u m=1
	mppd1 (net158 xpd vdda vdda) pmos1 l=180n w=1u m=1
	mps11 (net31 net158 vdda vdda) pmos1 l=1.9e-07n w=1.2e-06u m=1
	mpd11 (net56 inn net31 net31) pmos1 l=180n w=1u m=1
	mp001 (out net158 vdda vdda) pmos1 l=180n w=1u m=1
	mpd12 (net13 inp net31 net31) pmos1 l=180n w=1u m=1
	mpb01 (net158 net158 vdda vdda) pmos1 l=180n w=1u m=1
ends OPAMP1_variant306

subckt OPAMP1_variant307 inn inp out pd xpd vdda vssa
	xd1 (vssa vdda) prim_nwd AREA=6.13907e-9 PJ=476.6e-6 m=1
	xi0 (vssa net69) prim_nd AREA=9.2e-10 PJ=8.0e-05 m=1
	xi3 (net51 vdda) prim_pd AREA=790e-15 PJ=3.3e-6 m=1
	xr0 (vssa vdda net51) prim_rdiffp l=2.0e-07 w=1.9e-06 m=1
	xr1 (vdda vdda net69) prim_rdiffp l=2.1e-6 w=700e-9 m=1
	xcc01 (net12 out) prim_cpoly c=1p m=1
	mnm12 (net13 net56 vssa vssa) nmos1 l=180n w=1u m=1
	mnm11 (net56 net56 vssa vssa) nmos1 l=180n w=1u m=1
	mnb02 (net27 net27 net21 vssa) nmos1 l=180n w=1u m=1
	mnpd1 (net21 xpd vssa vssa) nmos1 l=180n w=1u m=1
	mn001 (out net13 vssa vssa) nmos1 l=180n w=1u m=1
	mnpd2 (net13 pd vssa vssa) nmos1 l=180n w=1u m=1
	mnc01 (net13 net69 net12 vssa) nmos1 l=180n w=1u m=1
	mpb02 (net27 net51 net158 vdda) pmos1 l=2.5e-07n w=6.0e-07u m=1
	mppd1 (net158 xpd vdda vdda) pmos1 l=1.7e-07n w=1.6e-06u m=1
	mps11 (net31 net158 vdda vdda) pmos1 l=180n w=1u m=1
	mpd11 (net56 inn net31 net31) pmos1 l=2.9e-07n w=1.3e-06u m=1
	mp001 (out net158 vdda vdda) pmos1 l=180n w=1u m=1
	mpd12 (net13 inp net31 net31) pmos1 l=180n w=1u m=1
	mpb01 (net158 net158 vdda vdda) pmos1 l=180n w=1u m=1
ends OPAMP1_variant307

subckt OPAMP1_variant308 inn inp out pd xpd vdda vssa
	xd1 (vssa vdda) prim_nwd AREA=6.13907e-9 PJ=476.6e-6 m=1
	xi0 (vssa net69) prim_nd AREA=1e-12 PJ=4e-6 m=1
	xi3 (net51 vdda) prim_pd AREA=1.1e-09 PJ=6.7e-05 m=1
	xr0 (vssa vdda net51) prim_rdiffp l=2.1e-6 w=700e-9 m=1
	xr1 (vdda vdda net69) prim_rdiffp l=2.4e-07 w=1.8e-06 m=1
	xcc01 (net12 out) prim_cpoly c=1p m=1
	mnm12 (net13 net56 vssa vssa) nmos1 l=1.3e-07n w=8.1e-07u m=1
	mnm11 (net56 net56 vssa vssa) nmos1 l=180n w=1u m=1
	mnb02 (net27 net27 net21 vssa) nmos1 l=2.0e-07n w=7.3e-07u m=1
	mnpd1 (net21 xpd vssa vssa) nmos1 l=180n w=1u m=1
	mn001 (out net13 vssa vssa) nmos1 l=180n w=1u m=1
	mnpd2 (net13 pd vssa vssa) nmos1 l=180n w=1u m=1
	mnc01 (net13 net69 net12 vssa) nmos1 l=180n w=1u m=1
	mpb02 (net27 net51 net158 vdda) pmos1 l=1.0e-07n w=5.7e-07u m=1
	mppd1 (net158 xpd vdda vdda) pmos1 l=180n w=1u m=1
	mps11 (net31 net158 vdda vdda) pmos1 l=180n w=1u m=1
	mpd11 (net56 inn net31 net31) pmos1 l=180n w=1u m=1
	mp001 (out net158 vdda vdda) pmos1 l=180n w=1u m=1
	mpd12 (net13 inp net31 net31) pmos1 l=180n w=1u m=1
	mpb01 (net158 net158 vdda vdda) pmos1 l=180n w=1u m=1
ends OPAMP1_variant308

subckt OPAMP1_variant309 inn inp out pd xpd vdda vssa
	xd1 (vssa vdda) prim_nwd AREA=6.13907e-9 PJ=476.6e-6 m=1
	xi0 (vssa net69) prim_nd AREA=1e-12 PJ=4e-6 m=1
	xi3 (net51 vdda) prim_pd AREA=790e-15 PJ=3.3e-6 m=1
	xr0 (vssa vdda net51) prim_rdiffp l=2.1e-6 w=700e-9 m=1
	xr1 (vdda vdda net69) prim_rdiffp l=1.5e-07 w=1.2e-06 m=1
	xcc01 (net12 out) prim_cpoly c=1.5e-12p m=1
	mnm12 (net13 net56 vssa vssa) nmos1 l=180n w=1u m=1
	mnm11 (net56 net56 vssa vssa) nmos1 l=180n w=1u m=1
	mnb02 (net27 net27 net21 vssa) nmos1 l=180n w=1u m=1
	mnpd1 (net21 xpd vssa vssa) nmos1 l=180n w=1u m=1
	mn001 (out net13 vssa vssa) nmos1 l=180n w=1u m=1
	mnpd2 (net13 pd vssa vssa) nmos1 l=180n w=1u m=1
	mnc01 (net13 net69 net12 vssa) nmos1 l=2.7e-07n w=1.5e-06u m=1
	mpb02 (net27 net51 net158 vdda) pmos1 l=180n w=1u m=1
	mppd1 (net158 xpd vdda vdda) pmos1 l=180n w=1u m=1
	mps11 (net31 net158 vdda vdda) pmos1 l=180n w=1u m=1
	mpd11 (net56 inn net31 net31) pmos1 l=180n w=1u m=1
	mp001 (out net158 vdda vdda) pmos1 l=180n w=1u m=1
	mpd12 (net13 inp net31 net31) pmos1 l=180n w=1u m=1
	mpb01 (net158 net158 vdda vdda) pmos1 l=180n w=1u m=1
ends OPAMP1_variant309

subckt OPAMP1_variant310 inn inp out pd xpd vdda vssa
	xd1 (vssa vdda) prim_nwd AREA=6.13907e-9 PJ=476.6e-6 m=1
	xi0 (vssa net69) prim_nd AREA=1e-12 PJ=4e-6 m=1
	xi3 (net51 vdda) prim_pd AREA=790e-15 PJ=3.3e-6 m=1
	xr0 (vssa vdda net51) prim_rdiffp l=2.1e-6 w=700e-9 m=1
	xr1 (vdda vdda net69) prim_rdiffp l=2.1e-6 w=700e-9 m=1
	xcc01 (net12 out) prim_cpoly c=1p m=1
	mnm12 (net13 net56 vssa vssa) nmos1 l=1.6e-07n w=9.8e-07u m=1
	mnm11 (net56 net56 vssa vssa) nmos1 l=180n w=1u m=1
	mnb02 (net27 net27 net21 vssa) nmos1 l=180n w=1u m=1
	mnpd1 (net21 xpd vssa vssa) nmos1 l=180n w=1u m=1
	mn001 (out net13 vssa vssa) nmos1 l=180n w=1u m=1
	mnpd2 (net13 pd vssa vssa) nmos1 l=180n w=1u m=1
	mnc01 (net13 net69 net12 vssa) nmos1 l=180n w=1u m=1
	mpb02 (net27 net51 net158 vdda) pmos1 l=180n w=1u m=1
	mppd1 (net158 xpd vdda vdda) pmos1 l=180n w=1u m=1
	mps11 (net31 net158 vdda vdda) pmos1 l=180n w=1u m=1
	mpd11 (net56 inn net31 net31) pmos1 l=180n w=1u m=1
	mp001 (out net158 vdda vdda) pmos1 l=180n w=1u m=1
	mpd12 (net13 inp net31 net31) pmos1 l=180n w=1u m=1
	mpb01 (net158 net158 vdda vdda) pmos1 l=2.4e-07n w=2.0e-06u m=1
ends OPAMP1_variant310

subckt OPAMP1_variant311 inn inp out pd xpd vdda vssa
	xd1 (vssa vdda) prim_nwd AREA=6.13907e-9 PJ=476.6e-6 m=1
	xi0 (vssa net69) prim_nd AREA=1e-12 PJ=4e-6 m=1
	xi3 (net51 vdda) prim_pd AREA=790e-15 PJ=3.3e-6 m=1
	xr0 (vssa vdda net51) prim_rdiffp l=2.1e-6 w=700e-9 m=1
	xr1 (vdda vdda net69) prim_rdiffp l=2.1e-6 w=700e-9 m=1
	xcc01 (net12 out) prim_cpoly c=1.5e-12p m=1
	mnm12 (net13 net56 vssa vssa) nmos1 l=180n w=1u m=1
	mnm11 (net56 net56 vssa vssa) nmos1 l=180n w=1u m=1
	mnb02 (net27 net27 net21 vssa) nmos1 l=180n w=1u m=1
	mnpd1 (net21 xpd vssa vssa) nmos1 l=180n w=1u m=1
	mn001 (out net13 vssa vssa) nmos1 l=2.9e-07n w=1.7e-06u m=1
	mnpd2 (net13 pd vssa vssa) nmos1 l=180n w=1u m=1
	mnc01 (net13 net69 net12 vssa) nmos1 l=180n w=1u m=1
	mpb02 (net27 net51 net158 vdda) pmos1 l=180n w=1u m=1
	mppd1 (net158 xpd vdda vdda) pmos1 l=180n w=1u m=1
	mps11 (net31 net158 vdda vdda) pmos1 l=180n w=1u m=1
	mpd11 (net56 inn net31 net31) pmos1 l=180n w=1u m=1
	mp001 (out net158 vdda vdda) pmos1 l=180n w=1u m=1
	mpd12 (net13 inp net31 net31) pmos1 l=180n w=1u m=1
	mpb01 (net158 net158 vdda vdda) pmos1 l=180n w=1u m=1
ends OPAMP1_variant311

subckt OPAMP1_variant312 inn inp out pd xpd vdda vssa
	xd1 (vssa vdda) prim_nwd AREA=6.13907e-9 PJ=476.6e-6 m=1
	xi0 (vssa net69) prim_nd AREA=1e-12 PJ=4e-6 m=1
	xi3 (net51 vdda) prim_pd AREA=790e-15 PJ=3.3e-6 m=1
	xr0 (vssa vdda net51) prim_rdiffp l=2.1e-6 w=700e-9 m=1
	xr1 (vdda vdda net69) prim_rdiffp l=2.1e-6 w=700e-9 m=1
	xcc01 (net12 out) prim_cpoly c=1p m=1
	mnm12 (net13 net56 vssa vssa) nmos1 l=180n w=1u m=1
	mnm11 (net56 net56 vssa vssa) nmos1 l=2.4e-07n w=8.6e-07u m=1
	mnb02 (net27 net27 net21 vssa) nmos1 l=180n w=1u m=1
	mnpd1 (net21 xpd vssa vssa) nmos1 l=180n w=1u m=1
	mn001 (out net13 vssa vssa) nmos1 l=180n w=1u m=1
	mnpd2 (net13 pd vssa vssa) nmos1 l=180n w=1u m=1
	mnc01 (net13 net69 net12 vssa) nmos1 l=3.0e-07n w=5.4e-07u m=1
	mpb02 (net27 net51 net158 vdda) pmos1 l=180n w=1u m=1
	mppd1 (net158 xpd vdda vdda) pmos1 l=180n w=1u m=1
	mps11 (net31 net158 vdda vdda) pmos1 l=2.0e-07n w=1.6e-06u m=1
	mpd11 (net56 inn net31 net31) pmos1 l=1.6e-07n w=1.6e-06u m=1
	mp001 (out net158 vdda vdda) pmos1 l=180n w=1u m=1
	mpd12 (net13 inp net31 net31) pmos1 l=1.2e-07n w=6.8e-07u m=1
	mpb01 (net158 net158 vdda vdda) pmos1 l=180n w=1u m=1
ends OPAMP1_variant312

subckt OPAMP1_variant313 inn inp out pd xpd vdda vssa
	xd1 (vssa vdda) prim_nwd AREA=6.13907e-9 PJ=476.6e-6 m=1
	xi0 (vssa net69) prim_nd AREA=8.1e-09 PJ=3.8e-05 m=1
	xi3 (net51 vdda) prim_pd AREA=790e-15 PJ=3.3e-6 m=1
	xr0 (vssa vdda net51) prim_rdiffp l=2.1e-6 w=700e-9 m=1
	xr1 (vdda vdda net69) prim_rdiffp l=2.1e-6 w=700e-9 m=1
	xcc01 (net12 out) prim_cpoly c=1.3e-12p m=1
	mnm12 (net13 net56 vssa vssa) nmos1 l=180n w=1u m=1
	mnm11 (net56 net56 vssa vssa) nmos1 l=180n w=1u m=1
	mnb02 (net27 net27 net21 vssa) nmos1 l=180n w=1u m=1
	mnpd1 (net21 xpd vssa vssa) nmos1 l=2.6e-07n w=1.6e-06u m=1
	mn001 (out net13 vssa vssa) nmos1 l=180n w=1u m=1
	mnpd2 (net13 pd vssa vssa) nmos1 l=180n w=1u m=1
	mnc01 (net13 net69 net12 vssa) nmos1 l=180n w=1u m=1
	mpb02 (net27 net51 net158 vdda) pmos1 l=3.0e-07n w=1.4e-06u m=1
	mppd1 (net158 xpd vdda vdda) pmos1 l=180n w=1u m=1
	mps11 (net31 net158 vdda vdda) pmos1 l=180n w=1u m=1
	mpd11 (net56 inn net31 net31) pmos1 l=180n w=1u m=1
	mp001 (out net158 vdda vdda) pmos1 l=180n w=1u m=1
	mpd12 (net13 inp net31 net31) pmos1 l=180n w=1u m=1
	mpb01 (net158 net158 vdda vdda) pmos1 l=180n w=1u m=1
ends OPAMP1_variant313

subckt OPAMP1_variant314 inn inp out pd xpd vdda vssa
	xd1 (vssa vdda) prim_nwd AREA=6.13907e-9 PJ=476.6e-6 m=1
	xi0 (vssa net69) prim_nd AREA=1e-12 PJ=4e-6 m=1
	xi3 (net51 vdda) prim_pd AREA=790e-15 PJ=3.3e-6 m=1
	xr0 (vssa vdda net51) prim_rdiffp l=2.1e-6 w=700e-9 m=1
	xr1 (vdda vdda net69) prim_rdiffp l=2.1e-6 w=700e-9 m=1
	xcc01 (net12 out) prim_cpoly c=1p m=1
	mnm12 (net13 net56 vssa vssa) nmos1 l=180n w=1u m=1
	mnm11 (net56 net56 vssa vssa) nmos1 l=180n w=1u m=1
	mnb02 (net27 net27 net21 vssa) nmos1 l=180n w=1u m=1
	mnpd1 (net21 xpd vssa vssa) nmos1 l=180n w=1u m=1
	mn001 (out net13 vssa vssa) nmos1 l=180n w=1u m=1
	mnpd2 (net13 pd vssa vssa) nmos1 l=180n w=1u m=1
	mnc01 (net13 net69 net12 vssa) nmos1 l=180n w=1u m=1
	mpb02 (net27 net51 net158 vdda) pmos1 l=1.0e-07n w=5.2e-07u m=1
	mppd1 (net158 xpd vdda vdda) pmos1 l=180n w=1u m=1
	mps11 (net31 net158 vdda vdda) pmos1 l=180n w=1u m=1
	mpd11 (net56 inn net31 net31) pmos1 l=2.0e-07n w=1.3e-06u m=1
	mp001 (out net158 vdda vdda) pmos1 l=180n w=1u m=1
	mpd12 (net13 inp net31 net31) pmos1 l=180n w=1u m=1
	mpb01 (net158 net158 vdda vdda) pmos1 l=180n w=1u m=1
ends OPAMP1_variant314

subckt OPAMP1_variant315 inn inp out pd xpd vdda vssa
	xd1 (vssa vdda) prim_nwd AREA=6.13907e-9 PJ=476.6e-6 m=1
	xi0 (vssa net69) prim_nd AREA=1e-12 PJ=4e-6 m=1
	xi3 (net51 vdda) prim_pd AREA=790e-15 PJ=3.3e-6 m=1
	xr0 (vssa vdda net51) prim_rdiffp l=2.1e-6 w=700e-9 m=1
	xr1 (vdda vdda net69) prim_rdiffp l=2.1e-6 w=700e-9 m=1
	xcc01 (net12 out) prim_cpoly c=1.2e-12p m=1
	mnm12 (net13 net56 vssa vssa) nmos1 l=180n w=1u m=1
	mnm11 (net56 net56 vssa vssa) nmos1 l=3.0e-07n w=7.4e-07u m=1
	mnb02 (net27 net27 net21 vssa) nmos1 l=180n w=1u m=1
	mnpd1 (net21 xpd vssa vssa) nmos1 l=180n w=1u m=1
	mn001 (out net13 vssa vssa) nmos1 l=180n w=1u m=1
	mnpd2 (net13 pd vssa vssa) nmos1 l=180n w=1u m=1
	mnc01 (net13 net69 net12 vssa) nmos1 l=180n w=1u m=1
	mpb02 (net27 net51 net158 vdda) pmos1 l=180n w=1u m=1
	mppd1 (net158 xpd vdda vdda) pmos1 l=180n w=1u m=1
	mps11 (net31 net158 vdda vdda) pmos1 l=180n w=1u m=1
	mpd11 (net56 inn net31 net31) pmos1 l=180n w=1u m=1
	mp001 (out net158 vdda vdda) pmos1 l=180n w=1u m=1
	mpd12 (net13 inp net31 net31) pmos1 l=3.0e-07n w=1.3e-06u m=1
	mpb01 (net158 net158 vdda vdda) pmos1 l=180n w=1u m=1
ends OPAMP1_variant315

subckt OPAMP1_variant316 inn inp out pd xpd vdda vssa
	xd1 (vssa vdda) prim_nwd AREA=6.13907e-9 PJ=476.6e-6 m=1
	xi0 (vssa net69) prim_nd AREA=1e-12 PJ=4e-6 m=1
	xi3 (net51 vdda) prim_pd AREA=790e-15 PJ=3.3e-6 m=1
	xr0 (vssa vdda net51) prim_rdiffp l=2.1e-6 w=700e-9 m=1
	xr1 (vdda vdda net69) prim_rdiffp l=2.1e-6 w=700e-9 m=1
	xcc01 (net12 out) prim_cpoly c=1p m=1
	mnm12 (net13 net56 vssa vssa) nmos1 l=180n w=1u m=1
	mnm11 (net56 net56 vssa vssa) nmos1 l=1.3e-07n w=1.7e-06u m=1
	mnb02 (net27 net27 net21 vssa) nmos1 l=180n w=1u m=1
	mnpd1 (net21 xpd vssa vssa) nmos1 l=2.8e-07n w=1.6e-06u m=1
	mn001 (out net13 vssa vssa) nmos1 l=180n w=1u m=1
	mnpd2 (net13 pd vssa vssa) nmos1 l=180n w=1u m=1
	mnc01 (net13 net69 net12 vssa) nmos1 l=180n w=1u m=1
	mpb02 (net27 net51 net158 vdda) pmos1 l=180n w=1u m=1
	mppd1 (net158 xpd vdda vdda) pmos1 l=180n w=1u m=1
	mps11 (net31 net158 vdda vdda) pmos1 l=180n w=1u m=1
	mpd11 (net56 inn net31 net31) pmos1 l=1.5e-07n w=2.0e-06u m=1
	mp001 (out net158 vdda vdda) pmos1 l=180n w=1u m=1
	mpd12 (net13 inp net31 net31) pmos1 l=2.0e-07n w=1.1e-06u m=1
	mpb01 (net158 net158 vdda vdda) pmos1 l=180n w=1u m=1
ends OPAMP1_variant316

subckt OPAMP1_variant317 inn inp out pd xpd vdda vssa
	xd1 (vssa vdda) prim_nwd AREA=6.13907e-9 PJ=476.6e-6 m=1
	xi0 (vssa net69) prim_nd AREA=1e-12 PJ=4e-6 m=1
	xi3 (net51 vdda) prim_pd AREA=4.9e-09 PJ=1.5e-05 m=1
	xr0 (vssa vdda net51) prim_rdiffp l=2.3e-07 w=1.8e-06 m=1
	xr1 (vdda vdda net69) prim_rdiffp l=2.1e-6 w=700e-9 m=1
	xcc01 (net12 out) prim_cpoly c=1p m=1
	mnm12 (net13 net56 vssa vssa) nmos1 l=180n w=1u m=1
	mnm11 (net56 net56 vssa vssa) nmos1 l=2.7e-07n w=9.0e-07u m=1
	mnb02 (net27 net27 net21 vssa) nmos1 l=180n w=1u m=1
	mnpd1 (net21 xpd vssa vssa) nmos1 l=2.6e-07n w=1.3e-06u m=1
	mn001 (out net13 vssa vssa) nmos1 l=180n w=1u m=1
	mnpd2 (net13 pd vssa vssa) nmos1 l=180n w=1u m=1
	mnc01 (net13 net69 net12 vssa) nmos1 l=180n w=1u m=1
	mpb02 (net27 net51 net158 vdda) pmos1 l=180n w=1u m=1
	mppd1 (net158 xpd vdda vdda) pmos1 l=180n w=1u m=1
	mps11 (net31 net158 vdda vdda) pmos1 l=180n w=1u m=1
	mpd11 (net56 inn net31 net31) pmos1 l=1.6e-07n w=1.2e-06u m=1
	mp001 (out net158 vdda vdda) pmos1 l=180n w=1u m=1
	mpd12 (net13 inp net31 net31) pmos1 l=180n w=1u m=1
	mpb01 (net158 net158 vdda vdda) pmos1 l=180n w=1u m=1
ends OPAMP1_variant317

subckt OPAMP1_variant318 inn inp out pd xpd vdda vssa
	xd1 (vssa vdda) prim_nwd AREA=6.13907e-9 PJ=476.6e-6 m=1
	xi0 (vssa net69) prim_nd AREA=1e-12 PJ=4e-6 m=1
	xi3 (net51 vdda) prim_pd AREA=790e-15 PJ=3.3e-6 m=1
	xr0 (vssa vdda net51) prim_rdiffp l=2.1e-6 w=700e-9 m=1
	xr1 (vdda vdda net69) prim_rdiffp l=2.1e-6 w=700e-9 m=1
	xcc01 (net12 out) prim_cpoly c=1.5e-12p m=1
	mnm12 (net13 net56 vssa vssa) nmos1 l=180n w=1u m=1
	mnm11 (net56 net56 vssa vssa) nmos1 l=180n w=1u m=1
	mnb02 (net27 net27 net21 vssa) nmos1 l=180n w=1u m=1
	mnpd1 (net21 xpd vssa vssa) nmos1 l=180n w=1u m=1
	mn001 (out net13 vssa vssa) nmos1 l=180n w=1u m=1
	mnpd2 (net13 pd vssa vssa) nmos1 l=180n w=1u m=1
	mnc01 (net13 net69 net12 vssa) nmos1 l=2.9e-07n w=5.9e-07u m=1
	mpb02 (net27 net51 net158 vdda) pmos1 l=180n w=1u m=1
	mppd1 (net158 xpd vdda vdda) pmos1 l=180n w=1u m=1
	mps11 (net31 net158 vdda vdda) pmos1 l=180n w=1u m=1
	mpd11 (net56 inn net31 net31) pmos1 l=2.6e-07n w=1.9e-06u m=1
	mp001 (out net158 vdda vdda) pmos1 l=1.5e-07n w=1.2e-06u m=1
	mpd12 (net13 inp net31 net31) pmos1 l=180n w=1u m=1
	mpb01 (net158 net158 vdda vdda) pmos1 l=180n w=1u m=1
ends OPAMP1_variant318

subckt OPAMP1_variant319 inn inp out pd xpd vdda vssa
	xd1 (vssa vdda) prim_nwd AREA=6.13907e-9 PJ=476.6e-6 m=1
	xi0 (vssa net69) prim_nd AREA=1e-12 PJ=4e-6 m=1
	xi3 (net51 vdda) prim_pd AREA=790e-15 PJ=3.3e-6 m=1
	xr0 (vssa vdda net51) prim_rdiffp l=2.1e-6 w=700e-9 m=1
	xr1 (vdda vdda net69) prim_rdiffp l=2.1e-6 w=700e-9 m=1
	xcc01 (net12 out) prim_cpoly c=1p m=1
	mnm12 (net13 net56 vssa vssa) nmos1 l=180n w=1u m=1
	mnm11 (net56 net56 vssa vssa) nmos1 l=1.6e-07n w=1.1e-06u m=1
	mnb02 (net27 net27 net21 vssa) nmos1 l=180n w=1u m=1
	mnpd1 (net21 xpd vssa vssa) nmos1 l=180n w=1u m=1
	mn001 (out net13 vssa vssa) nmos1 l=180n w=1u m=1
	mnpd2 (net13 pd vssa vssa) nmos1 l=180n w=1u m=1
	mnc01 (net13 net69 net12 vssa) nmos1 l=180n w=1u m=1
	mpb02 (net27 net51 net158 vdda) pmos1 l=180n w=1u m=1
	mppd1 (net158 xpd vdda vdda) pmos1 l=180n w=1u m=1
	mps11 (net31 net158 vdda vdda) pmos1 l=180n w=1u m=1
	mpd11 (net56 inn net31 net31) pmos1 l=1.7e-07n w=8.4e-07u m=1
	mp001 (out net158 vdda vdda) pmos1 l=180n w=1u m=1
	mpd12 (net13 inp net31 net31) pmos1 l=2.9e-07n w=1.1e-06u m=1
	mpb01 (net158 net158 vdda vdda) pmos1 l=180n w=1u m=1
ends OPAMP1_variant319

subckt OPAMP1_variant320 inn inp out pd xpd vdda vssa
	xd1 (vssa vdda) prim_nwd AREA=6.13907e-9 PJ=476.6e-6 m=1
	xi0 (vssa net69) prim_nd AREA=9.2e-09 PJ=7.8e-05 m=1
	xi3 (net51 vdda) prim_pd AREA=790e-15 PJ=3.3e-6 m=1
	xr0 (vssa vdda net51) prim_rdiffp l=2.1e-6 w=700e-9 m=1
	xr1 (vdda vdda net69) prim_rdiffp l=2.1e-6 w=700e-9 m=1
	xcc01 (net12 out) prim_cpoly c=1p m=1
	mnm12 (net13 net56 vssa vssa) nmos1 l=180n w=1u m=1
	mnm11 (net56 net56 vssa vssa) nmos1 l=180n w=1u m=1
	mnb02 (net27 net27 net21 vssa) nmos1 l=1.6e-07n w=8.0e-07u m=1
	mnpd1 (net21 xpd vssa vssa) nmos1 l=180n w=1u m=1
	mn001 (out net13 vssa vssa) nmos1 l=180n w=1u m=1
	mnpd2 (net13 pd vssa vssa) nmos1 l=2.2e-07n w=1.9e-06u m=1
	mnc01 (net13 net69 net12 vssa) nmos1 l=180n w=1u m=1
	mpb02 (net27 net51 net158 vdda) pmos1 l=1.4e-07n w=1.3e-06u m=1
	mppd1 (net158 xpd vdda vdda) pmos1 l=180n w=1u m=1
	mps11 (net31 net158 vdda vdda) pmos1 l=180n w=1u m=1
	mpd11 (net56 inn net31 net31) pmos1 l=180n w=1u m=1
	mp001 (out net158 vdda vdda) pmos1 l=180n w=1u m=1
	mpd12 (net13 inp net31 net31) pmos1 l=180n w=1u m=1
	mpb01 (net158 net158 vdda vdda) pmos1 l=180n w=1u m=1
ends OPAMP1_variant320

subckt OPAMP1_variant321 inn inp out pd xpd vdda vssa
	xd1 (vssa vdda) prim_nwd AREA=6.13907e-9 PJ=476.6e-6 m=1
	xi0 (vssa net69) prim_nd AREA=1e-12 PJ=4e-6 m=1
	xi3 (net51 vdda) prim_pd AREA=790e-15 PJ=3.3e-6 m=1
	xr0 (vssa vdda net51) prim_rdiffp l=2.1e-6 w=700e-9 m=1
	xr1 (vdda vdda net69) prim_rdiffp l=2.1e-6 w=700e-9 m=1
	xcc01 (net12 out) prim_cpoly c=1p m=1
	mnm12 (net13 net56 vssa vssa) nmos1 l=2.5e-07n w=1.4e-06u m=1
	mnm11 (net56 net56 vssa vssa) nmos1 l=180n w=1u m=1
	mnb02 (net27 net27 net21 vssa) nmos1 l=1.8e-07n w=5.2e-07u m=1
	mnpd1 (net21 xpd vssa vssa) nmos1 l=180n w=1u m=1
	mn001 (out net13 vssa vssa) nmos1 l=180n w=1u m=1
	mnpd2 (net13 pd vssa vssa) nmos1 l=180n w=1u m=1
	mnc01 (net13 net69 net12 vssa) nmos1 l=180n w=1u m=1
	mpb02 (net27 net51 net158 vdda) pmos1 l=180n w=1u m=1
	mppd1 (net158 xpd vdda vdda) pmos1 l=180n w=1u m=1
	mps11 (net31 net158 vdda vdda) pmos1 l=180n w=1u m=1
	mpd11 (net56 inn net31 net31) pmos1 l=180n w=1u m=1
	mp001 (out net158 vdda vdda) pmos1 l=1.2e-07n w=1.4e-06u m=1
	mpd12 (net13 inp net31 net31) pmos1 l=180n w=1u m=1
	mpb01 (net158 net158 vdda vdda) pmos1 l=180n w=1u m=1
ends OPAMP1_variant321

subckt OPAMP1_variant322 inn inp out pd xpd vdda vssa
	xd1 (vssa vdda) prim_nwd AREA=8.2e-09 PJ=2.7e-05 m=1
	xi0 (vssa net69) prim_nd AREA=1e-12 PJ=4e-6 m=1
	xi3 (net51 vdda) prim_pd AREA=790e-15 PJ=3.3e-6 m=1
	xr0 (vssa vdda net51) prim_rdiffp l=2.1e-6 w=700e-9 m=1
	xr1 (vdda vdda net69) prim_rdiffp l=2.9e-07 w=8.2e-07 m=1
	xcc01 (net12 out) prim_cpoly c=1p m=1
	mnm12 (net13 net56 vssa vssa) nmos1 l=180n w=1u m=1
	mnm11 (net56 net56 vssa vssa) nmos1 l=180n w=1u m=1
	mnb02 (net27 net27 net21 vssa) nmos1 l=180n w=1u m=1
	mnpd1 (net21 xpd vssa vssa) nmos1 l=180n w=1u m=1
	mn001 (out net13 vssa vssa) nmos1 l=180n w=1u m=1
	mnpd2 (net13 pd vssa vssa) nmos1 l=180n w=1u m=1
	mnc01 (net13 net69 net12 vssa) nmos1 l=180n w=1u m=1
	mpb02 (net27 net51 net158 vdda) pmos1 l=180n w=1u m=1
	mppd1 (net158 xpd vdda vdda) pmos1 l=180n w=1u m=1
	mps11 (net31 net158 vdda vdda) pmos1 l=180n w=1u m=1
	mpd11 (net56 inn net31 net31) pmos1 l=180n w=1u m=1
	mp001 (out net158 vdda vdda) pmos1 l=180n w=1u m=1
	mpd12 (net13 inp net31 net31) pmos1 l=180n w=1u m=1
	mpb01 (net158 net158 vdda vdda) pmos1 l=180n w=1u m=1
ends OPAMP1_variant322

subckt OPAMP1_variant323 inn inp out pd xpd vdda vssa
	xd1 (vssa vdda) prim_nwd AREA=9.3e-09 PJ=9.2e-05 m=1
	xi0 (vssa net69) prim_nd AREA=9.5e-09 PJ=4.6e-05 m=1
	xi3 (net51 vdda) prim_pd AREA=790e-15 PJ=3.3e-6 m=1
	xr0 (vssa vdda net51) prim_rdiffp l=2.1e-6 w=700e-9 m=1
	xr1 (vdda vdda net69) prim_rdiffp l=2.1e-6 w=700e-9 m=1
	xcc01 (net12 out) prim_cpoly c=1p m=1
	mnm12 (net13 net56 vssa vssa) nmos1 l=180n w=1u m=1
	mnm11 (net56 net56 vssa vssa) nmos1 l=180n w=1u m=1
	mnb02 (net27 net27 net21 vssa) nmos1 l=180n w=1u m=1
	mnpd1 (net21 xpd vssa vssa) nmos1 l=2.1e-07n w=1.4e-06u m=1
	mn001 (out net13 vssa vssa) nmos1 l=180n w=1u m=1
	mnpd2 (net13 pd vssa vssa) nmos1 l=180n w=1u m=1
	mnc01 (net13 net69 net12 vssa) nmos1 l=180n w=1u m=1
	mpb02 (net27 net51 net158 vdda) pmos1 l=2.7e-07n w=1.4e-06u m=1
	mppd1 (net158 xpd vdda vdda) pmos1 l=180n w=1u m=1
	mps11 (net31 net158 vdda vdda) pmos1 l=180n w=1u m=1
	mpd11 (net56 inn net31 net31) pmos1 l=180n w=1u m=1
	mp001 (out net158 vdda vdda) pmos1 l=180n w=1u m=1
	mpd12 (net13 inp net31 net31) pmos1 l=180n w=1u m=1
	mpb01 (net158 net158 vdda vdda) pmos1 l=180n w=1u m=1
ends OPAMP1_variant323

subckt OPAMP1_variant324 inn inp out pd xpd vdda vssa
	xd1 (vssa vdda) prim_nwd AREA=6.13907e-9 PJ=476.6e-6 m=1
	xi0 (vssa net69) prim_nd AREA=1e-12 PJ=4e-6 m=1
	xi3 (net51 vdda) prim_pd AREA=790e-15 PJ=3.3e-6 m=1
	xr0 (vssa vdda net51) prim_rdiffp l=2.1e-6 w=700e-9 m=1
	xr1 (vdda vdda net69) prim_rdiffp l=2.1e-6 w=700e-9 m=1
	xcc01 (net12 out) prim_cpoly c=5.8e-13p m=1
	mnm12 (net13 net56 vssa vssa) nmos1 l=1.5e-07n w=7.1e-07u m=1
	mnm11 (net56 net56 vssa vssa) nmos1 l=180n w=1u m=1
	mnb02 (net27 net27 net21 vssa) nmos1 l=180n w=1u m=1
	mnpd1 (net21 xpd vssa vssa) nmos1 l=1.2e-07n w=5.1e-07u m=1
	mn001 (out net13 vssa vssa) nmos1 l=180n w=1u m=1
	mnpd2 (net13 pd vssa vssa) nmos1 l=180n w=1u m=1
	mnc01 (net13 net69 net12 vssa) nmos1 l=180n w=1u m=1
	mpb02 (net27 net51 net158 vdda) pmos1 l=180n w=1u m=1
	mppd1 (net158 xpd vdda vdda) pmos1 l=1.3e-07n w=6.4e-07u m=1
	mps11 (net31 net158 vdda vdda) pmos1 l=180n w=1u m=1
	mpd11 (net56 inn net31 net31) pmos1 l=180n w=1u m=1
	mp001 (out net158 vdda vdda) pmos1 l=180n w=1u m=1
	mpd12 (net13 inp net31 net31) pmos1 l=180n w=1u m=1
	mpb01 (net158 net158 vdda vdda) pmos1 l=180n w=1u m=1
ends OPAMP1_variant324

subckt OPAMP1_variant325 inn inp out pd xpd vdda vssa
	xd1 (vssa vdda) prim_nwd AREA=6.13907e-9 PJ=476.6e-6 m=1
	xi0 (vssa net69) prim_nd AREA=1e-12 PJ=4e-6 m=1
	xi3 (net51 vdda) prim_pd AREA=5.7e-09 PJ=2.5e-05 m=1
	xr0 (vssa vdda net51) prim_rdiffp l=2.8e-07 w=1.1e-06 m=1
	xr1 (vdda vdda net69) prim_rdiffp l=2.4e-07 w=1.0e-06 m=1
	xcc01 (net12 out) prim_cpoly c=1.6e-12p m=1
	mnm12 (net13 net56 vssa vssa) nmos1 l=180n w=1u m=1
	mnm11 (net56 net56 vssa vssa) nmos1 l=180n w=1u m=1
	mnb02 (net27 net27 net21 vssa) nmos1 l=180n w=1u m=1
	mnpd1 (net21 xpd vssa vssa) nmos1 l=180n w=1u m=1
	mn001 (out net13 vssa vssa) nmos1 l=2.3e-07n w=1.2e-06u m=1
	mnpd2 (net13 pd vssa vssa) nmos1 l=180n w=1u m=1
	mnc01 (net13 net69 net12 vssa) nmos1 l=180n w=1u m=1
	mpb02 (net27 net51 net158 vdda) pmos1 l=180n w=1u m=1
	mppd1 (net158 xpd vdda vdda) pmos1 l=180n w=1u m=1
	mps11 (net31 net158 vdda vdda) pmos1 l=180n w=1u m=1
	mpd11 (net56 inn net31 net31) pmos1 l=180n w=1u m=1
	mp001 (out net158 vdda vdda) pmos1 l=180n w=1u m=1
	mpd12 (net13 inp net31 net31) pmos1 l=180n w=1u m=1
	mpb01 (net158 net158 vdda vdda) pmos1 l=180n w=1u m=1
ends OPAMP1_variant325

subckt OPAMP1_variant326 inn inp out pd xpd vdda vssa
	xd1 (vssa vdda) prim_nwd AREA=6.5e-09 PJ=2.2e-05 m=1
	xi0 (vssa net69) prim_nd AREA=1e-12 PJ=4e-6 m=1
	xi3 (net51 vdda) prim_pd AREA=3.3e-10 PJ=1.3e-05 m=1
	xr0 (vssa vdda net51) prim_rdiffp l=2.8e-07 w=1.3e-06 m=1
	xr1 (vdda vdda net69) prim_rdiffp l=2.1e-6 w=700e-9 m=1
	xcc01 (net12 out) prim_cpoly c=1p m=1
	mnm12 (net13 net56 vssa vssa) nmos1 l=180n w=1u m=1
	mnm11 (net56 net56 vssa vssa) nmos1 l=180n w=1u m=1
	mnb02 (net27 net27 net21 vssa) nmos1 l=180n w=1u m=1
	mnpd1 (net21 xpd vssa vssa) nmos1 l=180n w=1u m=1
	mn001 (out net13 vssa vssa) nmos1 l=180n w=1u m=1
	mnpd2 (net13 pd vssa vssa) nmos1 l=180n w=1u m=1
	mnc01 (net13 net69 net12 vssa) nmos1 l=180n w=1u m=1
	mpb02 (net27 net51 net158 vdda) pmos1 l=180n w=1u m=1
	mppd1 (net158 xpd vdda vdda) pmos1 l=180n w=1u m=1
	mps11 (net31 net158 vdda vdda) pmos1 l=180n w=1u m=1
	mpd11 (net56 inn net31 net31) pmos1 l=180n w=1u m=1
	mp001 (out net158 vdda vdda) pmos1 l=180n w=1u m=1
	mpd12 (net13 inp net31 net31) pmos1 l=180n w=1u m=1
	mpb01 (net158 net158 vdda vdda) pmos1 l=180n w=1u m=1
ends OPAMP1_variant326

subckt OPAMP1_variant327 inn inp out pd xpd vdda vssa
	xd1 (vssa vdda) prim_nwd AREA=6.13907e-9 PJ=476.6e-6 m=1
	xi0 (vssa net69) prim_nd AREA=1e-12 PJ=4e-6 m=1
	xi3 (net51 vdda) prim_pd AREA=790e-15 PJ=3.3e-6 m=1
	xr0 (vssa vdda net51) prim_rdiffp l=1.8e-07 w=1.2e-06 m=1
	xr1 (vdda vdda net69) prim_rdiffp l=2.1e-6 w=700e-9 m=1
	xcc01 (net12 out) prim_cpoly c=1p m=1
	mnm12 (net13 net56 vssa vssa) nmos1 l=180n w=1u m=1
	mnm11 (net56 net56 vssa vssa) nmos1 l=180n w=1u m=1
	mnb02 (net27 net27 net21 vssa) nmos1 l=180n w=1u m=1
	mnpd1 (net21 xpd vssa vssa) nmos1 l=180n w=1u m=1
	mn001 (out net13 vssa vssa) nmos1 l=180n w=1u m=1
	mnpd2 (net13 pd vssa vssa) nmos1 l=180n w=1u m=1
	mnc01 (net13 net69 net12 vssa) nmos1 l=180n w=1u m=1
	mpb02 (net27 net51 net158 vdda) pmos1 l=180n w=1u m=1
	mppd1 (net158 xpd vdda vdda) pmos1 l=180n w=1u m=1
	mps11 (net31 net158 vdda vdda) pmos1 l=2.5e-07n w=8.7e-07u m=1
	mpd11 (net56 inn net31 net31) pmos1 l=180n w=1u m=1
	mp001 (out net158 vdda vdda) pmos1 l=180n w=1u m=1
	mpd12 (net13 inp net31 net31) pmos1 l=180n w=1u m=1
	mpb01 (net158 net158 vdda vdda) pmos1 l=180n w=1u m=1
ends OPAMP1_variant327

subckt OPAMP1_variant328 inn inp out pd xpd vdda vssa
	xd1 (vssa vdda) prim_nwd AREA=6.13907e-9 PJ=476.6e-6 m=1
	xi0 (vssa net69) prim_nd AREA=1e-12 PJ=4e-6 m=1
	xi3 (net51 vdda) prim_pd AREA=790e-15 PJ=3.3e-6 m=1
	xr0 (vssa vdda net51) prim_rdiffp l=2.1e-6 w=700e-9 m=1
	xr1 (vdda vdda net69) prim_rdiffp l=2.1e-6 w=700e-9 m=1
	xcc01 (net12 out) prim_cpoly c=1p m=1
	mnm12 (net13 net56 vssa vssa) nmos1 l=1.5e-07n w=5.1e-07u m=1
	mnm11 (net56 net56 vssa vssa) nmos1 l=1.6e-07n w=1.6e-06u m=1
	mnb02 (net27 net27 net21 vssa) nmos1 l=180n w=1u m=1
	mnpd1 (net21 xpd vssa vssa) nmos1 l=180n w=1u m=1
	mn001 (out net13 vssa vssa) nmos1 l=180n w=1u m=1
	mnpd2 (net13 pd vssa vssa) nmos1 l=180n w=1u m=1
	mnc01 (net13 net69 net12 vssa) nmos1 l=180n w=1u m=1
	mpb02 (net27 net51 net158 vdda) pmos1 l=180n w=1u m=1
	mppd1 (net158 xpd vdda vdda) pmos1 l=180n w=1u m=1
	mps11 (net31 net158 vdda vdda) pmos1 l=180n w=1u m=1
	mpd11 (net56 inn net31 net31) pmos1 l=2.2e-07n w=1.0e-06u m=1
	mp001 (out net158 vdda vdda) pmos1 l=180n w=1u m=1
	mpd12 (net13 inp net31 net31) pmos1 l=180n w=1u m=1
	mpb01 (net158 net158 vdda vdda) pmos1 l=180n w=1u m=1
ends OPAMP1_variant328

subckt OPAMP1_variant329 inn inp out pd xpd vdda vssa
	xd1 (vssa vdda) prim_nwd AREA=6.13907e-9 PJ=476.6e-6 m=1
	xi0 (vssa net69) prim_nd AREA=1.0e-10 PJ=4.9e-05 m=1
	xi3 (net51 vdda) prim_pd AREA=7.1e-09 PJ=1.4e-05 m=1
	xr0 (vssa vdda net51) prim_rdiffp l=2.1e-6 w=700e-9 m=1
	xr1 (vdda vdda net69) prim_rdiffp l=2.1e-6 w=700e-9 m=1
	xcc01 (net12 out) prim_cpoly c=1p m=1
	mnm12 (net13 net56 vssa vssa) nmos1 l=2.5e-07n w=6.7e-07u m=1
	mnm11 (net56 net56 vssa vssa) nmos1 l=180n w=1u m=1
	mnb02 (net27 net27 net21 vssa) nmos1 l=180n w=1u m=1
	mnpd1 (net21 xpd vssa vssa) nmos1 l=180n w=1u m=1
	mn001 (out net13 vssa vssa) nmos1 l=180n w=1u m=1
	mnpd2 (net13 pd vssa vssa) nmos1 l=180n w=1u m=1
	mnc01 (net13 net69 net12 vssa) nmos1 l=180n w=1u m=1
	mpb02 (net27 net51 net158 vdda) pmos1 l=180n w=1u m=1
	mppd1 (net158 xpd vdda vdda) pmos1 l=180n w=1u m=1
	mps11 (net31 net158 vdda vdda) pmos1 l=180n w=1u m=1
	mpd11 (net56 inn net31 net31) pmos1 l=1.7e-07n w=7.0e-07u m=1
	mp001 (out net158 vdda vdda) pmos1 l=180n w=1u m=1
	mpd12 (net13 inp net31 net31) pmos1 l=180n w=1u m=1
	mpb01 (net158 net158 vdda vdda) pmos1 l=180n w=1u m=1
ends OPAMP1_variant329

subckt OPAMP1_variant330 inn inp out pd xpd vdda vssa
	xd1 (vssa vdda) prim_nwd AREA=6.13907e-9 PJ=476.6e-6 m=1
	xi0 (vssa net69) prim_nd AREA=1e-12 PJ=4e-6 m=1
	xi3 (net51 vdda) prim_pd AREA=790e-15 PJ=3.3e-6 m=1
	xr0 (vssa vdda net51) prim_rdiffp l=2.1e-6 w=700e-9 m=1
	xr1 (vdda vdda net69) prim_rdiffp l=2.1e-6 w=700e-9 m=1
	xcc01 (net12 out) prim_cpoly c=1p m=1
	mnm12 (net13 net56 vssa vssa) nmos1 l=2.7e-07n w=1.9e-06u m=1
	mnm11 (net56 net56 vssa vssa) nmos1 l=180n w=1u m=1
	mnb02 (net27 net27 net21 vssa) nmos1 l=2.7e-07n w=1.4e-06u m=1
	mnpd1 (net21 xpd vssa vssa) nmos1 l=180n w=1u m=1
	mn001 (out net13 vssa vssa) nmos1 l=180n w=1u m=1
	mnpd2 (net13 pd vssa vssa) nmos1 l=180n w=1u m=1
	mnc01 (net13 net69 net12 vssa) nmos1 l=180n w=1u m=1
	mpb02 (net27 net51 net158 vdda) pmos1 l=180n w=1u m=1
	mppd1 (net158 xpd vdda vdda) pmos1 l=180n w=1u m=1
	mps11 (net31 net158 vdda vdda) pmos1 l=180n w=1u m=1
	mpd11 (net56 inn net31 net31) pmos1 l=180n w=1u m=1
	mp001 (out net158 vdda vdda) pmos1 l=2.4e-07n w=1.1e-06u m=1
	mpd12 (net13 inp net31 net31) pmos1 l=180n w=1u m=1
	mpb01 (net158 net158 vdda vdda) pmos1 l=180n w=1u m=1
ends OPAMP1_variant330

subckt OPAMP1_variant331 inn inp out pd xpd vdda vssa
	xd1 (vssa vdda) prim_nwd AREA=6.13907e-9 PJ=476.6e-6 m=1
	xi0 (vssa net69) prim_nd AREA=1e-12 PJ=4e-6 m=1
	xi3 (net51 vdda) prim_pd AREA=790e-15 PJ=3.3e-6 m=1
	xr0 (vssa vdda net51) prim_rdiffp l=2.1e-6 w=700e-9 m=1
	xr1 (vdda vdda net69) prim_rdiffp l=2.1e-6 w=700e-9 m=1
	xcc01 (net12 out) prim_cpoly c=1p m=1
	mnm12 (net13 net56 vssa vssa) nmos1 l=180n w=1u m=1
	mnm11 (net56 net56 vssa vssa) nmos1 l=180n w=1u m=1
	mnb02 (net27 net27 net21 vssa) nmos1 l=2.0e-07n w=1.8e-06u m=1
	mnpd1 (net21 xpd vssa vssa) nmos1 l=180n w=1u m=1
	mn001 (out net13 vssa vssa) nmos1 l=1.5e-07n w=5.3e-07u m=1
	mnpd2 (net13 pd vssa vssa) nmos1 l=180n w=1u m=1
	mnc01 (net13 net69 net12 vssa) nmos1 l=180n w=1u m=1
	mpb02 (net27 net51 net158 vdda) pmos1 l=180n w=1u m=1
	mppd1 (net158 xpd vdda vdda) pmos1 l=180n w=1u m=1
	mps11 (net31 net158 vdda vdda) pmos1 l=180n w=1u m=1
	mpd11 (net56 inn net31 net31) pmos1 l=180n w=1u m=1
	mp001 (out net158 vdda vdda) pmos1 l=1.3e-07n w=1.1e-06u m=1
	mpd12 (net13 inp net31 net31) pmos1 l=180n w=1u m=1
	mpb01 (net158 net158 vdda vdda) pmos1 l=180n w=1u m=1
ends OPAMP1_variant331

subckt OPAMP1_variant332 inn inp out pd xpd vdda vssa
	xd1 (vssa vdda) prim_nwd AREA=6.13907e-9 PJ=476.6e-6 m=1
	xi0 (vssa net69) prim_nd AREA=1e-12 PJ=4e-6 m=1
	xi3 (net51 vdda) prim_pd AREA=1.8e-09 PJ=9.6e-05 m=1
	xr0 (vssa vdda net51) prim_rdiffp l=2.1e-07 w=8.0e-07 m=1
	xr1 (vdda vdda net69) prim_rdiffp l=2.1e-6 w=700e-9 m=1
	xcc01 (net12 out) prim_cpoly c=1p m=1
	mnm12 (net13 net56 vssa vssa) nmos1 l=180n w=1u m=1
	mnm11 (net56 net56 vssa vssa) nmos1 l=180n w=1u m=1
	mnb02 (net27 net27 net21 vssa) nmos1 l=180n w=1u m=1
	mnpd1 (net21 xpd vssa vssa) nmos1 l=180n w=1u m=1
	mn001 (out net13 vssa vssa) nmos1 l=180n w=1u m=1
	mnpd2 (net13 pd vssa vssa) nmos1 l=180n w=1u m=1
	mnc01 (net13 net69 net12 vssa) nmos1 l=180n w=1u m=1
	mpb02 (net27 net51 net158 vdda) pmos1 l=180n w=1u m=1
	mppd1 (net158 xpd vdda vdda) pmos1 l=180n w=1u m=1
	mps11 (net31 net158 vdda vdda) pmos1 l=1.3e-07n w=1.2e-06u m=1
	mpd11 (net56 inn net31 net31) pmos1 l=180n w=1u m=1
	mp001 (out net158 vdda vdda) pmos1 l=180n w=1u m=1
	mpd12 (net13 inp net31 net31) pmos1 l=180n w=1u m=1
	mpb01 (net158 net158 vdda vdda) pmos1 l=180n w=1u m=1
ends OPAMP1_variant332

subckt OPAMP1_variant333 inn inp out pd xpd vdda vssa
	xd1 (vssa vdda) prim_nwd AREA=6.13907e-9 PJ=476.6e-6 m=1
	xi0 (vssa net69) prim_nd AREA=1e-12 PJ=4e-6 m=1
	xi3 (net51 vdda) prim_pd AREA=790e-15 PJ=3.3e-6 m=1
	xr0 (vssa vdda net51) prim_rdiffp l=1.5e-07 w=1.4e-06 m=1
	xr1 (vdda vdda net69) prim_rdiffp l=2.1e-6 w=700e-9 m=1
	xcc01 (net12 out) prim_cpoly c=1p m=1
	mnm12 (net13 net56 vssa vssa) nmos1 l=180n w=1u m=1
	mnm11 (net56 net56 vssa vssa) nmos1 l=180n w=1u m=1
	mnb02 (net27 net27 net21 vssa) nmos1 l=180n w=1u m=1
	mnpd1 (net21 xpd vssa vssa) nmos1 l=180n w=1u m=1
	mn001 (out net13 vssa vssa) nmos1 l=180n w=1u m=1
	mnpd2 (net13 pd vssa vssa) nmos1 l=180n w=1u m=1
	mnc01 (net13 net69 net12 vssa) nmos1 l=180n w=1u m=1
	mpb02 (net27 net51 net158 vdda) pmos1 l=180n w=1u m=1
	mppd1 (net158 xpd vdda vdda) pmos1 l=180n w=1u m=1
	mps11 (net31 net158 vdda vdda) pmos1 l=180n w=1u m=1
	mpd11 (net56 inn net31 net31) pmos1 l=2.3e-07n w=8.3e-07u m=1
	mp001 (out net158 vdda vdda) pmos1 l=1.7e-07n w=9.8e-07u m=1
	mpd12 (net13 inp net31 net31) pmos1 l=180n w=1u m=1
	mpb01 (net158 net158 vdda vdda) pmos1 l=180n w=1u m=1
ends OPAMP1_variant333

subckt OPAMP1_variant334 inn inp out pd xpd vdda vssa
	xd1 (vssa vdda) prim_nwd AREA=6.13907e-9 PJ=476.6e-6 m=1
	xi0 (vssa net69) prim_nd AREA=1e-12 PJ=4e-6 m=1
	xi3 (net51 vdda) prim_pd AREA=2.3e-09 PJ=2.1e-05 m=1
	xr0 (vssa vdda net51) prim_rdiffp l=2.1e-6 w=700e-9 m=1
	xr1 (vdda vdda net69) prim_rdiffp l=2.1e-6 w=700e-9 m=1
	xcc01 (net12 out) prim_cpoly c=1p m=1
	mnm12 (net13 net56 vssa vssa) nmos1 l=180n w=1u m=1
	mnm11 (net56 net56 vssa vssa) nmos1 l=180n w=1u m=1
	mnb02 (net27 net27 net21 vssa) nmos1 l=2.6e-07n w=9.0e-07u m=1
	mnpd1 (net21 xpd vssa vssa) nmos1 l=180n w=1u m=1
	mn001 (out net13 vssa vssa) nmos1 l=180n w=1u m=1
	mnpd2 (net13 pd vssa vssa) nmos1 l=180n w=1u m=1
	mnc01 (net13 net69 net12 vssa) nmos1 l=180n w=1u m=1
	mpb02 (net27 net51 net158 vdda) pmos1 l=180n w=1u m=1
	mppd1 (net158 xpd vdda vdda) pmos1 l=180n w=1u m=1
	mps11 (net31 net158 vdda vdda) pmos1 l=180n w=1u m=1
	mpd11 (net56 inn net31 net31) pmos1 l=2.7e-07n w=9.6e-07u m=1
	mp001 (out net158 vdda vdda) pmos1 l=180n w=1u m=1
	mpd12 (net13 inp net31 net31) pmos1 l=180n w=1u m=1
	mpb01 (net158 net158 vdda vdda) pmos1 l=180n w=1u m=1
ends OPAMP1_variant334

subckt OPAMP1_variant335 inn inp out pd xpd vdda vssa
	xd1 (vssa vdda) prim_nwd AREA=7.0e-09 PJ=6.5e-05 m=1
	xi0 (vssa net69) prim_nd AREA=1e-12 PJ=4e-6 m=1
	xi3 (net51 vdda) prim_pd AREA=790e-15 PJ=3.3e-6 m=1
	xr0 (vssa vdda net51) prim_rdiffp l=2.1e-6 w=700e-9 m=1
	xr1 (vdda vdda net69) prim_rdiffp l=2.3e-07 w=1.4e-06 m=1
	xcc01 (net12 out) prim_cpoly c=1p m=1
	mnm12 (net13 net56 vssa vssa) nmos1 l=2.2e-07n w=1.5e-06u m=1
	mnm11 (net56 net56 vssa vssa) nmos1 l=180n w=1u m=1
	mnb02 (net27 net27 net21 vssa) nmos1 l=180n w=1u m=1
	mnpd1 (net21 xpd vssa vssa) nmos1 l=180n w=1u m=1
	mn001 (out net13 vssa vssa) nmos1 l=180n w=1u m=1
	mnpd2 (net13 pd vssa vssa) nmos1 l=2.9e-07n w=9.3e-07u m=1
	mnc01 (net13 net69 net12 vssa) nmos1 l=180n w=1u m=1
	mpb02 (net27 net51 net158 vdda) pmos1 l=180n w=1u m=1
	mppd1 (net158 xpd vdda vdda) pmos1 l=180n w=1u m=1
	mps11 (net31 net158 vdda vdda) pmos1 l=180n w=1u m=1
	mpd11 (net56 inn net31 net31) pmos1 l=180n w=1u m=1
	mp001 (out net158 vdda vdda) pmos1 l=180n w=1u m=1
	mpd12 (net13 inp net31 net31) pmos1 l=1.9e-07n w=5.9e-07u m=1
	mpb01 (net158 net158 vdda vdda) pmos1 l=180n w=1u m=1
ends OPAMP1_variant335

subckt OPAMP1_variant336 inn inp out pd xpd vdda vssa
	xd1 (vssa vdda) prim_nwd AREA=6.13907e-9 PJ=476.6e-6 m=1
	xi0 (vssa net69) prim_nd AREA=1e-12 PJ=4e-6 m=1
	xi3 (net51 vdda) prim_pd AREA=790e-15 PJ=3.3e-6 m=1
	xr0 (vssa vdda net51) prim_rdiffp l=2.1e-6 w=700e-9 m=1
	xr1 (vdda vdda net69) prim_rdiffp l=2.1e-6 w=700e-9 m=1
	xcc01 (net12 out) prim_cpoly c=1.7e-12p m=1
	mnm12 (net13 net56 vssa vssa) nmos1 l=1.2e-07n w=7.9e-07u m=1
	mnm11 (net56 net56 vssa vssa) nmos1 l=180n w=1u m=1
	mnb02 (net27 net27 net21 vssa) nmos1 l=2.2e-07n w=8.5e-07u m=1
	mnpd1 (net21 xpd vssa vssa) nmos1 l=180n w=1u m=1
	mn001 (out net13 vssa vssa) nmos1 l=180n w=1u m=1
	mnpd2 (net13 pd vssa vssa) nmos1 l=180n w=1u m=1
	mnc01 (net13 net69 net12 vssa) nmos1 l=180n w=1u m=1
	mpb02 (net27 net51 net158 vdda) pmos1 l=180n w=1u m=1
	mppd1 (net158 xpd vdda vdda) pmos1 l=180n w=1u m=1
	mps11 (net31 net158 vdda vdda) pmos1 l=180n w=1u m=1
	mpd11 (net56 inn net31 net31) pmos1 l=180n w=1u m=1
	mp001 (out net158 vdda vdda) pmos1 l=180n w=1u m=1
	mpd12 (net13 inp net31 net31) pmos1 l=180n w=1u m=1
	mpb01 (net158 net158 vdda vdda) pmos1 l=180n w=1u m=1
ends OPAMP1_variant336

subckt OPAMP1_variant337 inn inp out pd xpd vdda vssa
	xd1 (vssa vdda) prim_nwd AREA=1.7e-09 PJ=2.4e-06 m=1
	xi0 (vssa net69) prim_nd AREA=1e-12 PJ=4e-6 m=1
	xi3 (net51 vdda) prim_pd AREA=790e-15 PJ=3.3e-6 m=1
	xr0 (vssa vdda net51) prim_rdiffp l=2.1e-6 w=700e-9 m=1
	xr1 (vdda vdda net69) prim_rdiffp l=2.1e-6 w=700e-9 m=1
	xcc01 (net12 out) prim_cpoly c=1p m=1
	mnm12 (net13 net56 vssa vssa) nmos1 l=180n w=1u m=1
	mnm11 (net56 net56 vssa vssa) nmos1 l=180n w=1u m=1
	mnb02 (net27 net27 net21 vssa) nmos1 l=180n w=1u m=1
	mnpd1 (net21 xpd vssa vssa) nmos1 l=180n w=1u m=1
	mn001 (out net13 vssa vssa) nmos1 l=180n w=1u m=1
	mnpd2 (net13 pd vssa vssa) nmos1 l=180n w=1u m=1
	mnc01 (net13 net69 net12 vssa) nmos1 l=180n w=1u m=1
	mpb02 (net27 net51 net158 vdda) pmos1 l=180n w=1u m=1
	mppd1 (net158 xpd vdda vdda) pmos1 l=180n w=1u m=1
	mps11 (net31 net158 vdda vdda) pmos1 l=180n w=1u m=1
	mpd11 (net56 inn net31 net31) pmos1 l=1.1e-07n w=1.4e-06u m=1
	mp001 (out net158 vdda vdda) pmos1 l=1.7e-07n w=6.1e-07u m=1
	mpd12 (net13 inp net31 net31) pmos1 l=2.0e-07n w=1.1e-06u m=1
	mpb01 (net158 net158 vdda vdda) pmos1 l=2.1e-07n w=2.0e-06u m=1
ends OPAMP1_variant337

subckt OPAMP1_variant338 inn inp out pd xpd vdda vssa
	xd1 (vssa vdda) prim_nwd AREA=6.13907e-9 PJ=476.6e-6 m=1
	xi0 (vssa net69) prim_nd AREA=1e-12 PJ=4e-6 m=1
	xi3 (net51 vdda) prim_pd AREA=790e-15 PJ=3.3e-6 m=1
	xr0 (vssa vdda net51) prim_rdiffp l=2.1e-6 w=700e-9 m=1
	xr1 (vdda vdda net69) prim_rdiffp l=2.1e-6 w=700e-9 m=1
	xcc01 (net12 out) prim_cpoly c=1p m=1
	mnm12 (net13 net56 vssa vssa) nmos1 l=180n w=1u m=1
	mnm11 (net56 net56 vssa vssa) nmos1 l=1.7e-07n w=1.3e-06u m=1
	mnb02 (net27 net27 net21 vssa) nmos1 l=2.3e-07n w=1.3e-06u m=1
	mnpd1 (net21 xpd vssa vssa) nmos1 l=180n w=1u m=1
	mn001 (out net13 vssa vssa) nmos1 l=180n w=1u m=1
	mnpd2 (net13 pd vssa vssa) nmos1 l=1.7e-07n w=1.3e-06u m=1
	mnc01 (net13 net69 net12 vssa) nmos1 l=180n w=1u m=1
	mpb02 (net27 net51 net158 vdda) pmos1 l=180n w=1u m=1
	mppd1 (net158 xpd vdda vdda) pmos1 l=180n w=1u m=1
	mps11 (net31 net158 vdda vdda) pmos1 l=180n w=1u m=1
	mpd11 (net56 inn net31 net31) pmos1 l=180n w=1u m=1
	mp001 (out net158 vdda vdda) pmos1 l=180n w=1u m=1
	mpd12 (net13 inp net31 net31) pmos1 l=180n w=1u m=1
	mpb01 (net158 net158 vdda vdda) pmos1 l=180n w=1u m=1
ends OPAMP1_variant338

subckt OPAMP1_variant339 inn inp out pd xpd vdda vssa
	xd1 (vssa vdda) prim_nwd AREA=6.13907e-9 PJ=476.6e-6 m=1
	xi0 (vssa net69) prim_nd AREA=1e-12 PJ=4e-6 m=1
	xi3 (net51 vdda) prim_pd AREA=3.4e-09 PJ=1.7e-05 m=1
	xr0 (vssa vdda net51) prim_rdiffp l=2.1e-6 w=700e-9 m=1
	xr1 (vdda vdda net69) prim_rdiffp l=2.1e-6 w=700e-9 m=1
	xcc01 (net12 out) prim_cpoly c=5.2e-13p m=1
	mnm12 (net13 net56 vssa vssa) nmos1 l=180n w=1u m=1
	mnm11 (net56 net56 vssa vssa) nmos1 l=180n w=1u m=1
	mnb02 (net27 net27 net21 vssa) nmos1 l=180n w=1u m=1
	mnpd1 (net21 xpd vssa vssa) nmos1 l=180n w=1u m=1
	mn001 (out net13 vssa vssa) nmos1 l=180n w=1u m=1
	mnpd2 (net13 pd vssa vssa) nmos1 l=180n w=1u m=1
	mnc01 (net13 net69 net12 vssa) nmos1 l=180n w=1u m=1
	mpb02 (net27 net51 net158 vdda) pmos1 l=180n w=1u m=1
	mppd1 (net158 xpd vdda vdda) pmos1 l=180n w=1u m=1
	mps11 (net31 net158 vdda vdda) pmos1 l=180n w=1u m=1
	mpd11 (net56 inn net31 net31) pmos1 l=180n w=1u m=1
	mp001 (out net158 vdda vdda) pmos1 l=180n w=1u m=1
	mpd12 (net13 inp net31 net31) pmos1 l=180n w=1u m=1
	mpb01 (net158 net158 vdda vdda) pmos1 l=180n w=1u m=1
ends OPAMP1_variant339

subckt OPAMP1_variant340 inn inp out pd xpd vdda vssa
	xd1 (vssa vdda) prim_nwd AREA=3.1e-09 PJ=1.7e-05 m=1
	xi0 (vssa net69) prim_nd AREA=1e-12 PJ=4e-6 m=1
	xi3 (net51 vdda) prim_pd AREA=790e-15 PJ=3.3e-6 m=1
	xr0 (vssa vdda net51) prim_rdiffp l=2.1e-6 w=700e-9 m=1
	xr1 (vdda vdda net69) prim_rdiffp l=2.1e-6 w=700e-9 m=1
	xcc01 (net12 out) prim_cpoly c=1.6e-12p m=1
	mnm12 (net13 net56 vssa vssa) nmos1 l=180n w=1u m=1
	mnm11 (net56 net56 vssa vssa) nmos1 l=180n w=1u m=1
	mnb02 (net27 net27 net21 vssa) nmos1 l=180n w=1u m=1
	mnpd1 (net21 xpd vssa vssa) nmos1 l=180n w=1u m=1
	mn001 (out net13 vssa vssa) nmos1 l=180n w=1u m=1
	mnpd2 (net13 pd vssa vssa) nmos1 l=180n w=1u m=1
	mnc01 (net13 net69 net12 vssa) nmos1 l=2.7e-07n w=1.9e-06u m=1
	mpb02 (net27 net51 net158 vdda) pmos1 l=180n w=1u m=1
	mppd1 (net158 xpd vdda vdda) pmos1 l=180n w=1u m=1
	mps11 (net31 net158 vdda vdda) pmos1 l=180n w=1u m=1
	mpd11 (net56 inn net31 net31) pmos1 l=180n w=1u m=1
	mp001 (out net158 vdda vdda) pmos1 l=2.1e-07n w=1.6e-06u m=1
	mpd12 (net13 inp net31 net31) pmos1 l=180n w=1u m=1
	mpb01 (net158 net158 vdda vdda) pmos1 l=1.3e-07n w=1.1e-06u m=1
ends OPAMP1_variant340

subckt OPAMP1_variant341 inn inp out pd xpd vdda vssa
	xd1 (vssa vdda) prim_nwd AREA=6.13907e-9 PJ=476.6e-6 m=1
	xi0 (vssa net69) prim_nd AREA=1e-12 PJ=4e-6 m=1
	xi3 (net51 vdda) prim_pd AREA=790e-15 PJ=3.3e-6 m=1
	xr0 (vssa vdda net51) prim_rdiffp l=2.1e-6 w=700e-9 m=1
	xr1 (vdda vdda net69) prim_rdiffp l=2.1e-6 w=700e-9 m=1
	xcc01 (net12 out) prim_cpoly c=1p m=1
	mnm12 (net13 net56 vssa vssa) nmos1 l=180n w=1u m=1
	mnm11 (net56 net56 vssa vssa) nmos1 l=2.3e-07n w=1.8e-06u m=1
	mnb02 (net27 net27 net21 vssa) nmos1 l=180n w=1u m=1
	mnpd1 (net21 xpd vssa vssa) nmos1 l=1.5e-07n w=1.7e-06u m=1
	mn001 (out net13 vssa vssa) nmos1 l=1.5e-07n w=6.8e-07u m=1
	mnpd2 (net13 pd vssa vssa) nmos1 l=2.6e-07n w=1.6e-06u m=1
	mnc01 (net13 net69 net12 vssa) nmos1 l=180n w=1u m=1
	mpb02 (net27 net51 net158 vdda) pmos1 l=180n w=1u m=1
	mppd1 (net158 xpd vdda vdda) pmos1 l=180n w=1u m=1
	mps11 (net31 net158 vdda vdda) pmos1 l=180n w=1u m=1
	mpd11 (net56 inn net31 net31) pmos1 l=180n w=1u m=1
	mp001 (out net158 vdda vdda) pmos1 l=180n w=1u m=1
	mpd12 (net13 inp net31 net31) pmos1 l=180n w=1u m=1
	mpb01 (net158 net158 vdda vdda) pmos1 l=180n w=1u m=1
ends OPAMP1_variant341

subckt OPAMP1_variant342 inn inp out pd xpd vdda vssa
	xd1 (vssa vdda) prim_nwd AREA=6.13907e-9 PJ=476.6e-6 m=1
	xi0 (vssa net69) prim_nd AREA=1e-12 PJ=4e-6 m=1
	xi3 (net51 vdda) prim_pd AREA=5.0e-09 PJ=6.3e-05 m=1
	xr0 (vssa vdda net51) prim_rdiffp l=2.1e-6 w=700e-9 m=1
	xr1 (vdda vdda net69) prim_rdiffp l=2.1e-6 w=700e-9 m=1
	xcc01 (net12 out) prim_cpoly c=1p m=1
	mnm12 (net13 net56 vssa vssa) nmos1 l=180n w=1u m=1
	mnm11 (net56 net56 vssa vssa) nmos1 l=180n w=1u m=1
	mnb02 (net27 net27 net21 vssa) nmos1 l=180n w=1u m=1
	mnpd1 (net21 xpd vssa vssa) nmos1 l=180n w=1u m=1
	mn001 (out net13 vssa vssa) nmos1 l=1.1e-07n w=1.0e-06u m=1
	mnpd2 (net13 pd vssa vssa) nmos1 l=180n w=1u m=1
	mnc01 (net13 net69 net12 vssa) nmos1 l=180n w=1u m=1
	mpb02 (net27 net51 net158 vdda) pmos1 l=180n w=1u m=1
	mppd1 (net158 xpd vdda vdda) pmos1 l=180n w=1u m=1
	mps11 (net31 net158 vdda vdda) pmos1 l=180n w=1u m=1
	mpd11 (net56 inn net31 net31) pmos1 l=180n w=1u m=1
	mp001 (out net158 vdda vdda) pmos1 l=180n w=1u m=1
	mpd12 (net13 inp net31 net31) pmos1 l=180n w=1u m=1
	mpb01 (net158 net158 vdda vdda) pmos1 l=2.6e-07n w=1.7e-06u m=1
ends OPAMP1_variant342

subckt OPAMP1_variant343 inn inp out pd xpd vdda vssa
	xd1 (vssa vdda) prim_nwd AREA=6.13907e-9 PJ=476.6e-6 m=1
	xi0 (vssa net69) prim_nd AREA=9.6e-09 PJ=7.0e-05 m=1
	xi3 (net51 vdda) prim_pd AREA=8.9e-09 PJ=2.0e-05 m=1
	xr0 (vssa vdda net51) prim_rdiffp l=2.6e-07 w=7.6e-07 m=1
	xr1 (vdda vdda net69) prim_rdiffp l=2.1e-6 w=700e-9 m=1
	xcc01 (net12 out) prim_cpoly c=1p m=1
	mnm12 (net13 net56 vssa vssa) nmos1 l=180n w=1u m=1
	mnm11 (net56 net56 vssa vssa) nmos1 l=180n w=1u m=1
	mnb02 (net27 net27 net21 vssa) nmos1 l=180n w=1u m=1
	mnpd1 (net21 xpd vssa vssa) nmos1 l=180n w=1u m=1
	mn001 (out net13 vssa vssa) nmos1 l=180n w=1u m=1
	mnpd2 (net13 pd vssa vssa) nmos1 l=180n w=1u m=1
	mnc01 (net13 net69 net12 vssa) nmos1 l=180n w=1u m=1
	mpb02 (net27 net51 net158 vdda) pmos1 l=2.9e-07n w=9.7e-07u m=1
	mppd1 (net158 xpd vdda vdda) pmos1 l=1.4e-07n w=8.2e-07u m=1
	mps11 (net31 net158 vdda vdda) pmos1 l=180n w=1u m=1
	mpd11 (net56 inn net31 net31) pmos1 l=180n w=1u m=1
	mp001 (out net158 vdda vdda) pmos1 l=180n w=1u m=1
	mpd12 (net13 inp net31 net31) pmos1 l=180n w=1u m=1
	mpb01 (net158 net158 vdda vdda) pmos1 l=180n w=1u m=1
ends OPAMP1_variant343

subckt OPAMP1_variant344 inn inp out pd xpd vdda vssa
	xd1 (vssa vdda) prim_nwd AREA=6.13907e-9 PJ=476.6e-6 m=1
	xi0 (vssa net69) prim_nd AREA=1e-12 PJ=4e-6 m=1
	xi3 (net51 vdda) prim_pd AREA=790e-15 PJ=3.3e-6 m=1
	xr0 (vssa vdda net51) prim_rdiffp l=2.1e-6 w=700e-9 m=1
	xr1 (vdda vdda net69) prim_rdiffp l=1.5e-07 w=5.2e-07 m=1
	xcc01 (net12 out) prim_cpoly c=1p m=1
	mnm12 (net13 net56 vssa vssa) nmos1 l=180n w=1u m=1
	mnm11 (net56 net56 vssa vssa) nmos1 l=180n w=1u m=1
	mnb02 (net27 net27 net21 vssa) nmos1 l=180n w=1u m=1
	mnpd1 (net21 xpd vssa vssa) nmos1 l=180n w=1u m=1
	mn001 (out net13 vssa vssa) nmos1 l=180n w=1u m=1
	mnpd2 (net13 pd vssa vssa) nmos1 l=2.6e-07n w=1.8e-06u m=1
	mnc01 (net13 net69 net12 vssa) nmos1 l=180n w=1u m=1
	mpb02 (net27 net51 net158 vdda) pmos1 l=1.3e-07n w=9.9e-07u m=1
	mppd1 (net158 xpd vdda vdda) pmos1 l=180n w=1u m=1
	mps11 (net31 net158 vdda vdda) pmos1 l=180n w=1u m=1
	mpd11 (net56 inn net31 net31) pmos1 l=180n w=1u m=1
	mp001 (out net158 vdda vdda) pmos1 l=2.1e-07n w=1.3e-06u m=1
	mpd12 (net13 inp net31 net31) pmos1 l=1.2e-07n w=7.9e-07u m=1
	mpb01 (net158 net158 vdda vdda) pmos1 l=180n w=1u m=1
ends OPAMP1_variant344

subckt OPAMP1_variant345 inn inp out pd xpd vdda vssa
	xd1 (vssa vdda) prim_nwd AREA=6.13907e-9 PJ=476.6e-6 m=1
	xi0 (vssa net69) prim_nd AREA=1e-12 PJ=4e-6 m=1
	xi3 (net51 vdda) prim_pd AREA=790e-15 PJ=3.3e-6 m=1
	xr0 (vssa vdda net51) prim_rdiffp l=2.1e-6 w=700e-9 m=1
	xr1 (vdda vdda net69) prim_rdiffp l=2.1e-6 w=700e-9 m=1
	xcc01 (net12 out) prim_cpoly c=1.3e-12p m=1
	mnm12 (net13 net56 vssa vssa) nmos1 l=180n w=1u m=1
	mnm11 (net56 net56 vssa vssa) nmos1 l=180n w=1u m=1
	mnb02 (net27 net27 net21 vssa) nmos1 l=180n w=1u m=1
	mnpd1 (net21 xpd vssa vssa) nmos1 l=180n w=1u m=1
	mn001 (out net13 vssa vssa) nmos1 l=180n w=1u m=1
	mnpd2 (net13 pd vssa vssa) nmos1 l=2.5e-07n w=1.5e-06u m=1
	mnc01 (net13 net69 net12 vssa) nmos1 l=180n w=1u m=1
	mpb02 (net27 net51 net158 vdda) pmos1 l=180n w=1u m=1
	mppd1 (net158 xpd vdda vdda) pmos1 l=180n w=1u m=1
	mps11 (net31 net158 vdda vdda) pmos1 l=180n w=1u m=1
	mpd11 (net56 inn net31 net31) pmos1 l=180n w=1u m=1
	mp001 (out net158 vdda vdda) pmos1 l=180n w=1u m=1
	mpd12 (net13 inp net31 net31) pmos1 l=180n w=1u m=1
	mpb01 (net158 net158 vdda vdda) pmos1 l=180n w=1u m=1
ends OPAMP1_variant345

subckt OPAMP1_variant346 inn inp out pd xpd vdda vssa
	xd1 (vssa vdda) prim_nwd AREA=6.13907e-9 PJ=476.6e-6 m=1
	xi0 (vssa net69) prim_nd AREA=1e-12 PJ=4e-6 m=1
	xi3 (net51 vdda) prim_pd AREA=790e-15 PJ=3.3e-6 m=1
	xr0 (vssa vdda net51) prim_rdiffp l=2.1e-6 w=700e-9 m=1
	xr1 (vdda vdda net69) prim_rdiffp l=2.6e-07 w=1.5e-06 m=1
	xcc01 (net12 out) prim_cpoly c=1p m=1
	mnm12 (net13 net56 vssa vssa) nmos1 l=180n w=1u m=1
	mnm11 (net56 net56 vssa vssa) nmos1 l=180n w=1u m=1
	mnb02 (net27 net27 net21 vssa) nmos1 l=180n w=1u m=1
	mnpd1 (net21 xpd vssa vssa) nmos1 l=2.5e-07n w=1.3e-06u m=1
	mn001 (out net13 vssa vssa) nmos1 l=180n w=1u m=1
	mnpd2 (net13 pd vssa vssa) nmos1 l=1.9e-07n w=1.9e-06u m=1
	mnc01 (net13 net69 net12 vssa) nmos1 l=180n w=1u m=1
	mpb02 (net27 net51 net158 vdda) pmos1 l=180n w=1u m=1
	mppd1 (net158 xpd vdda vdda) pmos1 l=180n w=1u m=1
	mps11 (net31 net158 vdda vdda) pmos1 l=180n w=1u m=1
	mpd11 (net56 inn net31 net31) pmos1 l=180n w=1u m=1
	mp001 (out net158 vdda vdda) pmos1 l=180n w=1u m=1
	mpd12 (net13 inp net31 net31) pmos1 l=2.5e-07n w=1.6e-06u m=1
	mpb01 (net158 net158 vdda vdda) pmos1 l=180n w=1u m=1
ends OPAMP1_variant346

subckt OPAMP1_variant347 inn inp out pd xpd vdda vssa
	xd1 (vssa vdda) prim_nwd AREA=6.13907e-9 PJ=476.6e-6 m=1
	xi0 (vssa net69) prim_nd AREA=1e-12 PJ=4e-6 m=1
	xi3 (net51 vdda) prim_pd AREA=4.4e-09 PJ=2.7e-05 m=1
	xr0 (vssa vdda net51) prim_rdiffp l=1.1e-07 w=1.7e-06 m=1
	xr1 (vdda vdda net69) prim_rdiffp l=2.1e-6 w=700e-9 m=1
	xcc01 (net12 out) prim_cpoly c=1.6e-12p m=1
	mnm12 (net13 net56 vssa vssa) nmos1 l=180n w=1u m=1
	mnm11 (net56 net56 vssa vssa) nmos1 l=180n w=1u m=1
	mnb02 (net27 net27 net21 vssa) nmos1 l=180n w=1u m=1
	mnpd1 (net21 xpd vssa vssa) nmos1 l=180n w=1u m=1
	mn001 (out net13 vssa vssa) nmos1 l=180n w=1u m=1
	mnpd2 (net13 pd vssa vssa) nmos1 l=180n w=1u m=1
	mnc01 (net13 net69 net12 vssa) nmos1 l=180n w=1u m=1
	mpb02 (net27 net51 net158 vdda) pmos1 l=180n w=1u m=1
	mppd1 (net158 xpd vdda vdda) pmos1 l=180n w=1u m=1
	mps11 (net31 net158 vdda vdda) pmos1 l=180n w=1u m=1
	mpd11 (net56 inn net31 net31) pmos1 l=1.1e-07n w=1.8e-06u m=1
	mp001 (out net158 vdda vdda) pmos1 l=180n w=1u m=1
	mpd12 (net13 inp net31 net31) pmos1 l=2.3e-07n w=8.9e-07u m=1
	mpb01 (net158 net158 vdda vdda) pmos1 l=180n w=1u m=1
ends OPAMP1_variant347

subckt OPAMP1_variant348 inn inp out pd xpd vdda vssa
	xd1 (vssa vdda) prim_nwd AREA=6.13907e-9 PJ=476.6e-6 m=1
	xi0 (vssa net69) prim_nd AREA=1e-12 PJ=4e-6 m=1
	xi3 (net51 vdda) prim_pd AREA=4.3e-09 PJ=6.1e-05 m=1
	xr0 (vssa vdda net51) prim_rdiffp l=2.1e-6 w=700e-9 m=1
	xr1 (vdda vdda net69) prim_rdiffp l=2.1e-6 w=700e-9 m=1
	xcc01 (net12 out) prim_cpoly c=1p m=1
	mnm12 (net13 net56 vssa vssa) nmos1 l=180n w=1u m=1
	mnm11 (net56 net56 vssa vssa) nmos1 l=180n w=1u m=1
	mnb02 (net27 net27 net21 vssa) nmos1 l=180n w=1u m=1
	mnpd1 (net21 xpd vssa vssa) nmos1 l=180n w=1u m=1
	mn001 (out net13 vssa vssa) nmos1 l=180n w=1u m=1
	mnpd2 (net13 pd vssa vssa) nmos1 l=1.0e-07n w=5.4e-07u m=1
	mnc01 (net13 net69 net12 vssa) nmos1 l=180n w=1u m=1
	mpb02 (net27 net51 net158 vdda) pmos1 l=180n w=1u m=1
	mppd1 (net158 xpd vdda vdda) pmos1 l=1.9e-07n w=1.7e-06u m=1
	mps11 (net31 net158 vdda vdda) pmos1 l=2.2e-07n w=9.0e-07u m=1
	mpd11 (net56 inn net31 net31) pmos1 l=2.7e-07n w=1.6e-06u m=1
	mp001 (out net158 vdda vdda) pmos1 l=180n w=1u m=1
	mpd12 (net13 inp net31 net31) pmos1 l=180n w=1u m=1
	mpb01 (net158 net158 vdda vdda) pmos1 l=180n w=1u m=1
ends OPAMP1_variant348

subckt OPAMP1_variant349 inn inp out pd xpd vdda vssa
	xd1 (vssa vdda) prim_nwd AREA=6.13907e-9 PJ=476.6e-6 m=1
	xi0 (vssa net69) prim_nd AREA=1e-12 PJ=4e-6 m=1
	xi3 (net51 vdda) prim_pd AREA=790e-15 PJ=3.3e-6 m=1
	xr0 (vssa vdda net51) prim_rdiffp l=2.1e-6 w=700e-9 m=1
	xr1 (vdda vdda net69) prim_rdiffp l=2.1e-6 w=700e-9 m=1
	xcc01 (net12 out) prim_cpoly c=1.3e-12p m=1
	mnm12 (net13 net56 vssa vssa) nmos1 l=180n w=1u m=1
	mnm11 (net56 net56 vssa vssa) nmos1 l=180n w=1u m=1
	mnb02 (net27 net27 net21 vssa) nmos1 l=180n w=1u m=1
	mnpd1 (net21 xpd vssa vssa) nmos1 l=180n w=1u m=1
	mn001 (out net13 vssa vssa) nmos1 l=180n w=1u m=1
	mnpd2 (net13 pd vssa vssa) nmos1 l=180n w=1u m=1
	mnc01 (net13 net69 net12 vssa) nmos1 l=2.6e-07n w=1.8e-06u m=1
	mpb02 (net27 net51 net158 vdda) pmos1 l=180n w=1u m=1
	mppd1 (net158 xpd vdda vdda) pmos1 l=180n w=1u m=1
	mps11 (net31 net158 vdda vdda) pmos1 l=180n w=1u m=1
	mpd11 (net56 inn net31 net31) pmos1 l=180n w=1u m=1
	mp001 (out net158 vdda vdda) pmos1 l=180n w=1u m=1
	mpd12 (net13 inp net31 net31) pmos1 l=2.2e-07n w=5.6e-07u m=1
	mpb01 (net158 net158 vdda vdda) pmos1 l=3.0e-07n w=8.7e-07u m=1
ends OPAMP1_variant349

subckt OPAMP1_variant350 inn inp out pd xpd vdda vssa
	xd1 (vssa vdda) prim_nwd AREA=6.13907e-9 PJ=476.6e-6 m=1
	xi0 (vssa net69) prim_nd AREA=1e-12 PJ=4e-6 m=1
	xi3 (net51 vdda) prim_pd AREA=790e-15 PJ=3.3e-6 m=1
	xr0 (vssa vdda net51) prim_rdiffp l=2.1e-6 w=700e-9 m=1
	xr1 (vdda vdda net69) prim_rdiffp l=2.1e-6 w=700e-9 m=1
	xcc01 (net12 out) prim_cpoly c=1.1e-12p m=1
	mnm12 (net13 net56 vssa vssa) nmos1 l=180n w=1u m=1
	mnm11 (net56 net56 vssa vssa) nmos1 l=180n w=1u m=1
	mnb02 (net27 net27 net21 vssa) nmos1 l=180n w=1u m=1
	mnpd1 (net21 xpd vssa vssa) nmos1 l=2.4e-07n w=1.9e-06u m=1
	mn001 (out net13 vssa vssa) nmos1 l=180n w=1u m=1
	mnpd2 (net13 pd vssa vssa) nmos1 l=180n w=1u m=1
	mnc01 (net13 net69 net12 vssa) nmos1 l=180n w=1u m=1
	mpb02 (net27 net51 net158 vdda) pmos1 l=180n w=1u m=1
	mppd1 (net158 xpd vdda vdda) pmos1 l=180n w=1u m=1
	mps11 (net31 net158 vdda vdda) pmos1 l=180n w=1u m=1
	mpd11 (net56 inn net31 net31) pmos1 l=180n w=1u m=1
	mp001 (out net158 vdda vdda) pmos1 l=180n w=1u m=1
	mpd12 (net13 inp net31 net31) pmos1 l=1.7e-07n w=2.0e-06u m=1
	mpb01 (net158 net158 vdda vdda) pmos1 l=180n w=1u m=1
ends OPAMP1_variant350

subckt OPAMP1_variant351 inn inp out pd xpd vdda vssa
	xd1 (vssa vdda) prim_nwd AREA=5.7e-09 PJ=4.6e-05 m=1
	xi0 (vssa net69) prim_nd AREA=1e-12 PJ=4e-6 m=1
	xi3 (net51 vdda) prim_pd AREA=8.3e-09 PJ=2.2e-05 m=1
	xr0 (vssa vdda net51) prim_rdiffp l=2.1e-6 w=700e-9 m=1
	xr1 (vdda vdda net69) prim_rdiffp l=2.1e-6 w=700e-9 m=1
	xcc01 (net12 out) prim_cpoly c=1p m=1
	mnm12 (net13 net56 vssa vssa) nmos1 l=180n w=1u m=1
	mnm11 (net56 net56 vssa vssa) nmos1 l=180n w=1u m=1
	mnb02 (net27 net27 net21 vssa) nmos1 l=180n w=1u m=1
	mnpd1 (net21 xpd vssa vssa) nmos1 l=1.9e-07n w=9.0e-07u m=1
	mn001 (out net13 vssa vssa) nmos1 l=180n w=1u m=1
	mnpd2 (net13 pd vssa vssa) nmos1 l=180n w=1u m=1
	mnc01 (net13 net69 net12 vssa) nmos1 l=180n w=1u m=1
	mpb02 (net27 net51 net158 vdda) pmos1 l=180n w=1u m=1
	mppd1 (net158 xpd vdda vdda) pmos1 l=180n w=1u m=1
	mps11 (net31 net158 vdda vdda) pmos1 l=1.8e-07n w=5.1e-07u m=1
	mpd11 (net56 inn net31 net31) pmos1 l=180n w=1u m=1
	mp001 (out net158 vdda vdda) pmos1 l=180n w=1u m=1
	mpd12 (net13 inp net31 net31) pmos1 l=180n w=1u m=1
	mpb01 (net158 net158 vdda vdda) pmos1 l=1.1e-07n w=1.7e-06u m=1
ends OPAMP1_variant351

subckt OPAMP1_variant352 inn inp out pd xpd vdda vssa
	xd1 (vssa vdda) prim_nwd AREA=4.1e-09 PJ=6.7e-05 m=1
	xi0 (vssa net69) prim_nd AREA=1e-12 PJ=4e-6 m=1
	xi3 (net51 vdda) prim_pd AREA=790e-15 PJ=3.3e-6 m=1
	xr0 (vssa vdda net51) prim_rdiffp l=2.1e-6 w=700e-9 m=1
	xr1 (vdda vdda net69) prim_rdiffp l=2.1e-6 w=700e-9 m=1
	xcc01 (net12 out) prim_cpoly c=1p m=1
	mnm12 (net13 net56 vssa vssa) nmos1 l=180n w=1u m=1
	mnm11 (net56 net56 vssa vssa) nmos1 l=180n w=1u m=1
	mnb02 (net27 net27 net21 vssa) nmos1 l=1.5e-07n w=1.4e-06u m=1
	mnpd1 (net21 xpd vssa vssa) nmos1 l=180n w=1u m=1
	mn001 (out net13 vssa vssa) nmos1 l=180n w=1u m=1
	mnpd2 (net13 pd vssa vssa) nmos1 l=1.9e-07n w=9.1e-07u m=1
	mnc01 (net13 net69 net12 vssa) nmos1 l=180n w=1u m=1
	mpb02 (net27 net51 net158 vdda) pmos1 l=180n w=1u m=1
	mppd1 (net158 xpd vdda vdda) pmos1 l=180n w=1u m=1
	mps11 (net31 net158 vdda vdda) pmos1 l=180n w=1u m=1
	mpd11 (net56 inn net31 net31) pmos1 l=180n w=1u m=1
	mp001 (out net158 vdda vdda) pmos1 l=180n w=1u m=1
	mpd12 (net13 inp net31 net31) pmos1 l=180n w=1u m=1
	mpb01 (net158 net158 vdda vdda) pmos1 l=180n w=1u m=1
ends OPAMP1_variant352

subckt OPAMP1_variant353 inn inp out pd xpd vdda vssa
	xd1 (vssa vdda) prim_nwd AREA=6.13907e-9 PJ=476.6e-6 m=1
	xi0 (vssa net69) prim_nd AREA=1e-12 PJ=4e-6 m=1
	xi3 (net51 vdda) prim_pd AREA=790e-15 PJ=3.3e-6 m=1
	xr0 (vssa vdda net51) prim_rdiffp l=2.1e-6 w=700e-9 m=1
	xr1 (vdda vdda net69) prim_rdiffp l=2.1e-6 w=700e-9 m=1
	xcc01 (net12 out) prim_cpoly c=1p m=1
	mnm12 (net13 net56 vssa vssa) nmos1 l=180n w=1u m=1
	mnm11 (net56 net56 vssa vssa) nmos1 l=180n w=1u m=1
	mnb02 (net27 net27 net21 vssa) nmos1 l=180n w=1u m=1
	mnpd1 (net21 xpd vssa vssa) nmos1 l=180n w=1u m=1
	mn001 (out net13 vssa vssa) nmos1 l=180n w=1u m=1
	mnpd2 (net13 pd vssa vssa) nmos1 l=180n w=1u m=1
	mnc01 (net13 net69 net12 vssa) nmos1 l=180n w=1u m=1
	mpb02 (net27 net51 net158 vdda) pmos1 l=180n w=1u m=1
	mppd1 (net158 xpd vdda vdda) pmos1 l=180n w=1u m=1
	mps11 (net31 net158 vdda vdda) pmos1 l=1.1e-07n w=1.8e-06u m=1
	mpd11 (net56 inn net31 net31) pmos1 l=180n w=1u m=1
	mp001 (out net158 vdda vdda) pmos1 l=180n w=1u m=1
	mpd12 (net13 inp net31 net31) pmos1 l=2.8e-07n w=1.4e-06u m=1
	mpb01 (net158 net158 vdda vdda) pmos1 l=2.4e-07n w=1.6e-06u m=1
ends OPAMP1_variant353

subckt OPAMP1_variant354 inn inp out pd xpd vdda vssa
	xd1 (vssa vdda) prim_nwd AREA=6.13907e-9 PJ=476.6e-6 m=1
	xi0 (vssa net69) prim_nd AREA=8.6e-09 PJ=8.7e-05 m=1
	xi3 (net51 vdda) prim_pd AREA=790e-15 PJ=3.3e-6 m=1
	xr0 (vssa vdda net51) prim_rdiffp l=2.1e-6 w=700e-9 m=1
	xr1 (vdda vdda net69) prim_rdiffp l=2.1e-6 w=700e-9 m=1
	xcc01 (net12 out) prim_cpoly c=1p m=1
	mnm12 (net13 net56 vssa vssa) nmos1 l=180n w=1u m=1
	mnm11 (net56 net56 vssa vssa) nmos1 l=180n w=1u m=1
	mnb02 (net27 net27 net21 vssa) nmos1 l=1.7e-07n w=5.3e-07u m=1
	mnpd1 (net21 xpd vssa vssa) nmos1 l=180n w=1u m=1
	mn001 (out net13 vssa vssa) nmos1 l=180n w=1u m=1
	mnpd2 (net13 pd vssa vssa) nmos1 l=1.9e-07n w=1.7e-06u m=1
	mnc01 (net13 net69 net12 vssa) nmos1 l=180n w=1u m=1
	mpb02 (net27 net51 net158 vdda) pmos1 l=180n w=1u m=1
	mppd1 (net158 xpd vdda vdda) pmos1 l=180n w=1u m=1
	mps11 (net31 net158 vdda vdda) pmos1 l=2.4e-07n w=1.3e-06u m=1
	mpd11 (net56 inn net31 net31) pmos1 l=180n w=1u m=1
	mp001 (out net158 vdda vdda) pmos1 l=180n w=1u m=1
	mpd12 (net13 inp net31 net31) pmos1 l=180n w=1u m=1
	mpb01 (net158 net158 vdda vdda) pmos1 l=180n w=1u m=1
ends OPAMP1_variant354

subckt OPAMP1_variant355 inn inp out pd xpd vdda vssa
	xd1 (vssa vdda) prim_nwd AREA=6.13907e-9 PJ=476.6e-6 m=1
	xi0 (vssa net69) prim_nd AREA=1e-12 PJ=4e-6 m=1
	xi3 (net51 vdda) prim_pd AREA=790e-15 PJ=3.3e-6 m=1
	xr0 (vssa vdda net51) prim_rdiffp l=2.1e-6 w=700e-9 m=1
	xr1 (vdda vdda net69) prim_rdiffp l=2.1e-6 w=700e-9 m=1
	xcc01 (net12 out) prim_cpoly c=7.7e-13p m=1
	mnm12 (net13 net56 vssa vssa) nmos1 l=2.2e-07n w=1.9e-06u m=1
	mnm11 (net56 net56 vssa vssa) nmos1 l=180n w=1u m=1
	mnb02 (net27 net27 net21 vssa) nmos1 l=180n w=1u m=1
	mnpd1 (net21 xpd vssa vssa) nmos1 l=180n w=1u m=1
	mn001 (out net13 vssa vssa) nmos1 l=1.3e-07n w=1.8e-06u m=1
	mnpd2 (net13 pd vssa vssa) nmos1 l=180n w=1u m=1
	mnc01 (net13 net69 net12 vssa) nmos1 l=180n w=1u m=1
	mpb02 (net27 net51 net158 vdda) pmos1 l=180n w=1u m=1
	mppd1 (net158 xpd vdda vdda) pmos1 l=180n w=1u m=1
	mps11 (net31 net158 vdda vdda) pmos1 l=1.6e-07n w=1.1e-06u m=1
	mpd11 (net56 inn net31 net31) pmos1 l=180n w=1u m=1
	mp001 (out net158 vdda vdda) pmos1 l=180n w=1u m=1
	mpd12 (net13 inp net31 net31) pmos1 l=180n w=1u m=1
	mpb01 (net158 net158 vdda vdda) pmos1 l=180n w=1u m=1
ends OPAMP1_variant355

subckt OPAMP1_variant356 inn inp out pd xpd vdda vssa
	xd1 (vssa vdda) prim_nwd AREA=6.13907e-9 PJ=476.6e-6 m=1
	xi0 (vssa net69) prim_nd AREA=1e-12 PJ=4e-6 m=1
	xi3 (net51 vdda) prim_pd AREA=790e-15 PJ=3.3e-6 m=1
	xr0 (vssa vdda net51) prim_rdiffp l=2.1e-6 w=700e-9 m=1
	xr1 (vdda vdda net69) prim_rdiffp l=2.1e-6 w=700e-9 m=1
	xcc01 (net12 out) prim_cpoly c=1p m=1
	mnm12 (net13 net56 vssa vssa) nmos1 l=180n w=1u m=1
	mnm11 (net56 net56 vssa vssa) nmos1 l=180n w=1u m=1
	mnb02 (net27 net27 net21 vssa) nmos1 l=180n w=1u m=1
	mnpd1 (net21 xpd vssa vssa) nmos1 l=1.6e-07n w=1.3e-06u m=1
	mn001 (out net13 vssa vssa) nmos1 l=180n w=1u m=1
	mnpd2 (net13 pd vssa vssa) nmos1 l=180n w=1u m=1
	mnc01 (net13 net69 net12 vssa) nmos1 l=180n w=1u m=1
	mpb02 (net27 net51 net158 vdda) pmos1 l=180n w=1u m=1
	mppd1 (net158 xpd vdda vdda) pmos1 l=1.0e-07n w=1.1e-06u m=1
	mps11 (net31 net158 vdda vdda) pmos1 l=180n w=1u m=1
	mpd11 (net56 inn net31 net31) pmos1 l=180n w=1u m=1
	mp001 (out net158 vdda vdda) pmos1 l=180n w=1u m=1
	mpd12 (net13 inp net31 net31) pmos1 l=180n w=1u m=1
	mpb01 (net158 net158 vdda vdda) pmos1 l=180n w=1u m=1
ends OPAMP1_variant356

subckt OPAMP1_variant357 inn inp out pd xpd vdda vssa
	xd1 (vssa vdda) prim_nwd AREA=9.9e-09 PJ=9.5e-05 m=1
	xi0 (vssa net69) prim_nd AREA=8.7e-09 PJ=5.3e-05 m=1
	xi3 (net51 vdda) prim_pd AREA=790e-15 PJ=3.3e-6 m=1
	xr0 (vssa vdda net51) prim_rdiffp l=2.1e-6 w=700e-9 m=1
	xr1 (vdda vdda net69) prim_rdiffp l=2.1e-6 w=700e-9 m=1
	xcc01 (net12 out) prim_cpoly c=1p m=1
	mnm12 (net13 net56 vssa vssa) nmos1 l=180n w=1u m=1
	mnm11 (net56 net56 vssa vssa) nmos1 l=180n w=1u m=1
	mnb02 (net27 net27 net21 vssa) nmos1 l=180n w=1u m=1
	mnpd1 (net21 xpd vssa vssa) nmos1 l=180n w=1u m=1
	mn001 (out net13 vssa vssa) nmos1 l=1.4e-07n w=1.6e-06u m=1
	mnpd2 (net13 pd vssa vssa) nmos1 l=180n w=1u m=1
	mnc01 (net13 net69 net12 vssa) nmos1 l=180n w=1u m=1
	mpb02 (net27 net51 net158 vdda) pmos1 l=180n w=1u m=1
	mppd1 (net158 xpd vdda vdda) pmos1 l=180n w=1u m=1
	mps11 (net31 net158 vdda vdda) pmos1 l=180n w=1u m=1
	mpd11 (net56 inn net31 net31) pmos1 l=180n w=1u m=1
	mp001 (out net158 vdda vdda) pmos1 l=180n w=1u m=1
	mpd12 (net13 inp net31 net31) pmos1 l=180n w=1u m=1
	mpb01 (net158 net158 vdda vdda) pmos1 l=180n w=1u m=1
ends OPAMP1_variant357

subckt OPAMP1_variant358 inn inp out pd xpd vdda vssa
	xd1 (vssa vdda) prim_nwd AREA=6.0e-09 PJ=6.4e-05 m=1
	xi0 (vssa net69) prim_nd AREA=1e-12 PJ=4e-6 m=1
	xi3 (net51 vdda) prim_pd AREA=790e-15 PJ=3.3e-6 m=1
	xr0 (vssa vdda net51) prim_rdiffp l=2.1e-6 w=700e-9 m=1
	xr1 (vdda vdda net69) prim_rdiffp l=2.4e-07 w=6.8e-07 m=1
	xcc01 (net12 out) prim_cpoly c=1.0e-12p m=1
	mnm12 (net13 net56 vssa vssa) nmos1 l=180n w=1u m=1
	mnm11 (net56 net56 vssa vssa) nmos1 l=180n w=1u m=1
	mnb02 (net27 net27 net21 vssa) nmos1 l=180n w=1u m=1
	mnpd1 (net21 xpd vssa vssa) nmos1 l=180n w=1u m=1
	mn001 (out net13 vssa vssa) nmos1 l=1.3e-07n w=1.7e-06u m=1
	mnpd2 (net13 pd vssa vssa) nmos1 l=180n w=1u m=1
	mnc01 (net13 net69 net12 vssa) nmos1 l=180n w=1u m=1
	mpb02 (net27 net51 net158 vdda) pmos1 l=180n w=1u m=1
	mppd1 (net158 xpd vdda vdda) pmos1 l=1.1e-07n w=7.7e-07u m=1
	mps11 (net31 net158 vdda vdda) pmos1 l=180n w=1u m=1
	mpd11 (net56 inn net31 net31) pmos1 l=180n w=1u m=1
	mp001 (out net158 vdda vdda) pmos1 l=180n w=1u m=1
	mpd12 (net13 inp net31 net31) pmos1 l=180n w=1u m=1
	mpb01 (net158 net158 vdda vdda) pmos1 l=180n w=1u m=1
ends OPAMP1_variant358

subckt OPAMP1_variant359 inn inp out pd xpd vdda vssa
	xd1 (vssa vdda) prim_nwd AREA=7.4e-09 PJ=1.5e-05 m=1
	xi0 (vssa net69) prim_nd AREA=1e-12 PJ=4e-6 m=1
	xi3 (net51 vdda) prim_pd AREA=5.9e-09 PJ=3.8e-05 m=1
	xr0 (vssa vdda net51) prim_rdiffp l=2.1e-6 w=700e-9 m=1
	xr1 (vdda vdda net69) prim_rdiffp l=2.1e-6 w=700e-9 m=1
	xcc01 (net12 out) prim_cpoly c=1p m=1
	mnm12 (net13 net56 vssa vssa) nmos1 l=180n w=1u m=1
	mnm11 (net56 net56 vssa vssa) nmos1 l=2.7e-07n w=1.8e-06u m=1
	mnb02 (net27 net27 net21 vssa) nmos1 l=180n w=1u m=1
	mnpd1 (net21 xpd vssa vssa) nmos1 l=180n w=1u m=1
	mn001 (out net13 vssa vssa) nmos1 l=180n w=1u m=1
	mnpd2 (net13 pd vssa vssa) nmos1 l=180n w=1u m=1
	mnc01 (net13 net69 net12 vssa) nmos1 l=180n w=1u m=1
	mpb02 (net27 net51 net158 vdda) pmos1 l=180n w=1u m=1
	mppd1 (net158 xpd vdda vdda) pmos1 l=180n w=1u m=1
	mps11 (net31 net158 vdda vdda) pmos1 l=180n w=1u m=1
	mpd11 (net56 inn net31 net31) pmos1 l=2.0e-07n w=1.5e-06u m=1
	mp001 (out net158 vdda vdda) pmos1 l=180n w=1u m=1
	mpd12 (net13 inp net31 net31) pmos1 l=180n w=1u m=1
	mpb01 (net158 net158 vdda vdda) pmos1 l=1.2e-07n w=6.5e-07u m=1
ends OPAMP1_variant359

subckt OPAMP1_variant360 inn inp out pd xpd vdda vssa
	xd1 (vssa vdda) prim_nwd AREA=6.13907e-9 PJ=476.6e-6 m=1
	xi0 (vssa net69) prim_nd AREA=1e-12 PJ=4e-6 m=1
	xi3 (net51 vdda) prim_pd AREA=790e-15 PJ=3.3e-6 m=1
	xr0 (vssa vdda net51) prim_rdiffp l=1.3e-07 w=6.3e-07 m=1
	xr1 (vdda vdda net69) prim_rdiffp l=2.1e-6 w=700e-9 m=1
	xcc01 (net12 out) prim_cpoly c=1p m=1
	mnm12 (net13 net56 vssa vssa) nmos1 l=180n w=1u m=1
	mnm11 (net56 net56 vssa vssa) nmos1 l=180n w=1u m=1
	mnb02 (net27 net27 net21 vssa) nmos1 l=180n w=1u m=1
	mnpd1 (net21 xpd vssa vssa) nmos1 l=180n w=1u m=1
	mn001 (out net13 vssa vssa) nmos1 l=180n w=1u m=1
	mnpd2 (net13 pd vssa vssa) nmos1 l=180n w=1u m=1
	mnc01 (net13 net69 net12 vssa) nmos1 l=180n w=1u m=1
	mpb02 (net27 net51 net158 vdda) pmos1 l=180n w=1u m=1
	mppd1 (net158 xpd vdda vdda) pmos1 l=180n w=1u m=1
	mps11 (net31 net158 vdda vdda) pmos1 l=180n w=1u m=1
	mpd11 (net56 inn net31 net31) pmos1 l=180n w=1u m=1
	mp001 (out net158 vdda vdda) pmos1 l=2.7e-07n w=1.5e-06u m=1
	mpd12 (net13 inp net31 net31) pmos1 l=2.3e-07n w=1.6e-06u m=1
	mpb01 (net158 net158 vdda vdda) pmos1 l=180n w=1u m=1
ends OPAMP1_variant360

subckt OPAMP1_variant361 inn inp out pd xpd vdda vssa
	xd1 (vssa vdda) prim_nwd AREA=6.13907e-9 PJ=476.6e-6 m=1
	xi0 (vssa net69) prim_nd AREA=1e-12 PJ=4e-6 m=1
	xi3 (net51 vdda) prim_pd AREA=790e-15 PJ=3.3e-6 m=1
	xr0 (vssa vdda net51) prim_rdiffp l=2.1e-6 w=700e-9 m=1
	xr1 (vdda vdda net69) prim_rdiffp l=2.1e-6 w=700e-9 m=1
	xcc01 (net12 out) prim_cpoly c=1p m=1
	mnm12 (net13 net56 vssa vssa) nmos1 l=180n w=1u m=1
	mnm11 (net56 net56 vssa vssa) nmos1 l=180n w=1u m=1
	mnb02 (net27 net27 net21 vssa) nmos1 l=180n w=1u m=1
	mnpd1 (net21 xpd vssa vssa) nmos1 l=180n w=1u m=1
	mn001 (out net13 vssa vssa) nmos1 l=180n w=1u m=1
	mnpd2 (net13 pd vssa vssa) nmos1 l=180n w=1u m=1
	mnc01 (net13 net69 net12 vssa) nmos1 l=180n w=1u m=1
	mpb02 (net27 net51 net158 vdda) pmos1 l=180n w=1u m=1
	mppd1 (net158 xpd vdda vdda) pmos1 l=1.0e-07n w=1.2e-06u m=1
	mps11 (net31 net158 vdda vdda) pmos1 l=180n w=1u m=1
	mpd11 (net56 inn net31 net31) pmos1 l=180n w=1u m=1
	mp001 (out net158 vdda vdda) pmos1 l=180n w=1u m=1
	mpd12 (net13 inp net31 net31) pmos1 l=1.1e-07n w=1.7e-06u m=1
	mpb01 (net158 net158 vdda vdda) pmos1 l=180n w=1u m=1
ends OPAMP1_variant361

subckt OPAMP1_variant362 inn inp out pd xpd vdda vssa
	xd1 (vssa vdda) prim_nwd AREA=4.4e-09 PJ=2.3e-05 m=1
	xi0 (vssa net69) prim_nd AREA=1e-12 PJ=4e-6 m=1
	xi3 (net51 vdda) prim_pd AREA=790e-15 PJ=3.3e-6 m=1
	xr0 (vssa vdda net51) prim_rdiffp l=2.1e-6 w=700e-9 m=1
	xr1 (vdda vdda net69) prim_rdiffp l=2.1e-6 w=700e-9 m=1
	xcc01 (net12 out) prim_cpoly c=1p m=1
	mnm12 (net13 net56 vssa vssa) nmos1 l=180n w=1u m=1
	mnm11 (net56 net56 vssa vssa) nmos1 l=180n w=1u m=1
	mnb02 (net27 net27 net21 vssa) nmos1 l=180n w=1u m=1
	mnpd1 (net21 xpd vssa vssa) nmos1 l=180n w=1u m=1
	mn001 (out net13 vssa vssa) nmos1 l=180n w=1u m=1
	mnpd2 (net13 pd vssa vssa) nmos1 l=180n w=1u m=1
	mnc01 (net13 net69 net12 vssa) nmos1 l=180n w=1u m=1
	mpb02 (net27 net51 net158 vdda) pmos1 l=180n w=1u m=1
	mppd1 (net158 xpd vdda vdda) pmos1 l=180n w=1u m=1
	mps11 (net31 net158 vdda vdda) pmos1 l=180n w=1u m=1
	mpd11 (net56 inn net31 net31) pmos1 l=1.4e-07n w=1.0e-06u m=1
	mp001 (out net158 vdda vdda) pmos1 l=180n w=1u m=1
	mpd12 (net13 inp net31 net31) pmos1 l=180n w=1u m=1
	mpb01 (net158 net158 vdda vdda) pmos1 l=180n w=1u m=1
ends OPAMP1_variant362

subckt OPAMP1_variant363 inn inp out pd xpd vdda vssa
	xd1 (vssa vdda) prim_nwd AREA=6.13907e-9 PJ=476.6e-6 m=1
	xi0 (vssa net69) prim_nd AREA=1e-12 PJ=4e-6 m=1
	xi3 (net51 vdda) prim_pd AREA=8.7e-09 PJ=7.9e-06 m=1
	xr0 (vssa vdda net51) prim_rdiffp l=2.1e-6 w=700e-9 m=1
	xr1 (vdda vdda net69) prim_rdiffp l=2.1e-6 w=700e-9 m=1
	xcc01 (net12 out) prim_cpoly c=1p m=1
	mnm12 (net13 net56 vssa vssa) nmos1 l=180n w=1u m=1
	mnm11 (net56 net56 vssa vssa) nmos1 l=180n w=1u m=1
	mnb02 (net27 net27 net21 vssa) nmos1 l=180n w=1u m=1
	mnpd1 (net21 xpd vssa vssa) nmos1 l=180n w=1u m=1
	mn001 (out net13 vssa vssa) nmos1 l=1.3e-07n w=1.1e-06u m=1
	mnpd2 (net13 pd vssa vssa) nmos1 l=180n w=1u m=1
	mnc01 (net13 net69 net12 vssa) nmos1 l=2.9e-07n w=1.8e-06u m=1
	mpb02 (net27 net51 net158 vdda) pmos1 l=180n w=1u m=1
	mppd1 (net158 xpd vdda vdda) pmos1 l=180n w=1u m=1
	mps11 (net31 net158 vdda vdda) pmos1 l=180n w=1u m=1
	mpd11 (net56 inn net31 net31) pmos1 l=180n w=1u m=1
	mp001 (out net158 vdda vdda) pmos1 l=180n w=1u m=1
	mpd12 (net13 inp net31 net31) pmos1 l=180n w=1u m=1
	mpb01 (net158 net158 vdda vdda) pmos1 l=180n w=1u m=1
ends OPAMP1_variant363

subckt OPAMP1_variant364 inn inp out pd xpd vdda vssa
	xd1 (vssa vdda) prim_nwd AREA=6.13907e-9 PJ=476.6e-6 m=1
	xi0 (vssa net69) prim_nd AREA=1e-12 PJ=4e-6 m=1
	xi3 (net51 vdda) prim_pd AREA=790e-15 PJ=3.3e-6 m=1
	xr0 (vssa vdda net51) prim_rdiffp l=2.1e-6 w=700e-9 m=1
	xr1 (vdda vdda net69) prim_rdiffp l=2.2e-07 w=1.2e-06 m=1
	xcc01 (net12 out) prim_cpoly c=1p m=1
	mnm12 (net13 net56 vssa vssa) nmos1 l=2.7e-07n w=1.6e-06u m=1
	mnm11 (net56 net56 vssa vssa) nmos1 l=1.5e-07n w=8.9e-07u m=1
	mnb02 (net27 net27 net21 vssa) nmos1 l=180n w=1u m=1
	mnpd1 (net21 xpd vssa vssa) nmos1 l=180n w=1u m=1
	mn001 (out net13 vssa vssa) nmos1 l=180n w=1u m=1
	mnpd2 (net13 pd vssa vssa) nmos1 l=180n w=1u m=1
	mnc01 (net13 net69 net12 vssa) nmos1 l=180n w=1u m=1
	mpb02 (net27 net51 net158 vdda) pmos1 l=180n w=1u m=1
	mppd1 (net158 xpd vdda vdda) pmos1 l=180n w=1u m=1
	mps11 (net31 net158 vdda vdda) pmos1 l=180n w=1u m=1
	mpd11 (net56 inn net31 net31) pmos1 l=1.5e-07n w=7.5e-07u m=1
	mp001 (out net158 vdda vdda) pmos1 l=180n w=1u m=1
	mpd12 (net13 inp net31 net31) pmos1 l=2.1e-07n w=1.2e-06u m=1
	mpb01 (net158 net158 vdda vdda) pmos1 l=180n w=1u m=1
ends OPAMP1_variant364

subckt OPAMP1_variant365 inn inp out pd xpd vdda vssa
	xd1 (vssa vdda) prim_nwd AREA=6.13907e-9 PJ=476.6e-6 m=1
	xi0 (vssa net69) prim_nd AREA=3.5e-09 PJ=2.6e-05 m=1
	xi3 (net51 vdda) prim_pd AREA=790e-15 PJ=3.3e-6 m=1
	xr0 (vssa vdda net51) prim_rdiffp l=2.1e-6 w=700e-9 m=1
	xr1 (vdda vdda net69) prim_rdiffp l=1.6e-07 w=5.9e-07 m=1
	xcc01 (net12 out) prim_cpoly c=1p m=1
	mnm12 (net13 net56 vssa vssa) nmos1 l=180n w=1u m=1
	mnm11 (net56 net56 vssa vssa) nmos1 l=1.4e-07n w=8.4e-07u m=1
	mnb02 (net27 net27 net21 vssa) nmos1 l=180n w=1u m=1
	mnpd1 (net21 xpd vssa vssa) nmos1 l=180n w=1u m=1
	mn001 (out net13 vssa vssa) nmos1 l=180n w=1u m=1
	mnpd2 (net13 pd vssa vssa) nmos1 l=180n w=1u m=1
	mnc01 (net13 net69 net12 vssa) nmos1 l=180n w=1u m=1
	mpb02 (net27 net51 net158 vdda) pmos1 l=180n w=1u m=1
	mppd1 (net158 xpd vdda vdda) pmos1 l=1.4e-07n w=8.6e-07u m=1
	mps11 (net31 net158 vdda vdda) pmos1 l=180n w=1u m=1
	mpd11 (net56 inn net31 net31) pmos1 l=180n w=1u m=1
	mp001 (out net158 vdda vdda) pmos1 l=180n w=1u m=1
	mpd12 (net13 inp net31 net31) pmos1 l=180n w=1u m=1
	mpb01 (net158 net158 vdda vdda) pmos1 l=180n w=1u m=1
ends OPAMP1_variant365

subckt OPAMP1_variant366 inn inp out pd xpd vdda vssa
	xd1 (vssa vdda) prim_nwd AREA=6.13907e-9 PJ=476.6e-6 m=1
	xi0 (vssa net69) prim_nd AREA=1e-12 PJ=4e-6 m=1
	xi3 (net51 vdda) prim_pd AREA=790e-15 PJ=3.3e-6 m=1
	xr0 (vssa vdda net51) prim_rdiffp l=2.1e-6 w=700e-9 m=1
	xr1 (vdda vdda net69) prim_rdiffp l=2.1e-6 w=700e-9 m=1
	xcc01 (net12 out) prim_cpoly c=1p m=1
	mnm12 (net13 net56 vssa vssa) nmos1 l=180n w=1u m=1
	mnm11 (net56 net56 vssa vssa) nmos1 l=180n w=1u m=1
	mnb02 (net27 net27 net21 vssa) nmos1 l=180n w=1u m=1
	mnpd1 (net21 xpd vssa vssa) nmos1 l=180n w=1u m=1
	mn001 (out net13 vssa vssa) nmos1 l=180n w=1u m=1
	mnpd2 (net13 pd vssa vssa) nmos1 l=180n w=1u m=1
	mnc01 (net13 net69 net12 vssa) nmos1 l=180n w=1u m=1
	mpb02 (net27 net51 net158 vdda) pmos1 l=180n w=1u m=1
	mppd1 (net158 xpd vdda vdda) pmos1 l=180n w=1u m=1
	mps11 (net31 net158 vdda vdda) pmos1 l=1.6e-07n w=1.9e-06u m=1
	mpd11 (net56 inn net31 net31) pmos1 l=1.4e-07n w=9.8e-07u m=1
	mp001 (out net158 vdda vdda) pmos1 l=2.0e-07n w=1.4e-06u m=1
	mpd12 (net13 inp net31 net31) pmos1 l=180n w=1u m=1
	mpb01 (net158 net158 vdda vdda) pmos1 l=180n w=1u m=1
ends OPAMP1_variant366

subckt OPAMP1_variant367 inn inp out pd xpd vdda vssa
	xd1 (vssa vdda) prim_nwd AREA=6.13907e-9 PJ=476.6e-6 m=1
	xi0 (vssa net69) prim_nd AREA=1e-12 PJ=4e-6 m=1
	xi3 (net51 vdda) prim_pd AREA=790e-15 PJ=3.3e-6 m=1
	xr0 (vssa vdda net51) prim_rdiffp l=2.1e-6 w=700e-9 m=1
	xr1 (vdda vdda net69) prim_rdiffp l=2.1e-07 w=2.0e-06 m=1
	xcc01 (net12 out) prim_cpoly c=1p m=1
	mnm12 (net13 net56 vssa vssa) nmos1 l=180n w=1u m=1
	mnm11 (net56 net56 vssa vssa) nmos1 l=180n w=1u m=1
	mnb02 (net27 net27 net21 vssa) nmos1 l=180n w=1u m=1
	mnpd1 (net21 xpd vssa vssa) nmos1 l=180n w=1u m=1
	mn001 (out net13 vssa vssa) nmos1 l=1.6e-07n w=1.4e-06u m=1
	mnpd2 (net13 pd vssa vssa) nmos1 l=180n w=1u m=1
	mnc01 (net13 net69 net12 vssa) nmos1 l=180n w=1u m=1
	mpb02 (net27 net51 net158 vdda) pmos1 l=2.5e-07n w=5.9e-07u m=1
	mppd1 (net158 xpd vdda vdda) pmos1 l=2.8e-07n w=1.0e-06u m=1
	mps11 (net31 net158 vdda vdda) pmos1 l=180n w=1u m=1
	mpd11 (net56 inn net31 net31) pmos1 l=180n w=1u m=1
	mp001 (out net158 vdda vdda) pmos1 l=180n w=1u m=1
	mpd12 (net13 inp net31 net31) pmos1 l=180n w=1u m=1
	mpb01 (net158 net158 vdda vdda) pmos1 l=180n w=1u m=1
ends OPAMP1_variant367

subckt OPAMP1_variant368 inn inp out pd xpd vdda vssa
	xd1 (vssa vdda) prim_nwd AREA=6.13907e-9 PJ=476.6e-6 m=1
	xi0 (vssa net69) prim_nd AREA=1e-12 PJ=4e-6 m=1
	xi3 (net51 vdda) prim_pd AREA=790e-15 PJ=3.3e-6 m=1
	xr0 (vssa vdda net51) prim_rdiffp l=2.1e-6 w=700e-9 m=1
	xr1 (vdda vdda net69) prim_rdiffp l=2.1e-6 w=700e-9 m=1
	xcc01 (net12 out) prim_cpoly c=1p m=1
	mnm12 (net13 net56 vssa vssa) nmos1 l=180n w=1u m=1
	mnm11 (net56 net56 vssa vssa) nmos1 l=180n w=1u m=1
	mnb02 (net27 net27 net21 vssa) nmos1 l=180n w=1u m=1
	mnpd1 (net21 xpd vssa vssa) nmos1 l=180n w=1u m=1
	mn001 (out net13 vssa vssa) nmos1 l=180n w=1u m=1
	mnpd2 (net13 pd vssa vssa) nmos1 l=180n w=1u m=1
	mnc01 (net13 net69 net12 vssa) nmos1 l=2.6e-07n w=8.1e-07u m=1
	mpb02 (net27 net51 net158 vdda) pmos1 l=180n w=1u m=1
	mppd1 (net158 xpd vdda vdda) pmos1 l=180n w=1u m=1
	mps11 (net31 net158 vdda vdda) pmos1 l=180n w=1u m=1
	mpd11 (net56 inn net31 net31) pmos1 l=1.6e-07n w=7.8e-07u m=1
	mp001 (out net158 vdda vdda) pmos1 l=180n w=1u m=1
	mpd12 (net13 inp net31 net31) pmos1 l=180n w=1u m=1
	mpb01 (net158 net158 vdda vdda) pmos1 l=180n w=1u m=1
ends OPAMP1_variant368

subckt OPAMP1_variant369 inn inp out pd xpd vdda vssa
	xd1 (vssa vdda) prim_nwd AREA=1.9e-09 PJ=1.7e-05 m=1
	xi0 (vssa net69) prim_nd AREA=1e-12 PJ=4e-6 m=1
	xi3 (net51 vdda) prim_pd AREA=790e-15 PJ=3.3e-6 m=1
	xr0 (vssa vdda net51) prim_rdiffp l=2.1e-6 w=700e-9 m=1
	xr1 (vdda vdda net69) prim_rdiffp l=1.1e-07 w=7.5e-07 m=1
	xcc01 (net12 out) prim_cpoly c=1.5e-12p m=1
	mnm12 (net13 net56 vssa vssa) nmos1 l=2.0e-07n w=1.4e-06u m=1
	mnm11 (net56 net56 vssa vssa) nmos1 l=180n w=1u m=1
	mnb02 (net27 net27 net21 vssa) nmos1 l=180n w=1u m=1
	mnpd1 (net21 xpd vssa vssa) nmos1 l=180n w=1u m=1
	mn001 (out net13 vssa vssa) nmos1 l=180n w=1u m=1
	mnpd2 (net13 pd vssa vssa) nmos1 l=180n w=1u m=1
	mnc01 (net13 net69 net12 vssa) nmos1 l=180n w=1u m=1
	mpb02 (net27 net51 net158 vdda) pmos1 l=180n w=1u m=1
	mppd1 (net158 xpd vdda vdda) pmos1 l=180n w=1u m=1
	mps11 (net31 net158 vdda vdda) pmos1 l=180n w=1u m=1
	mpd11 (net56 inn net31 net31) pmos1 l=180n w=1u m=1
	mp001 (out net158 vdda vdda) pmos1 l=180n w=1u m=1
	mpd12 (net13 inp net31 net31) pmos1 l=180n w=1u m=1
	mpb01 (net158 net158 vdda vdda) pmos1 l=180n w=1u m=1
ends OPAMP1_variant369

subckt OPAMP1_variant370 inn inp out pd xpd vdda vssa
	xd1 (vssa vdda) prim_nwd AREA=6.13907e-9 PJ=476.6e-6 m=1
	xi0 (vssa net69) prim_nd AREA=1e-12 PJ=4e-6 m=1
	xi3 (net51 vdda) prim_pd AREA=790e-15 PJ=3.3e-6 m=1
	xr0 (vssa vdda net51) prim_rdiffp l=1.3e-07 w=7.6e-07 m=1
	xr1 (vdda vdda net69) prim_rdiffp l=2.1e-6 w=700e-9 m=1
	xcc01 (net12 out) prim_cpoly c=1p m=1
	mnm12 (net13 net56 vssa vssa) nmos1 l=180n w=1u m=1
	mnm11 (net56 net56 vssa vssa) nmos1 l=180n w=1u m=1
	mnb02 (net27 net27 net21 vssa) nmos1 l=180n w=1u m=1
	mnpd1 (net21 xpd vssa vssa) nmos1 l=1.7e-07n w=1.5e-06u m=1
	mn001 (out net13 vssa vssa) nmos1 l=180n w=1u m=1
	mnpd2 (net13 pd vssa vssa) nmos1 l=180n w=1u m=1
	mnc01 (net13 net69 net12 vssa) nmos1 l=180n w=1u m=1
	mpb02 (net27 net51 net158 vdda) pmos1 l=180n w=1u m=1
	mppd1 (net158 xpd vdda vdda) pmos1 l=180n w=1u m=1
	mps11 (net31 net158 vdda vdda) pmos1 l=180n w=1u m=1
	mpd11 (net56 inn net31 net31) pmos1 l=180n w=1u m=1
	mp001 (out net158 vdda vdda) pmos1 l=180n w=1u m=1
	mpd12 (net13 inp net31 net31) pmos1 l=180n w=1u m=1
	mpb01 (net158 net158 vdda vdda) pmos1 l=180n w=1u m=1
ends OPAMP1_variant370

subckt OPAMP1_variant371 inn inp out pd xpd vdda vssa
	xd1 (vssa vdda) prim_nwd AREA=6.13907e-9 PJ=476.6e-6 m=1
	xi0 (vssa net69) prim_nd AREA=1e-12 PJ=4e-6 m=1
	xi3 (net51 vdda) prim_pd AREA=790e-15 PJ=3.3e-6 m=1
	xr0 (vssa vdda net51) prim_rdiffp l=2.1e-6 w=700e-9 m=1
	xr1 (vdda vdda net69) prim_rdiffp l=2.1e-6 w=700e-9 m=1
	xcc01 (net12 out) prim_cpoly c=1p m=1
	mnm12 (net13 net56 vssa vssa) nmos1 l=2.4e-07n w=1.7e-06u m=1
	mnm11 (net56 net56 vssa vssa) nmos1 l=180n w=1u m=1
	mnb02 (net27 net27 net21 vssa) nmos1 l=180n w=1u m=1
	mnpd1 (net21 xpd vssa vssa) nmos1 l=180n w=1u m=1
	mn001 (out net13 vssa vssa) nmos1 l=180n w=1u m=1
	mnpd2 (net13 pd vssa vssa) nmos1 l=2.8e-07n w=1.7e-06u m=1
	mnc01 (net13 net69 net12 vssa) nmos1 l=180n w=1u m=1
	mpb02 (net27 net51 net158 vdda) pmos1 l=180n w=1u m=1
	mppd1 (net158 xpd vdda vdda) pmos1 l=2.2e-07n w=1.6e-06u m=1
	mps11 (net31 net158 vdda vdda) pmos1 l=180n w=1u m=1
	mpd11 (net56 inn net31 net31) pmos1 l=2.8e-07n w=1.2e-06u m=1
	mp001 (out net158 vdda vdda) pmos1 l=1.3e-07n w=1.2e-06u m=1
	mpd12 (net13 inp net31 net31) pmos1 l=180n w=1u m=1
	mpb01 (net158 net158 vdda vdda) pmos1 l=180n w=1u m=1
ends OPAMP1_variant371

subckt OPAMP1_variant372 inn inp out pd xpd vdda vssa
	xd1 (vssa vdda) prim_nwd AREA=6.13907e-9 PJ=476.6e-6 m=1
	xi0 (vssa net69) prim_nd AREA=5.6e-09 PJ=5.1e-05 m=1
	xi3 (net51 vdda) prim_pd AREA=790e-15 PJ=3.3e-6 m=1
	xr0 (vssa vdda net51) prim_rdiffp l=2.1e-6 w=700e-9 m=1
	xr1 (vdda vdda net69) prim_rdiffp l=2.4e-07 w=1.5e-06 m=1
	xcc01 (net12 out) prim_cpoly c=1.8e-12p m=1
	mnm12 (net13 net56 vssa vssa) nmos1 l=180n w=1u m=1
	mnm11 (net56 net56 vssa vssa) nmos1 l=180n w=1u m=1
	mnb02 (net27 net27 net21 vssa) nmos1 l=2.9e-07n w=1.8e-06u m=1
	mnpd1 (net21 xpd vssa vssa) nmos1 l=180n w=1u m=1
	mn001 (out net13 vssa vssa) nmos1 l=180n w=1u m=1
	mnpd2 (net13 pd vssa vssa) nmos1 l=1.4e-07n w=1.8e-06u m=1
	mnc01 (net13 net69 net12 vssa) nmos1 l=180n w=1u m=1
	mpb02 (net27 net51 net158 vdda) pmos1 l=180n w=1u m=1
	mppd1 (net158 xpd vdda vdda) pmos1 l=180n w=1u m=1
	mps11 (net31 net158 vdda vdda) pmos1 l=180n w=1u m=1
	mpd11 (net56 inn net31 net31) pmos1 l=180n w=1u m=1
	mp001 (out net158 vdda vdda) pmos1 l=180n w=1u m=1
	mpd12 (net13 inp net31 net31) pmos1 l=180n w=1u m=1
	mpb01 (net158 net158 vdda vdda) pmos1 l=180n w=1u m=1
ends OPAMP1_variant372

subckt OPAMP1_variant373 inn inp out pd xpd vdda vssa
	xd1 (vssa vdda) prim_nwd AREA=6.13907e-9 PJ=476.6e-6 m=1
	xi0 (vssa net69) prim_nd AREA=1e-12 PJ=4e-6 m=1
	xi3 (net51 vdda) prim_pd AREA=790e-15 PJ=3.3e-6 m=1
	xr0 (vssa vdda net51) prim_rdiffp l=2.1e-6 w=700e-9 m=1
	xr1 (vdda vdda net69) prim_rdiffp l=2.1e-6 w=700e-9 m=1
	xcc01 (net12 out) prim_cpoly c=1p m=1
	mnm12 (net13 net56 vssa vssa) nmos1 l=2.5e-07n w=5.1e-07u m=1
	mnm11 (net56 net56 vssa vssa) nmos1 l=1.4e-07n w=8.1e-07u m=1
	mnb02 (net27 net27 net21 vssa) nmos1 l=180n w=1u m=1
	mnpd1 (net21 xpd vssa vssa) nmos1 l=180n w=1u m=1
	mn001 (out net13 vssa vssa) nmos1 l=180n w=1u m=1
	mnpd2 (net13 pd vssa vssa) nmos1 l=180n w=1u m=1
	mnc01 (net13 net69 net12 vssa) nmos1 l=180n w=1u m=1
	mpb02 (net27 net51 net158 vdda) pmos1 l=1.2e-07n w=8.2e-07u m=1
	mppd1 (net158 xpd vdda vdda) pmos1 l=180n w=1u m=1
	mps11 (net31 net158 vdda vdda) pmos1 l=180n w=1u m=1
	mpd11 (net56 inn net31 net31) pmos1 l=180n w=1u m=1
	mp001 (out net158 vdda vdda) pmos1 l=180n w=1u m=1
	mpd12 (net13 inp net31 net31) pmos1 l=180n w=1u m=1
	mpb01 (net158 net158 vdda vdda) pmos1 l=180n w=1u m=1
ends OPAMP1_variant373

subckt OPAMP1_variant374 inn inp out pd xpd vdda vssa
	xd1 (vssa vdda) prim_nwd AREA=6.13907e-9 PJ=476.6e-6 m=1
	xi0 (vssa net69) prim_nd AREA=9.9e-09 PJ=8.9e-05 m=1
	xi3 (net51 vdda) prim_pd AREA=790e-15 PJ=3.3e-6 m=1
	xr0 (vssa vdda net51) prim_rdiffp l=2.1e-6 w=700e-9 m=1
	xr1 (vdda vdda net69) prim_rdiffp l=2.1e-6 w=700e-9 m=1
	xcc01 (net12 out) prim_cpoly c=1p m=1
	mnm12 (net13 net56 vssa vssa) nmos1 l=180n w=1u m=1
	mnm11 (net56 net56 vssa vssa) nmos1 l=180n w=1u m=1
	mnb02 (net27 net27 net21 vssa) nmos1 l=180n w=1u m=1
	mnpd1 (net21 xpd vssa vssa) nmos1 l=180n w=1u m=1
	mn001 (out net13 vssa vssa) nmos1 l=180n w=1u m=1
	mnpd2 (net13 pd vssa vssa) nmos1 l=180n w=1u m=1
	mnc01 (net13 net69 net12 vssa) nmos1 l=180n w=1u m=1
	mpb02 (net27 net51 net158 vdda) pmos1 l=180n w=1u m=1
	mppd1 (net158 xpd vdda vdda) pmos1 l=1.1e-07n w=5.4e-07u m=1
	mps11 (net31 net158 vdda vdda) pmos1 l=180n w=1u m=1
	mpd11 (net56 inn net31 net31) pmos1 l=1.2e-07n w=1.3e-06u m=1
	mp001 (out net158 vdda vdda) pmos1 l=1.3e-07n w=1.2e-06u m=1
	mpd12 (net13 inp net31 net31) pmos1 l=180n w=1u m=1
	mpb01 (net158 net158 vdda vdda) pmos1 l=180n w=1u m=1
ends OPAMP1_variant374

subckt OPAMP1_variant375 inn inp out pd xpd vdda vssa
	xd1 (vssa vdda) prim_nwd AREA=6.13907e-9 PJ=476.6e-6 m=1
	xi0 (vssa net69) prim_nd AREA=1e-12 PJ=4e-6 m=1
	xi3 (net51 vdda) prim_pd AREA=5.4e-10 PJ=8.1e-06 m=1
	xr0 (vssa vdda net51) prim_rdiffp l=1.5e-07 w=7.1e-07 m=1
	xr1 (vdda vdda net69) prim_rdiffp l=2.1e-6 w=700e-9 m=1
	xcc01 (net12 out) prim_cpoly c=1p m=1
	mnm12 (net13 net56 vssa vssa) nmos1 l=180n w=1u m=1
	mnm11 (net56 net56 vssa vssa) nmos1 l=180n w=1u m=1
	mnb02 (net27 net27 net21 vssa) nmos1 l=1.4e-07n w=1.8e-06u m=1
	mnpd1 (net21 xpd vssa vssa) nmos1 l=180n w=1u m=1
	mn001 (out net13 vssa vssa) nmos1 l=180n w=1u m=1
	mnpd2 (net13 pd vssa vssa) nmos1 l=180n w=1u m=1
	mnc01 (net13 net69 net12 vssa) nmos1 l=180n w=1u m=1
	mpb02 (net27 net51 net158 vdda) pmos1 l=180n w=1u m=1
	mppd1 (net158 xpd vdda vdda) pmos1 l=180n w=1u m=1
	mps11 (net31 net158 vdda vdda) pmos1 l=1.3e-07n w=9.6e-07u m=1
	mpd11 (net56 inn net31 net31) pmos1 l=180n w=1u m=1
	mp001 (out net158 vdda vdda) pmos1 l=180n w=1u m=1
	mpd12 (net13 inp net31 net31) pmos1 l=180n w=1u m=1
	mpb01 (net158 net158 vdda vdda) pmos1 l=2.1e-07n w=6.4e-07u m=1
ends OPAMP1_variant375

subckt OPAMP1_variant376 inn inp out pd xpd vdda vssa
	xd1 (vssa vdda) prim_nwd AREA=6.13907e-9 PJ=476.6e-6 m=1
	xi0 (vssa net69) prim_nd AREA=7.7e-09 PJ=8.1e-05 m=1
	xi3 (net51 vdda) prim_pd AREA=790e-15 PJ=3.3e-6 m=1
	xr0 (vssa vdda net51) prim_rdiffp l=2.1e-6 w=700e-9 m=1
	xr1 (vdda vdda net69) prim_rdiffp l=2.1e-6 w=700e-9 m=1
	xcc01 (net12 out) prim_cpoly c=1p m=1
	mnm12 (net13 net56 vssa vssa) nmos1 l=2.9e-07n w=7.2e-07u m=1
	mnm11 (net56 net56 vssa vssa) nmos1 l=180n w=1u m=1
	mnb02 (net27 net27 net21 vssa) nmos1 l=180n w=1u m=1
	mnpd1 (net21 xpd vssa vssa) nmos1 l=180n w=1u m=1
	mn001 (out net13 vssa vssa) nmos1 l=180n w=1u m=1
	mnpd2 (net13 pd vssa vssa) nmos1 l=180n w=1u m=1
	mnc01 (net13 net69 net12 vssa) nmos1 l=180n w=1u m=1
	mpb02 (net27 net51 net158 vdda) pmos1 l=180n w=1u m=1
	mppd1 (net158 xpd vdda vdda) pmos1 l=180n w=1u m=1
	mps11 (net31 net158 vdda vdda) pmos1 l=180n w=1u m=1
	mpd11 (net56 inn net31 net31) pmos1 l=1.0e-07n w=1.2e-06u m=1
	mp001 (out net158 vdda vdda) pmos1 l=180n w=1u m=1
	mpd12 (net13 inp net31 net31) pmos1 l=2.0e-07n w=8.8e-07u m=1
	mpb01 (net158 net158 vdda vdda) pmos1 l=180n w=1u m=1
ends OPAMP1_variant376

subckt OPAMP1_variant377 inn inp out pd xpd vdda vssa
	xd1 (vssa vdda) prim_nwd AREA=9.3e-09 PJ=1.8e-05 m=1
	xi0 (vssa net69) prim_nd AREA=1e-12 PJ=4e-6 m=1
	xi3 (net51 vdda) prim_pd AREA=790e-15 PJ=3.3e-6 m=1
	xr0 (vssa vdda net51) prim_rdiffp l=2.1e-6 w=700e-9 m=1
	xr1 (vdda vdda net69) prim_rdiffp l=2.1e-6 w=700e-9 m=1
	xcc01 (net12 out) prim_cpoly c=1p m=1
	mnm12 (net13 net56 vssa vssa) nmos1 l=180n w=1u m=1
	mnm11 (net56 net56 vssa vssa) nmos1 l=180n w=1u m=1
	mnb02 (net27 net27 net21 vssa) nmos1 l=180n w=1u m=1
	mnpd1 (net21 xpd vssa vssa) nmos1 l=180n w=1u m=1
	mn001 (out net13 vssa vssa) nmos1 l=180n w=1u m=1
	mnpd2 (net13 pd vssa vssa) nmos1 l=180n w=1u m=1
	mnc01 (net13 net69 net12 vssa) nmos1 l=2.4e-07n w=1.6e-06u m=1
	mpb02 (net27 net51 net158 vdda) pmos1 l=180n w=1u m=1
	mppd1 (net158 xpd vdda vdda) pmos1 l=180n w=1u m=1
	mps11 (net31 net158 vdda vdda) pmos1 l=180n w=1u m=1
	mpd11 (net56 inn net31 net31) pmos1 l=180n w=1u m=1
	mp001 (out net158 vdda vdda) pmos1 l=180n w=1u m=1
	mpd12 (net13 inp net31 net31) pmos1 l=2.9e-07n w=1.7e-06u m=1
	mpb01 (net158 net158 vdda vdda) pmos1 l=180n w=1u m=1
ends OPAMP1_variant377

subckt OPAMP1_variant378 inn inp out pd xpd vdda vssa
	xd1 (vssa vdda) prim_nwd AREA=6.13907e-9 PJ=476.6e-6 m=1
	xi0 (vssa net69) prim_nd AREA=1e-12 PJ=4e-6 m=1
	xi3 (net51 vdda) prim_pd AREA=790e-15 PJ=3.3e-6 m=1
	xr0 (vssa vdda net51) prim_rdiffp l=2.1e-6 w=700e-9 m=1
	xr1 (vdda vdda net69) prim_rdiffp l=2.1e-6 w=700e-9 m=1
	xcc01 (net12 out) prim_cpoly c=1p m=1
	mnm12 (net13 net56 vssa vssa) nmos1 l=180n w=1u m=1
	mnm11 (net56 net56 vssa vssa) nmos1 l=180n w=1u m=1
	mnb02 (net27 net27 net21 vssa) nmos1 l=2.6e-07n w=1.4e-06u m=1
	mnpd1 (net21 xpd vssa vssa) nmos1 l=180n w=1u m=1
	mn001 (out net13 vssa vssa) nmos1 l=1.0e-07n w=2.0e-06u m=1
	mnpd2 (net13 pd vssa vssa) nmos1 l=180n w=1u m=1
	mnc01 (net13 net69 net12 vssa) nmos1 l=180n w=1u m=1
	mpb02 (net27 net51 net158 vdda) pmos1 l=180n w=1u m=1
	mppd1 (net158 xpd vdda vdda) pmos1 l=180n w=1u m=1
	mps11 (net31 net158 vdda vdda) pmos1 l=180n w=1u m=1
	mpd11 (net56 inn net31 net31) pmos1 l=180n w=1u m=1
	mp001 (out net158 vdda vdda) pmos1 l=180n w=1u m=1
	mpd12 (net13 inp net31 net31) pmos1 l=180n w=1u m=1
	mpb01 (net158 net158 vdda vdda) pmos1 l=180n w=1u m=1
ends OPAMP1_variant378

subckt OPAMP1_variant379 inn inp out pd xpd vdda vssa
	xd1 (vssa vdda) prim_nwd AREA=6.13907e-9 PJ=476.6e-6 m=1
	xi0 (vssa net69) prim_nd AREA=1e-12 PJ=4e-6 m=1
	xi3 (net51 vdda) prim_pd AREA=4.2e-09 PJ=4.9e-05 m=1
	xr0 (vssa vdda net51) prim_rdiffp l=2.1e-6 w=700e-9 m=1
	xr1 (vdda vdda net69) prim_rdiffp l=2.1e-6 w=700e-9 m=1
	xcc01 (net12 out) prim_cpoly c=1p m=1
	mnm12 (net13 net56 vssa vssa) nmos1 l=180n w=1u m=1
	mnm11 (net56 net56 vssa vssa) nmos1 l=180n w=1u m=1
	mnb02 (net27 net27 net21 vssa) nmos1 l=180n w=1u m=1
	mnpd1 (net21 xpd vssa vssa) nmos1 l=1.8e-07n w=1.7e-06u m=1
	mn001 (out net13 vssa vssa) nmos1 l=2.6e-07n w=1.2e-06u m=1
	mnpd2 (net13 pd vssa vssa) nmos1 l=180n w=1u m=1
	mnc01 (net13 net69 net12 vssa) nmos1 l=180n w=1u m=1
	mpb02 (net27 net51 net158 vdda) pmos1 l=180n w=1u m=1
	mppd1 (net158 xpd vdda vdda) pmos1 l=180n w=1u m=1
	mps11 (net31 net158 vdda vdda) pmos1 l=180n w=1u m=1
	mpd11 (net56 inn net31 net31) pmos1 l=180n w=1u m=1
	mp001 (out net158 vdda vdda) pmos1 l=180n w=1u m=1
	mpd12 (net13 inp net31 net31) pmos1 l=180n w=1u m=1
	mpb01 (net158 net158 vdda vdda) pmos1 l=180n w=1u m=1
ends OPAMP1_variant379

subckt OPAMP1_variant380 inn inp out pd xpd vdda vssa
	xd1 (vssa vdda) prim_nwd AREA=6.13907e-9 PJ=476.6e-6 m=1
	xi0 (vssa net69) prim_nd AREA=4.5e-09 PJ=4.6e-05 m=1
	xi3 (net51 vdda) prim_pd AREA=790e-15 PJ=3.3e-6 m=1
	xr0 (vssa vdda net51) prim_rdiffp l=2.1e-6 w=700e-9 m=1
	xr1 (vdda vdda net69) prim_rdiffp l=2.1e-6 w=700e-9 m=1
	xcc01 (net12 out) prim_cpoly c=1p m=1
	mnm12 (net13 net56 vssa vssa) nmos1 l=180n w=1u m=1
	mnm11 (net56 net56 vssa vssa) nmos1 l=180n w=1u m=1
	mnb02 (net27 net27 net21 vssa) nmos1 l=180n w=1u m=1
	mnpd1 (net21 xpd vssa vssa) nmos1 l=180n w=1u m=1
	mn001 (out net13 vssa vssa) nmos1 l=180n w=1u m=1
	mnpd2 (net13 pd vssa vssa) nmos1 l=180n w=1u m=1
	mnc01 (net13 net69 net12 vssa) nmos1 l=1.5e-07n w=8.1e-07u m=1
	mpb02 (net27 net51 net158 vdda) pmos1 l=180n w=1u m=1
	mppd1 (net158 xpd vdda vdda) pmos1 l=180n w=1u m=1
	mps11 (net31 net158 vdda vdda) pmos1 l=2.2e-07n w=6.3e-07u m=1
	mpd11 (net56 inn net31 net31) pmos1 l=180n w=1u m=1
	mp001 (out net158 vdda vdda) pmos1 l=180n w=1u m=1
	mpd12 (net13 inp net31 net31) pmos1 l=180n w=1u m=1
	mpb01 (net158 net158 vdda vdda) pmos1 l=180n w=1u m=1
ends OPAMP1_variant380

subckt OPAMP1_variant381 inn inp out pd xpd vdda vssa
	xd1 (vssa vdda) prim_nwd AREA=6.13907e-9 PJ=476.6e-6 m=1
	xi0 (vssa net69) prim_nd AREA=5.7e-09 PJ=5.7e-05 m=1
	xi3 (net51 vdda) prim_pd AREA=3.2e-09 PJ=9.9e-05 m=1
	xr0 (vssa vdda net51) prim_rdiffp l=2.1e-6 w=700e-9 m=1
	xr1 (vdda vdda net69) prim_rdiffp l=2.1e-6 w=700e-9 m=1
	xcc01 (net12 out) prim_cpoly c=1p m=1
	mnm12 (net13 net56 vssa vssa) nmos1 l=180n w=1u m=1
	mnm11 (net56 net56 vssa vssa) nmos1 l=1.6e-07n w=7.6e-07u m=1
	mnb02 (net27 net27 net21 vssa) nmos1 l=180n w=1u m=1
	mnpd1 (net21 xpd vssa vssa) nmos1 l=180n w=1u m=1
	mn001 (out net13 vssa vssa) nmos1 l=180n w=1u m=1
	mnpd2 (net13 pd vssa vssa) nmos1 l=180n w=1u m=1
	mnc01 (net13 net69 net12 vssa) nmos1 l=180n w=1u m=1
	mpb02 (net27 net51 net158 vdda) pmos1 l=180n w=1u m=1
	mppd1 (net158 xpd vdda vdda) pmos1 l=180n w=1u m=1
	mps11 (net31 net158 vdda vdda) pmos1 l=180n w=1u m=1
	mpd11 (net56 inn net31 net31) pmos1 l=180n w=1u m=1
	mp001 (out net158 vdda vdda) pmos1 l=180n w=1u m=1
	mpd12 (net13 inp net31 net31) pmos1 l=180n w=1u m=1
	mpb01 (net158 net158 vdda vdda) pmos1 l=180n w=1u m=1
ends OPAMP1_variant381

subckt OPAMP1_variant382 inn inp out pd xpd vdda vssa
	xd1 (vssa vdda) prim_nwd AREA=8.8e-09 PJ=3.6e-05 m=1
	xi0 (vssa net69) prim_nd AREA=1e-12 PJ=4e-6 m=1
	xi3 (net51 vdda) prim_pd AREA=790e-15 PJ=3.3e-6 m=1
	xr0 (vssa vdda net51) prim_rdiffp l=2.1e-6 w=700e-9 m=1
	xr1 (vdda vdda net69) prim_rdiffp l=2.1e-6 w=700e-9 m=1
	xcc01 (net12 out) prim_cpoly c=1p m=1
	mnm12 (net13 net56 vssa vssa) nmos1 l=180n w=1u m=1
	mnm11 (net56 net56 vssa vssa) nmos1 l=2.6e-07n w=7.5e-07u m=1
	mnb02 (net27 net27 net21 vssa) nmos1 l=180n w=1u m=1
	mnpd1 (net21 xpd vssa vssa) nmos1 l=180n w=1u m=1
	mn001 (out net13 vssa vssa) nmos1 l=180n w=1u m=1
	mnpd2 (net13 pd vssa vssa) nmos1 l=180n w=1u m=1
	mnc01 (net13 net69 net12 vssa) nmos1 l=180n w=1u m=1
	mpb02 (net27 net51 net158 vdda) pmos1 l=2.9e-07n w=2.0e-06u m=1
	mppd1 (net158 xpd vdda vdda) pmos1 l=180n w=1u m=1
	mps11 (net31 net158 vdda vdda) pmos1 l=180n w=1u m=1
	mpd11 (net56 inn net31 net31) pmos1 l=180n w=1u m=1
	mp001 (out net158 vdda vdda) pmos1 l=180n w=1u m=1
	mpd12 (net13 inp net31 net31) pmos1 l=180n w=1u m=1
	mpb01 (net158 net158 vdda vdda) pmos1 l=180n w=1u m=1
ends OPAMP1_variant382

subckt OPAMP1_variant383 inn inp out pd xpd vdda vssa
	xd1 (vssa vdda) prim_nwd AREA=6.13907e-9 PJ=476.6e-6 m=1
	xi0 (vssa net69) prim_nd AREA=1e-12 PJ=4e-6 m=1
	xi3 (net51 vdda) prim_pd AREA=5.0e-09 PJ=4.1e-05 m=1
	xr0 (vssa vdda net51) prim_rdiffp l=2.1e-6 w=700e-9 m=1
	xr1 (vdda vdda net69) prim_rdiffp l=2.1e-6 w=700e-9 m=1
	xcc01 (net12 out) prim_cpoly c=1p m=1
	mnm12 (net13 net56 vssa vssa) nmos1 l=1.3e-07n w=1.0e-06u m=1
	mnm11 (net56 net56 vssa vssa) nmos1 l=180n w=1u m=1
	mnb02 (net27 net27 net21 vssa) nmos1 l=180n w=1u m=1
	mnpd1 (net21 xpd vssa vssa) nmos1 l=180n w=1u m=1
	mn001 (out net13 vssa vssa) nmos1 l=180n w=1u m=1
	mnpd2 (net13 pd vssa vssa) nmos1 l=2.9e-07n w=1.3e-06u m=1
	mnc01 (net13 net69 net12 vssa) nmos1 l=180n w=1u m=1
	mpb02 (net27 net51 net158 vdda) pmos1 l=2.0e-07n w=1.8e-06u m=1
	mppd1 (net158 xpd vdda vdda) pmos1 l=2.4e-07n w=1.4e-06u m=1
	mps11 (net31 net158 vdda vdda) pmos1 l=180n w=1u m=1
	mpd11 (net56 inn net31 net31) pmos1 l=180n w=1u m=1
	mp001 (out net158 vdda vdda) pmos1 l=180n w=1u m=1
	mpd12 (net13 inp net31 net31) pmos1 l=180n w=1u m=1
	mpb01 (net158 net158 vdda vdda) pmos1 l=180n w=1u m=1
ends OPAMP1_variant383

subckt OPAMP1_variant384 inn inp out pd xpd vdda vssa
	xd1 (vssa vdda) prim_nwd AREA=6.13907e-9 PJ=476.6e-6 m=1
	xi0 (vssa net69) prim_nd AREA=4.6e-09 PJ=1.9e-05 m=1
	xi3 (net51 vdda) prim_pd AREA=2.6e-10 PJ=7.1e-05 m=1
	xr0 (vssa vdda net51) prim_rdiffp l=2.1e-6 w=700e-9 m=1
	xr1 (vdda vdda net69) prim_rdiffp l=2.1e-6 w=700e-9 m=1
	xcc01 (net12 out) prim_cpoly c=1.8e-12p m=1
	mnm12 (net13 net56 vssa vssa) nmos1 l=180n w=1u m=1
	mnm11 (net56 net56 vssa vssa) nmos1 l=1.7e-07n w=1.9e-06u m=1
	mnb02 (net27 net27 net21 vssa) nmos1 l=180n w=1u m=1
	mnpd1 (net21 xpd vssa vssa) nmos1 l=180n w=1u m=1
	mn001 (out net13 vssa vssa) nmos1 l=180n w=1u m=1
	mnpd2 (net13 pd vssa vssa) nmos1 l=180n w=1u m=1
	mnc01 (net13 net69 net12 vssa) nmos1 l=180n w=1u m=1
	mpb02 (net27 net51 net158 vdda) pmos1 l=180n w=1u m=1
	mppd1 (net158 xpd vdda vdda) pmos1 l=180n w=1u m=1
	mps11 (net31 net158 vdda vdda) pmos1 l=180n w=1u m=1
	mpd11 (net56 inn net31 net31) pmos1 l=1.1e-07n w=1.2e-06u m=1
	mp001 (out net158 vdda vdda) pmos1 l=180n w=1u m=1
	mpd12 (net13 inp net31 net31) pmos1 l=180n w=1u m=1
	mpb01 (net158 net158 vdda vdda) pmos1 l=180n w=1u m=1
ends OPAMP1_variant384

subckt OPAMP1_variant385 inn inp out pd xpd vdda vssa
	xd1 (vssa vdda) prim_nwd AREA=6.13907e-9 PJ=476.6e-6 m=1
	xi0 (vssa net69) prim_nd AREA=1e-12 PJ=4e-6 m=1
	xi3 (net51 vdda) prim_pd AREA=8.6e-09 PJ=6.0e-05 m=1
	xr0 (vssa vdda net51) prim_rdiffp l=2.1e-6 w=700e-9 m=1
	xr1 (vdda vdda net69) prim_rdiffp l=2.1e-6 w=700e-9 m=1
	xcc01 (net12 out) prim_cpoly c=1p m=1
	mnm12 (net13 net56 vssa vssa) nmos1 l=180n w=1u m=1
	mnm11 (net56 net56 vssa vssa) nmos1 l=180n w=1u m=1
	mnb02 (net27 net27 net21 vssa) nmos1 l=1.1e-07n w=5.8e-07u m=1
	mnpd1 (net21 xpd vssa vssa) nmos1 l=1.7e-07n w=8.1e-07u m=1
	mn001 (out net13 vssa vssa) nmos1 l=180n w=1u m=1
	mnpd2 (net13 pd vssa vssa) nmos1 l=180n w=1u m=1
	mnc01 (net13 net69 net12 vssa) nmos1 l=180n w=1u m=1
	mpb02 (net27 net51 net158 vdda) pmos1 l=180n w=1u m=1
	mppd1 (net158 xpd vdda vdda) pmos1 l=180n w=1u m=1
	mps11 (net31 net158 vdda vdda) pmos1 l=180n w=1u m=1
	mpd11 (net56 inn net31 net31) pmos1 l=180n w=1u m=1
	mp001 (out net158 vdda vdda) pmos1 l=1.1e-07n w=1.7e-06u m=1
	mpd12 (net13 inp net31 net31) pmos1 l=180n w=1u m=1
	mpb01 (net158 net158 vdda vdda) pmos1 l=2.3e-07n w=1.2e-06u m=1
ends OPAMP1_variant385

subckt OPAMP1_variant386 inn inp out pd xpd vdda vssa
	xd1 (vssa vdda) prim_nwd AREA=6.13907e-9 PJ=476.6e-6 m=1
	xi0 (vssa net69) prim_nd AREA=1e-12 PJ=4e-6 m=1
	xi3 (net51 vdda) prim_pd AREA=2.7e-09 PJ=6.5e-05 m=1
	xr0 (vssa vdda net51) prim_rdiffp l=2.1e-6 w=700e-9 m=1
	xr1 (vdda vdda net69) prim_rdiffp l=2.1e-6 w=700e-9 m=1
	xcc01 (net12 out) prim_cpoly c=1p m=1
	mnm12 (net13 net56 vssa vssa) nmos1 l=180n w=1u m=1
	mnm11 (net56 net56 vssa vssa) nmos1 l=180n w=1u m=1
	mnb02 (net27 net27 net21 vssa) nmos1 l=180n w=1u m=1
	mnpd1 (net21 xpd vssa vssa) nmos1 l=180n w=1u m=1
	mn001 (out net13 vssa vssa) nmos1 l=180n w=1u m=1
	mnpd2 (net13 pd vssa vssa) nmos1 l=180n w=1u m=1
	mnc01 (net13 net69 net12 vssa) nmos1 l=1.7e-07n w=6.2e-07u m=1
	mpb02 (net27 net51 net158 vdda) pmos1 l=180n w=1u m=1
	mppd1 (net158 xpd vdda vdda) pmos1 l=180n w=1u m=1
	mps11 (net31 net158 vdda vdda) pmos1 l=180n w=1u m=1
	mpd11 (net56 inn net31 net31) pmos1 l=180n w=1u m=1
	mp001 (out net158 vdda vdda) pmos1 l=180n w=1u m=1
	mpd12 (net13 inp net31 net31) pmos1 l=2.7e-07n w=1.1e-06u m=1
	mpb01 (net158 net158 vdda vdda) pmos1 l=180n w=1u m=1
ends OPAMP1_variant386

subckt OPAMP1_variant387 inn inp out pd xpd vdda vssa
	xd1 (vssa vdda) prim_nwd AREA=6.13907e-9 PJ=476.6e-6 m=1
	xi0 (vssa net69) prim_nd AREA=4.8e-10 PJ=1.1e-05 m=1
	xi3 (net51 vdda) prim_pd AREA=4.4e-09 PJ=2.2e-05 m=1
	xr0 (vssa vdda net51) prim_rdiffp l=2.8e-07 w=8.8e-07 m=1
	xr1 (vdda vdda net69) prim_rdiffp l=2.1e-6 w=700e-9 m=1
	xcc01 (net12 out) prim_cpoly c=1p m=1
	mnm12 (net13 net56 vssa vssa) nmos1 l=180n w=1u m=1
	mnm11 (net56 net56 vssa vssa) nmos1 l=180n w=1u m=1
	mnb02 (net27 net27 net21 vssa) nmos1 l=180n w=1u m=1
	mnpd1 (net21 xpd vssa vssa) nmos1 l=180n w=1u m=1
	mn001 (out net13 vssa vssa) nmos1 l=180n w=1u m=1
	mnpd2 (net13 pd vssa vssa) nmos1 l=180n w=1u m=1
	mnc01 (net13 net69 net12 vssa) nmos1 l=180n w=1u m=1
	mpb02 (net27 net51 net158 vdda) pmos1 l=180n w=1u m=1
	mppd1 (net158 xpd vdda vdda) pmos1 l=180n w=1u m=1
	mps11 (net31 net158 vdda vdda) pmos1 l=180n w=1u m=1
	mpd11 (net56 inn net31 net31) pmos1 l=1.3e-07n w=1.9e-06u m=1
	mp001 (out net158 vdda vdda) pmos1 l=180n w=1u m=1
	mpd12 (net13 inp net31 net31) pmos1 l=1.6e-07n w=1.5e-06u m=1
	mpb01 (net158 net158 vdda vdda) pmos1 l=180n w=1u m=1
ends OPAMP1_variant387

subckt OPAMP1_variant388 inn inp out pd xpd vdda vssa
	xd1 (vssa vdda) prim_nwd AREA=6.13907e-9 PJ=476.6e-6 m=1
	xi0 (vssa net69) prim_nd AREA=1e-12 PJ=4e-6 m=1
	xi3 (net51 vdda) prim_pd AREA=790e-15 PJ=3.3e-6 m=1
	xr0 (vssa vdda net51) prim_rdiffp l=1.5e-07 w=9.5e-07 m=1
	xr1 (vdda vdda net69) prim_rdiffp l=2.1e-6 w=700e-9 m=1
	xcc01 (net12 out) prim_cpoly c=1p m=1
	mnm12 (net13 net56 vssa vssa) nmos1 l=180n w=1u m=1
	mnm11 (net56 net56 vssa vssa) nmos1 l=180n w=1u m=1
	mnb02 (net27 net27 net21 vssa) nmos1 l=180n w=1u m=1
	mnpd1 (net21 xpd vssa vssa) nmos1 l=180n w=1u m=1
	mn001 (out net13 vssa vssa) nmos1 l=180n w=1u m=1
	mnpd2 (net13 pd vssa vssa) nmos1 l=180n w=1u m=1
	mnc01 (net13 net69 net12 vssa) nmos1 l=180n w=1u m=1
	mpb02 (net27 net51 net158 vdda) pmos1 l=180n w=1u m=1
	mppd1 (net158 xpd vdda vdda) pmos1 l=180n w=1u m=1
	mps11 (net31 net158 vdda vdda) pmos1 l=180n w=1u m=1
	mpd11 (net56 inn net31 net31) pmos1 l=180n w=1u m=1
	mp001 (out net158 vdda vdda) pmos1 l=180n w=1u m=1
	mpd12 (net13 inp net31 net31) pmos1 l=180n w=1u m=1
	mpb01 (net158 net158 vdda vdda) pmos1 l=2.9e-07n w=1.7e-06u m=1
ends OPAMP1_variant388

subckt OPAMP1_variant389 inn inp out pd xpd vdda vssa
	xd1 (vssa vdda) prim_nwd AREA=6.13907e-9 PJ=476.6e-6 m=1
	xi0 (vssa net69) prim_nd AREA=1e-12 PJ=4e-6 m=1
	xi3 (net51 vdda) prim_pd AREA=790e-15 PJ=3.3e-6 m=1
	xr0 (vssa vdda net51) prim_rdiffp l=2.1e-6 w=700e-9 m=1
	xr1 (vdda vdda net69) prim_rdiffp l=2.1e-6 w=700e-9 m=1
	xcc01 (net12 out) prim_cpoly c=1p m=1
	mnm12 (net13 net56 vssa vssa) nmos1 l=180n w=1u m=1
	mnm11 (net56 net56 vssa vssa) nmos1 l=180n w=1u m=1
	mnb02 (net27 net27 net21 vssa) nmos1 l=180n w=1u m=1
	mnpd1 (net21 xpd vssa vssa) nmos1 l=180n w=1u m=1
	mn001 (out net13 vssa vssa) nmos1 l=180n w=1u m=1
	mnpd2 (net13 pd vssa vssa) nmos1 l=180n w=1u m=1
	mnc01 (net13 net69 net12 vssa) nmos1 l=180n w=1u m=1
	mpb02 (net27 net51 net158 vdda) pmos1 l=180n w=1u m=1
	mppd1 (net158 xpd vdda vdda) pmos1 l=180n w=1u m=1
	mps11 (net31 net158 vdda vdda) pmos1 l=2.0e-07n w=1.8e-06u m=1
	mpd11 (net56 inn net31 net31) pmos1 l=180n w=1u m=1
	mp001 (out net158 vdda vdda) pmos1 l=180n w=1u m=1
	mpd12 (net13 inp net31 net31) pmos1 l=1.2e-07n w=1.7e-06u m=1
	mpb01 (net158 net158 vdda vdda) pmos1 l=180n w=1u m=1
ends OPAMP1_variant389

subckt OPAMP1_variant390 inn inp out pd xpd vdda vssa
	xd1 (vssa vdda) prim_nwd AREA=6.13907e-9 PJ=476.6e-6 m=1
	xi0 (vssa net69) prim_nd AREA=1e-12 PJ=4e-6 m=1
	xi3 (net51 vdda) prim_pd AREA=790e-15 PJ=3.3e-6 m=1
	xr0 (vssa vdda net51) prim_rdiffp l=2.1e-6 w=700e-9 m=1
	xr1 (vdda vdda net69) prim_rdiffp l=2.1e-6 w=700e-9 m=1
	xcc01 (net12 out) prim_cpoly c=1p m=1
	mnm12 (net13 net56 vssa vssa) nmos1 l=180n w=1u m=1
	mnm11 (net56 net56 vssa vssa) nmos1 l=180n w=1u m=1
	mnb02 (net27 net27 net21 vssa) nmos1 l=180n w=1u m=1
	mnpd1 (net21 xpd vssa vssa) nmos1 l=180n w=1u m=1
	mn001 (out net13 vssa vssa) nmos1 l=180n w=1u m=1
	mnpd2 (net13 pd vssa vssa) nmos1 l=180n w=1u m=1
	mnc01 (net13 net69 net12 vssa) nmos1 l=180n w=1u m=1
	mpb02 (net27 net51 net158 vdda) pmos1 l=180n w=1u m=1
	mppd1 (net158 xpd vdda vdda) pmos1 l=1.8e-07n w=5.3e-07u m=1
	mps11 (net31 net158 vdda vdda) pmos1 l=180n w=1u m=1
	mpd11 (net56 inn net31 net31) pmos1 l=180n w=1u m=1
	mp001 (out net158 vdda vdda) pmos1 l=180n w=1u m=1
	mpd12 (net13 inp net31 net31) pmos1 l=180n w=1u m=1
	mpb01 (net158 net158 vdda vdda) pmos1 l=2.8e-07n w=1.6e-06u m=1
ends OPAMP1_variant390

subckt OPAMP1_variant391 inn inp out pd xpd vdda vssa
	xd1 (vssa vdda) prim_nwd AREA=5.3e-09 PJ=4.6e-06 m=1
	xi0 (vssa net69) prim_nd AREA=1e-12 PJ=4e-6 m=1
	xi3 (net51 vdda) prim_pd AREA=790e-15 PJ=3.3e-6 m=1
	xr0 (vssa vdda net51) prim_rdiffp l=2.1e-6 w=700e-9 m=1
	xr1 (vdda vdda net69) prim_rdiffp l=2.1e-6 w=700e-9 m=1
	xcc01 (net12 out) prim_cpoly c=1.2e-12p m=1
	mnm12 (net13 net56 vssa vssa) nmos1 l=2.9e-07n w=6.3e-07u m=1
	mnm11 (net56 net56 vssa vssa) nmos1 l=1.3e-07n w=5.5e-07u m=1
	mnb02 (net27 net27 net21 vssa) nmos1 l=180n w=1u m=1
	mnpd1 (net21 xpd vssa vssa) nmos1 l=1.4e-07n w=1.6e-06u m=1
	mn001 (out net13 vssa vssa) nmos1 l=180n w=1u m=1
	mnpd2 (net13 pd vssa vssa) nmos1 l=180n w=1u m=1
	mnc01 (net13 net69 net12 vssa) nmos1 l=180n w=1u m=1
	mpb02 (net27 net51 net158 vdda) pmos1 l=180n w=1u m=1
	mppd1 (net158 xpd vdda vdda) pmos1 l=180n w=1u m=1
	mps11 (net31 net158 vdda vdda) pmos1 l=180n w=1u m=1
	mpd11 (net56 inn net31 net31) pmos1 l=180n w=1u m=1
	mp001 (out net158 vdda vdda) pmos1 l=180n w=1u m=1
	mpd12 (net13 inp net31 net31) pmos1 l=180n w=1u m=1
	mpb01 (net158 net158 vdda vdda) pmos1 l=180n w=1u m=1
ends OPAMP1_variant391

subckt OPAMP1_variant392 inn inp out pd xpd vdda vssa
	xd1 (vssa vdda) prim_nwd AREA=6.13907e-9 PJ=476.6e-6 m=1
	xi0 (vssa net69) prim_nd AREA=9.7e-09 PJ=7.4e-05 m=1
	xi3 (net51 vdda) prim_pd AREA=790e-15 PJ=3.3e-6 m=1
	xr0 (vssa vdda net51) prim_rdiffp l=2.1e-6 w=700e-9 m=1
	xr1 (vdda vdda net69) prim_rdiffp l=2.1e-6 w=700e-9 m=1
	xcc01 (net12 out) prim_cpoly c=1p m=1
	mnm12 (net13 net56 vssa vssa) nmos1 l=180n w=1u m=1
	mnm11 (net56 net56 vssa vssa) nmos1 l=180n w=1u m=1
	mnb02 (net27 net27 net21 vssa) nmos1 l=180n w=1u m=1
	mnpd1 (net21 xpd vssa vssa) nmos1 l=180n w=1u m=1
	mn001 (out net13 vssa vssa) nmos1 l=180n w=1u m=1
	mnpd2 (net13 pd vssa vssa) nmos1 l=180n w=1u m=1
	mnc01 (net13 net69 net12 vssa) nmos1 l=1.6e-07n w=1.3e-06u m=1
	mpb02 (net27 net51 net158 vdda) pmos1 l=1.9e-07n w=1.1e-06u m=1
	mppd1 (net158 xpd vdda vdda) pmos1 l=180n w=1u m=1
	mps11 (net31 net158 vdda vdda) pmos1 l=180n w=1u m=1
	mpd11 (net56 inn net31 net31) pmos1 l=180n w=1u m=1
	mp001 (out net158 vdda vdda) pmos1 l=180n w=1u m=1
	mpd12 (net13 inp net31 net31) pmos1 l=2.8e-07n w=1.5e-06u m=1
	mpb01 (net158 net158 vdda vdda) pmos1 l=180n w=1u m=1
ends OPAMP1_variant392

subckt OPAMP1_variant393 inn inp out pd xpd vdda vssa
	xd1 (vssa vdda) prim_nwd AREA=6.13907e-9 PJ=476.6e-6 m=1
	xi0 (vssa net69) prim_nd AREA=1e-12 PJ=4e-6 m=1
	xi3 (net51 vdda) prim_pd AREA=790e-15 PJ=3.3e-6 m=1
	xr0 (vssa vdda net51) prim_rdiffp l=2.1e-6 w=700e-9 m=1
	xr1 (vdda vdda net69) prim_rdiffp l=1.2e-07 w=1.7e-06 m=1
	xcc01 (net12 out) prim_cpoly c=1p m=1
	mnm12 (net13 net56 vssa vssa) nmos1 l=180n w=1u m=1
	mnm11 (net56 net56 vssa vssa) nmos1 l=1.3e-07n w=8.8e-07u m=1
	mnb02 (net27 net27 net21 vssa) nmos1 l=180n w=1u m=1
	mnpd1 (net21 xpd vssa vssa) nmos1 l=180n w=1u m=1
	mn001 (out net13 vssa vssa) nmos1 l=2.6e-07n w=1.0e-06u m=1
	mnpd2 (net13 pd vssa vssa) nmos1 l=180n w=1u m=1
	mnc01 (net13 net69 net12 vssa) nmos1 l=180n w=1u m=1
	mpb02 (net27 net51 net158 vdda) pmos1 l=180n w=1u m=1
	mppd1 (net158 xpd vdda vdda) pmos1 l=180n w=1u m=1
	mps11 (net31 net158 vdda vdda) pmos1 l=180n w=1u m=1
	mpd11 (net56 inn net31 net31) pmos1 l=180n w=1u m=1
	mp001 (out net158 vdda vdda) pmos1 l=180n w=1u m=1
	mpd12 (net13 inp net31 net31) pmos1 l=180n w=1u m=1
	mpb01 (net158 net158 vdda vdda) pmos1 l=180n w=1u m=1
ends OPAMP1_variant393

subckt OPAMP1_variant394 inn inp out pd xpd vdda vssa
	xd1 (vssa vdda) prim_nwd AREA=6.13907e-9 PJ=476.6e-6 m=1
	xi0 (vssa net69) prim_nd AREA=1e-12 PJ=4e-6 m=1
	xi3 (net51 vdda) prim_pd AREA=790e-15 PJ=3.3e-6 m=1
	xr0 (vssa vdda net51) prim_rdiffp l=2.9e-07 w=1.5e-06 m=1
	xr1 (vdda vdda net69) prim_rdiffp l=2.1e-6 w=700e-9 m=1
	xcc01 (net12 out) prim_cpoly c=1p m=1
	mnm12 (net13 net56 vssa vssa) nmos1 l=180n w=1u m=1
	mnm11 (net56 net56 vssa vssa) nmos1 l=1.4e-07n w=5.7e-07u m=1
	mnb02 (net27 net27 net21 vssa) nmos1 l=180n w=1u m=1
	mnpd1 (net21 xpd vssa vssa) nmos1 l=180n w=1u m=1
	mn001 (out net13 vssa vssa) nmos1 l=180n w=1u m=1
	mnpd2 (net13 pd vssa vssa) nmos1 l=1.9e-07n w=1.1e-06u m=1
	mnc01 (net13 net69 net12 vssa) nmos1 l=180n w=1u m=1
	mpb02 (net27 net51 net158 vdda) pmos1 l=180n w=1u m=1
	mppd1 (net158 xpd vdda vdda) pmos1 l=180n w=1u m=1
	mps11 (net31 net158 vdda vdda) pmos1 l=180n w=1u m=1
	mpd11 (net56 inn net31 net31) pmos1 l=180n w=1u m=1
	mp001 (out net158 vdda vdda) pmos1 l=180n w=1u m=1
	mpd12 (net13 inp net31 net31) pmos1 l=180n w=1u m=1
	mpb01 (net158 net158 vdda vdda) pmos1 l=180n w=1u m=1
ends OPAMP1_variant394

subckt OPAMP1_variant395 inn inp out pd xpd vdda vssa
	xd1 (vssa vdda) prim_nwd AREA=6.13907e-9 PJ=476.6e-6 m=1
	xi0 (vssa net69) prim_nd AREA=1e-12 PJ=4e-6 m=1
	xi3 (net51 vdda) prim_pd AREA=9.7e-09 PJ=1.8e-05 m=1
	xr0 (vssa vdda net51) prim_rdiffp l=2.1e-6 w=700e-9 m=1
	xr1 (vdda vdda net69) prim_rdiffp l=2.1e-6 w=700e-9 m=1
	xcc01 (net12 out) prim_cpoly c=1p m=1
	mnm12 (net13 net56 vssa vssa) nmos1 l=180n w=1u m=1
	mnm11 (net56 net56 vssa vssa) nmos1 l=180n w=1u m=1
	mnb02 (net27 net27 net21 vssa) nmos1 l=1.4e-07n w=1.4e-06u m=1
	mnpd1 (net21 xpd vssa vssa) nmos1 l=180n w=1u m=1
	mn001 (out net13 vssa vssa) nmos1 l=180n w=1u m=1
	mnpd2 (net13 pd vssa vssa) nmos1 l=2.3e-07n w=8.4e-07u m=1
	mnc01 (net13 net69 net12 vssa) nmos1 l=180n w=1u m=1
	mpb02 (net27 net51 net158 vdda) pmos1 l=180n w=1u m=1
	mppd1 (net158 xpd vdda vdda) pmos1 l=180n w=1u m=1
	mps11 (net31 net158 vdda vdda) pmos1 l=180n w=1u m=1
	mpd11 (net56 inn net31 net31) pmos1 l=180n w=1u m=1
	mp001 (out net158 vdda vdda) pmos1 l=180n w=1u m=1
	mpd12 (net13 inp net31 net31) pmos1 l=180n w=1u m=1
	mpb01 (net158 net158 vdda vdda) pmos1 l=180n w=1u m=1
ends OPAMP1_variant395

subckt OPAMP1_variant396 inn inp out pd xpd vdda vssa
	xd1 (vssa vdda) prim_nwd AREA=3.1e-09 PJ=5.3e-05 m=1
	xi0 (vssa net69) prim_nd AREA=1e-12 PJ=4e-6 m=1
	xi3 (net51 vdda) prim_pd AREA=790e-15 PJ=3.3e-6 m=1
	xr0 (vssa vdda net51) prim_rdiffp l=2.1e-6 w=700e-9 m=1
	xr1 (vdda vdda net69) prim_rdiffp l=2.1e-6 w=700e-9 m=1
	xcc01 (net12 out) prim_cpoly c=1p m=1
	mnm12 (net13 net56 vssa vssa) nmos1 l=180n w=1u m=1
	mnm11 (net56 net56 vssa vssa) nmos1 l=180n w=1u m=1
	mnb02 (net27 net27 net21 vssa) nmos1 l=180n w=1u m=1
	mnpd1 (net21 xpd vssa vssa) nmos1 l=180n w=1u m=1
	mn001 (out net13 vssa vssa) nmos1 l=180n w=1u m=1
	mnpd2 (net13 pd vssa vssa) nmos1 l=180n w=1u m=1
	mnc01 (net13 net69 net12 vssa) nmos1 l=180n w=1u m=1
	mpb02 (net27 net51 net158 vdda) pmos1 l=180n w=1u m=1
	mppd1 (net158 xpd vdda vdda) pmos1 l=180n w=1u m=1
	mps11 (net31 net158 vdda vdda) pmos1 l=180n w=1u m=1
	mpd11 (net56 inn net31 net31) pmos1 l=180n w=1u m=1
	mp001 (out net158 vdda vdda) pmos1 l=2.6e-07n w=1.8e-06u m=1
	mpd12 (net13 inp net31 net31) pmos1 l=180n w=1u m=1
	mpb01 (net158 net158 vdda vdda) pmos1 l=180n w=1u m=1
ends OPAMP1_variant396

subckt OPAMP1_variant397 inn inp out pd xpd vdda vssa
	xd1 (vssa vdda) prim_nwd AREA=6.13907e-9 PJ=476.6e-6 m=1
	xi0 (vssa net69) prim_nd AREA=2.4e-09 PJ=9.5e-05 m=1
	xi3 (net51 vdda) prim_pd AREA=790e-15 PJ=3.3e-6 m=1
	xr0 (vssa vdda net51) prim_rdiffp l=2.1e-6 w=700e-9 m=1
	xr1 (vdda vdda net69) prim_rdiffp l=2.1e-6 w=700e-9 m=1
	xcc01 (net12 out) prim_cpoly c=1p m=1
	mnm12 (net13 net56 vssa vssa) nmos1 l=180n w=1u m=1
	mnm11 (net56 net56 vssa vssa) nmos1 l=1.2e-07n w=1.1e-06u m=1
	mnb02 (net27 net27 net21 vssa) nmos1 l=180n w=1u m=1
	mnpd1 (net21 xpd vssa vssa) nmos1 l=180n w=1u m=1
	mn001 (out net13 vssa vssa) nmos1 l=180n w=1u m=1
	mnpd2 (net13 pd vssa vssa) nmos1 l=180n w=1u m=1
	mnc01 (net13 net69 net12 vssa) nmos1 l=2.8e-07n w=1.9e-06u m=1
	mpb02 (net27 net51 net158 vdda) pmos1 l=180n w=1u m=1
	mppd1 (net158 xpd vdda vdda) pmos1 l=1.6e-07n w=1.5e-06u m=1
	mps11 (net31 net158 vdda vdda) pmos1 l=180n w=1u m=1
	mpd11 (net56 inn net31 net31) pmos1 l=180n w=1u m=1
	mp001 (out net158 vdda vdda) pmos1 l=180n w=1u m=1
	mpd12 (net13 inp net31 net31) pmos1 l=180n w=1u m=1
	mpb01 (net158 net158 vdda vdda) pmos1 l=1.8e-07n w=1.1e-06u m=1
ends OPAMP1_variant397

subckt OPAMP1_variant398 inn inp out pd xpd vdda vssa
	xd1 (vssa vdda) prim_nwd AREA=6.13907e-9 PJ=476.6e-6 m=1
	xi0 (vssa net69) prim_nd AREA=1e-12 PJ=4e-6 m=1
	xi3 (net51 vdda) prim_pd AREA=3.6e-09 PJ=5.7e-05 m=1
	xr0 (vssa vdda net51) prim_rdiffp l=2.1e-6 w=700e-9 m=1
	xr1 (vdda vdda net69) prim_rdiffp l=2.1e-6 w=700e-9 m=1
	xcc01 (net12 out) prim_cpoly c=1p m=1
	mnm12 (net13 net56 vssa vssa) nmos1 l=180n w=1u m=1
	mnm11 (net56 net56 vssa vssa) nmos1 l=180n w=1u m=1
	mnb02 (net27 net27 net21 vssa) nmos1 l=2.9e-07n w=1.6e-06u m=1
	mnpd1 (net21 xpd vssa vssa) nmos1 l=180n w=1u m=1
	mn001 (out net13 vssa vssa) nmos1 l=1.1e-07n w=1.6e-06u m=1
	mnpd2 (net13 pd vssa vssa) nmos1 l=1.6e-07n w=1.2e-06u m=1
	mnc01 (net13 net69 net12 vssa) nmos1 l=180n w=1u m=1
	mpb02 (net27 net51 net158 vdda) pmos1 l=180n w=1u m=1
	mppd1 (net158 xpd vdda vdda) pmos1 l=180n w=1u m=1
	mps11 (net31 net158 vdda vdda) pmos1 l=180n w=1u m=1
	mpd11 (net56 inn net31 net31) pmos1 l=2.8e-07n w=1.1e-06u m=1
	mp001 (out net158 vdda vdda) pmos1 l=180n w=1u m=1
	mpd12 (net13 inp net31 net31) pmos1 l=180n w=1u m=1
	mpb01 (net158 net158 vdda vdda) pmos1 l=180n w=1u m=1
ends OPAMP1_variant398

subckt OPAMP1_variant399 inn inp out pd xpd vdda vssa
	xd1 (vssa vdda) prim_nwd AREA=6.13907e-9 PJ=476.6e-6 m=1
	xi0 (vssa net69) prim_nd AREA=1e-12 PJ=4e-6 m=1
	xi3 (net51 vdda) prim_pd AREA=790e-15 PJ=3.3e-6 m=1
	xr0 (vssa vdda net51) prim_rdiffp l=2.9e-07 w=1.3e-06 m=1
	xr1 (vdda vdda net69) prim_rdiffp l=2.4e-07 w=1.9e-06 m=1
	xcc01 (net12 out) prim_cpoly c=1p m=1
	mnm12 (net13 net56 vssa vssa) nmos1 l=180n w=1u m=1
	mnm11 (net56 net56 vssa vssa) nmos1 l=180n w=1u m=1
	mnb02 (net27 net27 net21 vssa) nmos1 l=180n w=1u m=1
	mnpd1 (net21 xpd vssa vssa) nmos1 l=180n w=1u m=1
	mn001 (out net13 vssa vssa) nmos1 l=180n w=1u m=1
	mnpd2 (net13 pd vssa vssa) nmos1 l=180n w=1u m=1
	mnc01 (net13 net69 net12 vssa) nmos1 l=180n w=1u m=1
	mpb02 (net27 net51 net158 vdda) pmos1 l=180n w=1u m=1
	mppd1 (net158 xpd vdda vdda) pmos1 l=1.7e-07n w=1.2e-06u m=1
	mps11 (net31 net158 vdda vdda) pmos1 l=180n w=1u m=1
	mpd11 (net56 inn net31 net31) pmos1 l=180n w=1u m=1
	mp001 (out net158 vdda vdda) pmos1 l=180n w=1u m=1
	mpd12 (net13 inp net31 net31) pmos1 l=180n w=1u m=1
	mpb01 (net158 net158 vdda vdda) pmos1 l=180n w=1u m=1
ends OPAMP1_variant399

subckt OPAMP1_variant400 inn inp out pd xpd vdda vssa
	xd1 (vssa vdda) prim_nwd AREA=6.13907e-9 PJ=476.6e-6 m=1
	xi0 (vssa net69) prim_nd AREA=4.5e-09 PJ=2.6e-05 m=1
	xi3 (net51 vdda) prim_pd AREA=5.3e-09 PJ=5.0e-05 m=1
	xr0 (vssa vdda net51) prim_rdiffp l=2.1e-6 w=700e-9 m=1
	xr1 (vdda vdda net69) prim_rdiffp l=2.1e-6 w=700e-9 m=1
	xcc01 (net12 out) prim_cpoly c=1p m=1
	mnm12 (net13 net56 vssa vssa) nmos1 l=1.6e-07n w=9.2e-07u m=1
	mnm11 (net56 net56 vssa vssa) nmos1 l=180n w=1u m=1
	mnb02 (net27 net27 net21 vssa) nmos1 l=180n w=1u m=1
	mnpd1 (net21 xpd vssa vssa) nmos1 l=180n w=1u m=1
	mn001 (out net13 vssa vssa) nmos1 l=180n w=1u m=1
	mnpd2 (net13 pd vssa vssa) nmos1 l=180n w=1u m=1
	mnc01 (net13 net69 net12 vssa) nmos1 l=180n w=1u m=1
	mpb02 (net27 net51 net158 vdda) pmos1 l=180n w=1u m=1
	mppd1 (net158 xpd vdda vdda) pmos1 l=180n w=1u m=1
	mps11 (net31 net158 vdda vdda) pmos1 l=180n w=1u m=1
	mpd11 (net56 inn net31 net31) pmos1 l=180n w=1u m=1
	mp001 (out net158 vdda vdda) pmos1 l=180n w=1u m=1
	mpd12 (net13 inp net31 net31) pmos1 l=180n w=1u m=1
	mpb01 (net158 net158 vdda vdda) pmos1 l=180n w=1u m=1
ends OPAMP1_variant400

subckt OPAMP1_variant401 inn inp out pd xpd vdda vssa
	xd1 (vssa vdda) prim_nwd AREA=6.13907e-9 PJ=476.6e-6 m=1
	xi0 (vssa net69) prim_nd AREA=1e-12 PJ=4e-6 m=1
	xi3 (net51 vdda) prim_pd AREA=790e-15 PJ=3.3e-6 m=1
	xr0 (vssa vdda net51) prim_rdiffp l=2.1e-6 w=700e-9 m=1
	xr1 (vdda vdda net69) prim_rdiffp l=2.1e-6 w=700e-9 m=1
	xcc01 (net12 out) prim_cpoly c=1p m=1
	mnm12 (net13 net56 vssa vssa) nmos1 l=180n w=1u m=1
	mnm11 (net56 net56 vssa vssa) nmos1 l=180n w=1u m=1
	mnb02 (net27 net27 net21 vssa) nmos1 l=2.8e-07n w=9.8e-07u m=1
	mnpd1 (net21 xpd vssa vssa) nmos1 l=180n w=1u m=1
	mn001 (out net13 vssa vssa) nmos1 l=180n w=1u m=1
	mnpd2 (net13 pd vssa vssa) nmos1 l=180n w=1u m=1
	mnc01 (net13 net69 net12 vssa) nmos1 l=180n w=1u m=1
	mpb02 (net27 net51 net158 vdda) pmos1 l=1.9e-07n w=6.0e-07u m=1
	mppd1 (net158 xpd vdda vdda) pmos1 l=180n w=1u m=1
	mps11 (net31 net158 vdda vdda) pmos1 l=2.9e-07n w=1.9e-06u m=1
	mpd11 (net56 inn net31 net31) pmos1 l=180n w=1u m=1
	mp001 (out net158 vdda vdda) pmos1 l=180n w=1u m=1
	mpd12 (net13 inp net31 net31) pmos1 l=180n w=1u m=1
	mpb01 (net158 net158 vdda vdda) pmos1 l=180n w=1u m=1
ends OPAMP1_variant401

subckt OPAMP1_variant402 inn inp out pd xpd vdda vssa
	xd1 (vssa vdda) prim_nwd AREA=6.13907e-9 PJ=476.6e-6 m=1
	xi0 (vssa net69) prim_nd AREA=1e-12 PJ=4e-6 m=1
	xi3 (net51 vdda) prim_pd AREA=7.3e-09 PJ=4.9e-05 m=1
	xr0 (vssa vdda net51) prim_rdiffp l=2.1e-6 w=700e-9 m=1
	xr1 (vdda vdda net69) prim_rdiffp l=2.1e-6 w=700e-9 m=1
	xcc01 (net12 out) prim_cpoly c=1p m=1
	mnm12 (net13 net56 vssa vssa) nmos1 l=180n w=1u m=1
	mnm11 (net56 net56 vssa vssa) nmos1 l=180n w=1u m=1
	mnb02 (net27 net27 net21 vssa) nmos1 l=180n w=1u m=1
	mnpd1 (net21 xpd vssa vssa) nmos1 l=180n w=1u m=1
	mn001 (out net13 vssa vssa) nmos1 l=180n w=1u m=1
	mnpd2 (net13 pd vssa vssa) nmos1 l=180n w=1u m=1
	mnc01 (net13 net69 net12 vssa) nmos1 l=180n w=1u m=1
	mpb02 (net27 net51 net158 vdda) pmos1 l=180n w=1u m=1
	mppd1 (net158 xpd vdda vdda) pmos1 l=180n w=1u m=1
	mps11 (net31 net158 vdda vdda) pmos1 l=180n w=1u m=1
	mpd11 (net56 inn net31 net31) pmos1 l=180n w=1u m=1
	mp001 (out net158 vdda vdda) pmos1 l=2.1e-07n w=9.0e-07u m=1
	mpd12 (net13 inp net31 net31) pmos1 l=180n w=1u m=1
	mpb01 (net158 net158 vdda vdda) pmos1 l=180n w=1u m=1
ends OPAMP1_variant402

subckt OPAMP1_variant403 inn inp out pd xpd vdda vssa
	xd1 (vssa vdda) prim_nwd AREA=6.13907e-9 PJ=476.6e-6 m=1
	xi0 (vssa net69) prim_nd AREA=9.7e-09 PJ=8.4e-05 m=1
	xi3 (net51 vdda) prim_pd AREA=790e-15 PJ=3.3e-6 m=1
	xr0 (vssa vdda net51) prim_rdiffp l=2.1e-6 w=700e-9 m=1
	xr1 (vdda vdda net69) prim_rdiffp l=2.1e-6 w=700e-9 m=1
	xcc01 (net12 out) prim_cpoly c=1p m=1
	mnm12 (net13 net56 vssa vssa) nmos1 l=180n w=1u m=1
	mnm11 (net56 net56 vssa vssa) nmos1 l=2.0e-07n w=6.0e-07u m=1
	mnb02 (net27 net27 net21 vssa) nmos1 l=180n w=1u m=1
	mnpd1 (net21 xpd vssa vssa) nmos1 l=180n w=1u m=1
	mn001 (out net13 vssa vssa) nmos1 l=180n w=1u m=1
	mnpd2 (net13 pd vssa vssa) nmos1 l=180n w=1u m=1
	mnc01 (net13 net69 net12 vssa) nmos1 l=180n w=1u m=1
	mpb02 (net27 net51 net158 vdda) pmos1 l=1.9e-07n w=5.2e-07u m=1
	mppd1 (net158 xpd vdda vdda) pmos1 l=180n w=1u m=1
	mps11 (net31 net158 vdda vdda) pmos1 l=180n w=1u m=1
	mpd11 (net56 inn net31 net31) pmos1 l=180n w=1u m=1
	mp001 (out net158 vdda vdda) pmos1 l=180n w=1u m=1
	mpd12 (net13 inp net31 net31) pmos1 l=180n w=1u m=1
	mpb01 (net158 net158 vdda vdda) pmos1 l=180n w=1u m=1
ends OPAMP1_variant403

subckt OPAMP1_variant404 inn inp out pd xpd vdda vssa
	xd1 (vssa vdda) prim_nwd AREA=2.4e-09 PJ=2.6e-05 m=1
	xi0 (vssa net69) prim_nd AREA=1e-12 PJ=4e-6 m=1
	xi3 (net51 vdda) prim_pd AREA=790e-15 PJ=3.3e-6 m=1
	xr0 (vssa vdda net51) prim_rdiffp l=2.1e-6 w=700e-9 m=1
	xr1 (vdda vdda net69) prim_rdiffp l=2.1e-6 w=700e-9 m=1
	xcc01 (net12 out) prim_cpoly c=1p m=1
	mnm12 (net13 net56 vssa vssa) nmos1 l=180n w=1u m=1
	mnm11 (net56 net56 vssa vssa) nmos1 l=180n w=1u m=1
	mnb02 (net27 net27 net21 vssa) nmos1 l=180n w=1u m=1
	mnpd1 (net21 xpd vssa vssa) nmos1 l=180n w=1u m=1
	mn001 (out net13 vssa vssa) nmos1 l=180n w=1u m=1
	mnpd2 (net13 pd vssa vssa) nmos1 l=180n w=1u m=1
	mnc01 (net13 net69 net12 vssa) nmos1 l=180n w=1u m=1
	mpb02 (net27 net51 net158 vdda) pmos1 l=2.1e-07n w=1.2e-06u m=1
	mppd1 (net158 xpd vdda vdda) pmos1 l=180n w=1u m=1
	mps11 (net31 net158 vdda vdda) pmos1 l=180n w=1u m=1
	mpd11 (net56 inn net31 net31) pmos1 l=180n w=1u m=1
	mp001 (out net158 vdda vdda) pmos1 l=180n w=1u m=1
	mpd12 (net13 inp net31 net31) pmos1 l=1.7e-07n w=7.0e-07u m=1
	mpb01 (net158 net158 vdda vdda) pmos1 l=180n w=1u m=1
ends OPAMP1_variant404

subckt OPAMP1_variant405 inn inp out pd xpd vdda vssa
	xd1 (vssa vdda) prim_nwd AREA=6.13907e-9 PJ=476.6e-6 m=1
	xi0 (vssa net69) prim_nd AREA=3.7e-09 PJ=5.0e-05 m=1
	xi3 (net51 vdda) prim_pd AREA=790e-15 PJ=3.3e-6 m=1
	xr0 (vssa vdda net51) prim_rdiffp l=2.1e-6 w=700e-9 m=1
	xr1 (vdda vdda net69) prim_rdiffp l=2.6e-07 w=8.2e-07 m=1
	xcc01 (net12 out) prim_cpoly c=1p m=1
	mnm12 (net13 net56 vssa vssa) nmos1 l=180n w=1u m=1
	mnm11 (net56 net56 vssa vssa) nmos1 l=180n w=1u m=1
	mnb02 (net27 net27 net21 vssa) nmos1 l=180n w=1u m=1
	mnpd1 (net21 xpd vssa vssa) nmos1 l=180n w=1u m=1
	mn001 (out net13 vssa vssa) nmos1 l=180n w=1u m=1
	mnpd2 (net13 pd vssa vssa) nmos1 l=180n w=1u m=1
	mnc01 (net13 net69 net12 vssa) nmos1 l=180n w=1u m=1
	mpb02 (net27 net51 net158 vdda) pmos1 l=1.1e-07n w=1.5e-06u m=1
	mppd1 (net158 xpd vdda vdda) pmos1 l=180n w=1u m=1
	mps11 (net31 net158 vdda vdda) pmos1 l=180n w=1u m=1
	mpd11 (net56 inn net31 net31) pmos1 l=180n w=1u m=1
	mp001 (out net158 vdda vdda) pmos1 l=2.7e-07n w=1.0e-06u m=1
	mpd12 (net13 inp net31 net31) pmos1 l=180n w=1u m=1
	mpb01 (net158 net158 vdda vdda) pmos1 l=180n w=1u m=1
ends OPAMP1_variant405

subckt OPAMP1_variant406 inn inp out pd xpd vdda vssa
	xd1 (vssa vdda) prim_nwd AREA=6.13907e-9 PJ=476.6e-6 m=1
	xi0 (vssa net69) prim_nd AREA=1e-12 PJ=4e-6 m=1
	xi3 (net51 vdda) prim_pd AREA=3.0e-09 PJ=9.5e-05 m=1
	xr0 (vssa vdda net51) prim_rdiffp l=2.1e-6 w=700e-9 m=1
	xr1 (vdda vdda net69) prim_rdiffp l=1.7e-07 w=1.9e-06 m=1
	xcc01 (net12 out) prim_cpoly c=1p m=1
	mnm12 (net13 net56 vssa vssa) nmos1 l=180n w=1u m=1
	mnm11 (net56 net56 vssa vssa) nmos1 l=180n w=1u m=1
	mnb02 (net27 net27 net21 vssa) nmos1 l=180n w=1u m=1
	mnpd1 (net21 xpd vssa vssa) nmos1 l=180n w=1u m=1
	mn001 (out net13 vssa vssa) nmos1 l=180n w=1u m=1
	mnpd2 (net13 pd vssa vssa) nmos1 l=180n w=1u m=1
	mnc01 (net13 net69 net12 vssa) nmos1 l=1.3e-07n w=1.4e-06u m=1
	mpb02 (net27 net51 net158 vdda) pmos1 l=180n w=1u m=1
	mppd1 (net158 xpd vdda vdda) pmos1 l=180n w=1u m=1
	mps11 (net31 net158 vdda vdda) pmos1 l=180n w=1u m=1
	mpd11 (net56 inn net31 net31) pmos1 l=2.0e-07n w=1.8e-06u m=1
	mp001 (out net158 vdda vdda) pmos1 l=180n w=1u m=1
	mpd12 (net13 inp net31 net31) pmos1 l=180n w=1u m=1
	mpb01 (net158 net158 vdda vdda) pmos1 l=180n w=1u m=1
ends OPAMP1_variant406

subckt OPAMP1_variant407 inn inp out pd xpd vdda vssa
	xd1 (vssa vdda) prim_nwd AREA=6.13907e-9 PJ=476.6e-6 m=1
	xi0 (vssa net69) prim_nd AREA=2.8e-09 PJ=6.0e-05 m=1
	xi3 (net51 vdda) prim_pd AREA=790e-15 PJ=3.3e-6 m=1
	xr0 (vssa vdda net51) prim_rdiffp l=2.1e-6 w=700e-9 m=1
	xr1 (vdda vdda net69) prim_rdiffp l=2.0e-07 w=9.0e-07 m=1
	xcc01 (net12 out) prim_cpoly c=1p m=1
	mnm12 (net13 net56 vssa vssa) nmos1 l=180n w=1u m=1
	mnm11 (net56 net56 vssa vssa) nmos1 l=180n w=1u m=1
	mnb02 (net27 net27 net21 vssa) nmos1 l=180n w=1u m=1
	mnpd1 (net21 xpd vssa vssa) nmos1 l=180n w=1u m=1
	mn001 (out net13 vssa vssa) nmos1 l=180n w=1u m=1
	mnpd2 (net13 pd vssa vssa) nmos1 l=180n w=1u m=1
	mnc01 (net13 net69 net12 vssa) nmos1 l=180n w=1u m=1
	mpb02 (net27 net51 net158 vdda) pmos1 l=180n w=1u m=1
	mppd1 (net158 xpd vdda vdda) pmos1 l=180n w=1u m=1
	mps11 (net31 net158 vdda vdda) pmos1 l=180n w=1u m=1
	mpd11 (net56 inn net31 net31) pmos1 l=180n w=1u m=1
	mp001 (out net158 vdda vdda) pmos1 l=180n w=1u m=1
	mpd12 (net13 inp net31 net31) pmos1 l=180n w=1u m=1
	mpb01 (net158 net158 vdda vdda) pmos1 l=180n w=1u m=1
ends OPAMP1_variant407

subckt OPAMP1_variant408 inn inp out pd xpd vdda vssa
	xd1 (vssa vdda) prim_nwd AREA=1.7e-09 PJ=8.0e-05 m=1
	xi0 (vssa net69) prim_nd AREA=1e-12 PJ=4e-6 m=1
	xi3 (net51 vdda) prim_pd AREA=8.0e-09 PJ=9.9e-05 m=1
	xr0 (vssa vdda net51) prim_rdiffp l=2.1e-6 w=700e-9 m=1
	xr1 (vdda vdda net69) prim_rdiffp l=2.1e-6 w=700e-9 m=1
	xcc01 (net12 out) prim_cpoly c=1p m=1
	mnm12 (net13 net56 vssa vssa) nmos1 l=180n w=1u m=1
	mnm11 (net56 net56 vssa vssa) nmos1 l=180n w=1u m=1
	mnb02 (net27 net27 net21 vssa) nmos1 l=180n w=1u m=1
	mnpd1 (net21 xpd vssa vssa) nmos1 l=180n w=1u m=1
	mn001 (out net13 vssa vssa) nmos1 l=180n w=1u m=1
	mnpd2 (net13 pd vssa vssa) nmos1 l=180n w=1u m=1
	mnc01 (net13 net69 net12 vssa) nmos1 l=180n w=1u m=1
	mpb02 (net27 net51 net158 vdda) pmos1 l=180n w=1u m=1
	mppd1 (net158 xpd vdda vdda) pmos1 l=180n w=1u m=1
	mps11 (net31 net158 vdda vdda) pmos1 l=1.5e-07n w=1.8e-06u m=1
	mpd11 (net56 inn net31 net31) pmos1 l=180n w=1u m=1
	mp001 (out net158 vdda vdda) pmos1 l=180n w=1u m=1
	mpd12 (net13 inp net31 net31) pmos1 l=180n w=1u m=1
	mpb01 (net158 net158 vdda vdda) pmos1 l=180n w=1u m=1
ends OPAMP1_variant408

subckt OPAMP1_variant409 inn inp out pd xpd vdda vssa
	xd1 (vssa vdda) prim_nwd AREA=6.13907e-9 PJ=476.6e-6 m=1
	xi0 (vssa net69) prim_nd AREA=1e-12 PJ=4e-6 m=1
	xi3 (net51 vdda) prim_pd AREA=790e-15 PJ=3.3e-6 m=1
	xr0 (vssa vdda net51) prim_rdiffp l=1.8e-07 w=1.1e-06 m=1
	xr1 (vdda vdda net69) prim_rdiffp l=2.1e-6 w=700e-9 m=1
	xcc01 (net12 out) prim_cpoly c=1p m=1
	mnm12 (net13 net56 vssa vssa) nmos1 l=2.9e-07n w=1.1e-06u m=1
	mnm11 (net56 net56 vssa vssa) nmos1 l=180n w=1u m=1
	mnb02 (net27 net27 net21 vssa) nmos1 l=2.1e-07n w=6.2e-07u m=1
	mnpd1 (net21 xpd vssa vssa) nmos1 l=2.7e-07n w=1.1e-06u m=1
	mn001 (out net13 vssa vssa) nmos1 l=180n w=1u m=1
	mnpd2 (net13 pd vssa vssa) nmos1 l=180n w=1u m=1
	mnc01 (net13 net69 net12 vssa) nmos1 l=180n w=1u m=1
	mpb02 (net27 net51 net158 vdda) pmos1 l=180n w=1u m=1
	mppd1 (net158 xpd vdda vdda) pmos1 l=180n w=1u m=1
	mps11 (net31 net158 vdda vdda) pmos1 l=180n w=1u m=1
	mpd11 (net56 inn net31 net31) pmos1 l=180n w=1u m=1
	mp001 (out net158 vdda vdda) pmos1 l=180n w=1u m=1
	mpd12 (net13 inp net31 net31) pmos1 l=180n w=1u m=1
	mpb01 (net158 net158 vdda vdda) pmos1 l=180n w=1u m=1
ends OPAMP1_variant409

subckt OPAMP1_variant410 inn inp out pd xpd vdda vssa
	xd1 (vssa vdda) prim_nwd AREA=6.13907e-9 PJ=476.6e-6 m=1
	xi0 (vssa net69) prim_nd AREA=1e-12 PJ=4e-6 m=1
	xi3 (net51 vdda) prim_pd AREA=5.4e-09 PJ=2.6e-05 m=1
	xr0 (vssa vdda net51) prim_rdiffp l=2.1e-6 w=700e-9 m=1
	xr1 (vdda vdda net69) prim_rdiffp l=2.1e-6 w=700e-9 m=1
	xcc01 (net12 out) prim_cpoly c=1p m=1
	mnm12 (net13 net56 vssa vssa) nmos1 l=180n w=1u m=1
	mnm11 (net56 net56 vssa vssa) nmos1 l=180n w=1u m=1
	mnb02 (net27 net27 net21 vssa) nmos1 l=180n w=1u m=1
	mnpd1 (net21 xpd vssa vssa) nmos1 l=180n w=1u m=1
	mn001 (out net13 vssa vssa) nmos1 l=180n w=1u m=1
	mnpd2 (net13 pd vssa vssa) nmos1 l=180n w=1u m=1
	mnc01 (net13 net69 net12 vssa) nmos1 l=180n w=1u m=1
	mpb02 (net27 net51 net158 vdda) pmos1 l=1.5e-07n w=1.9e-06u m=1
	mppd1 (net158 xpd vdda vdda) pmos1 l=180n w=1u m=1
	mps11 (net31 net158 vdda vdda) pmos1 l=180n w=1u m=1
	mpd11 (net56 inn net31 net31) pmos1 l=3.0e-07n w=6.8e-07u m=1
	mp001 (out net158 vdda vdda) pmos1 l=180n w=1u m=1
	mpd12 (net13 inp net31 net31) pmos1 l=180n w=1u m=1
	mpb01 (net158 net158 vdda vdda) pmos1 l=180n w=1u m=1
ends OPAMP1_variant410

subckt OPAMP1_variant411 inn inp out pd xpd vdda vssa
	xd1 (vssa vdda) prim_nwd AREA=6.13907e-9 PJ=476.6e-6 m=1
	xi0 (vssa net69) prim_nd AREA=1e-12 PJ=4e-6 m=1
	xi3 (net51 vdda) prim_pd AREA=5.0e-09 PJ=7.5e-05 m=1
	xr0 (vssa vdda net51) prim_rdiffp l=2.1e-6 w=700e-9 m=1
	xr1 (vdda vdda net69) prim_rdiffp l=2.1e-6 w=700e-9 m=1
	xcc01 (net12 out) prim_cpoly c=1p m=1
	mnm12 (net13 net56 vssa vssa) nmos1 l=180n w=1u m=1
	mnm11 (net56 net56 vssa vssa) nmos1 l=180n w=1u m=1
	mnb02 (net27 net27 net21 vssa) nmos1 l=180n w=1u m=1
	mnpd1 (net21 xpd vssa vssa) nmos1 l=180n w=1u m=1
	mn001 (out net13 vssa vssa) nmos1 l=180n w=1u m=1
	mnpd2 (net13 pd vssa vssa) nmos1 l=180n w=1u m=1
	mnc01 (net13 net69 net12 vssa) nmos1 l=2.4e-07n w=1.0e-06u m=1
	mpb02 (net27 net51 net158 vdda) pmos1 l=180n w=1u m=1
	mppd1 (net158 xpd vdda vdda) pmos1 l=180n w=1u m=1
	mps11 (net31 net158 vdda vdda) pmos1 l=180n w=1u m=1
	mpd11 (net56 inn net31 net31) pmos1 l=180n w=1u m=1
	mp001 (out net158 vdda vdda) pmos1 l=180n w=1u m=1
	mpd12 (net13 inp net31 net31) pmos1 l=180n w=1u m=1
	mpb01 (net158 net158 vdda vdda) pmos1 l=180n w=1u m=1
ends OPAMP1_variant411

subckt OPAMP1_variant412 inn inp out pd xpd vdda vssa
	xd1 (vssa vdda) prim_nwd AREA=6.13907e-9 PJ=476.6e-6 m=1
	xi0 (vssa net69) prim_nd AREA=1e-12 PJ=4e-6 m=1
	xi3 (net51 vdda) prim_pd AREA=1.8e-09 PJ=3.1e-06 m=1
	xr0 (vssa vdda net51) prim_rdiffp l=2.1e-6 w=700e-9 m=1
	xr1 (vdda vdda net69) prim_rdiffp l=2.1e-6 w=700e-9 m=1
	xcc01 (net12 out) prim_cpoly c=1p m=1
	mnm12 (net13 net56 vssa vssa) nmos1 l=180n w=1u m=1
	mnm11 (net56 net56 vssa vssa) nmos1 l=180n w=1u m=1
	mnb02 (net27 net27 net21 vssa) nmos1 l=180n w=1u m=1
	mnpd1 (net21 xpd vssa vssa) nmos1 l=180n w=1u m=1
	mn001 (out net13 vssa vssa) nmos1 l=180n w=1u m=1
	mnpd2 (net13 pd vssa vssa) nmos1 l=180n w=1u m=1
	mnc01 (net13 net69 net12 vssa) nmos1 l=180n w=1u m=1
	mpb02 (net27 net51 net158 vdda) pmos1 l=180n w=1u m=1
	mppd1 (net158 xpd vdda vdda) pmos1 l=180n w=1u m=1
	mps11 (net31 net158 vdda vdda) pmos1 l=1.8e-07n w=1.2e-06u m=1
	mpd11 (net56 inn net31 net31) pmos1 l=180n w=1u m=1
	mp001 (out net158 vdda vdda) pmos1 l=180n w=1u m=1
	mpd12 (net13 inp net31 net31) pmos1 l=180n w=1u m=1
	mpb01 (net158 net158 vdda vdda) pmos1 l=180n w=1u m=1
ends OPAMP1_variant412

subckt OPAMP1_variant413 inn inp out pd xpd vdda vssa
	xd1 (vssa vdda) prim_nwd AREA=9.9e-09 PJ=7.0e-05 m=1
	xi0 (vssa net69) prim_nd AREA=9.7e-09 PJ=4.8e-05 m=1
	xi3 (net51 vdda) prim_pd AREA=2.9e-09 PJ=5.1e-05 m=1
	xr0 (vssa vdda net51) prim_rdiffp l=1.5e-07 w=1.9e-06 m=1
	xr1 (vdda vdda net69) prim_rdiffp l=2.1e-6 w=700e-9 m=1
	xcc01 (net12 out) prim_cpoly c=1p m=1
	mnm12 (net13 net56 vssa vssa) nmos1 l=180n w=1u m=1
	mnm11 (net56 net56 vssa vssa) nmos1 l=180n w=1u m=1
	mnb02 (net27 net27 net21 vssa) nmos1 l=180n w=1u m=1
	mnpd1 (net21 xpd vssa vssa) nmos1 l=180n w=1u m=1
	mn001 (out net13 vssa vssa) nmos1 l=2.8e-07n w=1.1e-06u m=1
	mnpd2 (net13 pd vssa vssa) nmos1 l=180n w=1u m=1
	mnc01 (net13 net69 net12 vssa) nmos1 l=180n w=1u m=1
	mpb02 (net27 net51 net158 vdda) pmos1 l=180n w=1u m=1
	mppd1 (net158 xpd vdda vdda) pmos1 l=180n w=1u m=1
	mps11 (net31 net158 vdda vdda) pmos1 l=180n w=1u m=1
	mpd11 (net56 inn net31 net31) pmos1 l=180n w=1u m=1
	mp001 (out net158 vdda vdda) pmos1 l=180n w=1u m=1
	mpd12 (net13 inp net31 net31) pmos1 l=180n w=1u m=1
	mpb01 (net158 net158 vdda vdda) pmos1 l=180n w=1u m=1
ends OPAMP1_variant413

subckt OPAMP1_variant414 inn inp out pd xpd vdda vssa
	xd1 (vssa vdda) prim_nwd AREA=2.6e-09 PJ=1.2e-05 m=1
	xi0 (vssa net69) prim_nd AREA=9.4e-09 PJ=7.2e-05 m=1
	xi3 (net51 vdda) prim_pd AREA=790e-15 PJ=3.3e-6 m=1
	xr0 (vssa vdda net51) prim_rdiffp l=2.1e-6 w=700e-9 m=1
	xr1 (vdda vdda net69) prim_rdiffp l=2.1e-6 w=700e-9 m=1
	xcc01 (net12 out) prim_cpoly c=1p m=1
	mnm12 (net13 net56 vssa vssa) nmos1 l=180n w=1u m=1
	mnm11 (net56 net56 vssa vssa) nmos1 l=180n w=1u m=1
	mnb02 (net27 net27 net21 vssa) nmos1 l=180n w=1u m=1
	mnpd1 (net21 xpd vssa vssa) nmos1 l=180n w=1u m=1
	mn001 (out net13 vssa vssa) nmos1 l=2.5e-07n w=1.3e-06u m=1
	mnpd2 (net13 pd vssa vssa) nmos1 l=180n w=1u m=1
	mnc01 (net13 net69 net12 vssa) nmos1 l=2.9e-07n w=1.7e-06u m=1
	mpb02 (net27 net51 net158 vdda) pmos1 l=180n w=1u m=1
	mppd1 (net158 xpd vdda vdda) pmos1 l=180n w=1u m=1
	mps11 (net31 net158 vdda vdda) pmos1 l=180n w=1u m=1
	mpd11 (net56 inn net31 net31) pmos1 l=1.3e-07n w=1.8e-06u m=1
	mp001 (out net158 vdda vdda) pmos1 l=180n w=1u m=1
	mpd12 (net13 inp net31 net31) pmos1 l=180n w=1u m=1
	mpb01 (net158 net158 vdda vdda) pmos1 l=180n w=1u m=1
ends OPAMP1_variant414

subckt OPAMP1_variant415 inn inp out pd xpd vdda vssa
	xd1 (vssa vdda) prim_nwd AREA=7.0e-09 PJ=4.9e-06 m=1
	xi0 (vssa net69) prim_nd AREA=1e-12 PJ=4e-6 m=1
	xi3 (net51 vdda) prim_pd AREA=790e-15 PJ=3.3e-6 m=1
	xr0 (vssa vdda net51) prim_rdiffp l=2.1e-6 w=700e-9 m=1
	xr1 (vdda vdda net69) prim_rdiffp l=2.1e-6 w=700e-9 m=1
	xcc01 (net12 out) prim_cpoly c=1p m=1
	mnm12 (net13 net56 vssa vssa) nmos1 l=180n w=1u m=1
	mnm11 (net56 net56 vssa vssa) nmos1 l=180n w=1u m=1
	mnb02 (net27 net27 net21 vssa) nmos1 l=180n w=1u m=1
	mnpd1 (net21 xpd vssa vssa) nmos1 l=1.9e-07n w=1.6e-06u m=1
	mn001 (out net13 vssa vssa) nmos1 l=180n w=1u m=1
	mnpd2 (net13 pd vssa vssa) nmos1 l=180n w=1u m=1
	mnc01 (net13 net69 net12 vssa) nmos1 l=2.7e-07n w=8.0e-07u m=1
	mpb02 (net27 net51 net158 vdda) pmos1 l=180n w=1u m=1
	mppd1 (net158 xpd vdda vdda) pmos1 l=180n w=1u m=1
	mps11 (net31 net158 vdda vdda) pmos1 l=180n w=1u m=1
	mpd11 (net56 inn net31 net31) pmos1 l=2.9e-07n w=1.2e-06u m=1
	mp001 (out net158 vdda vdda) pmos1 l=180n w=1u m=1
	mpd12 (net13 inp net31 net31) pmos1 l=180n w=1u m=1
	mpb01 (net158 net158 vdda vdda) pmos1 l=180n w=1u m=1
ends OPAMP1_variant415

subckt OPAMP1_variant416 inn inp out pd xpd vdda vssa
	xd1 (vssa vdda) prim_nwd AREA=6.13907e-9 PJ=476.6e-6 m=1
	xi0 (vssa net69) prim_nd AREA=1e-12 PJ=4e-6 m=1
	xi3 (net51 vdda) prim_pd AREA=790e-15 PJ=3.3e-6 m=1
	xr0 (vssa vdda net51) prim_rdiffp l=2.1e-6 w=700e-9 m=1
	xr1 (vdda vdda net69) prim_rdiffp l=2.1e-6 w=700e-9 m=1
	xcc01 (net12 out) prim_cpoly c=1p m=1
	mnm12 (net13 net56 vssa vssa) nmos1 l=180n w=1u m=1
	mnm11 (net56 net56 vssa vssa) nmos1 l=2.6e-07n w=1.2e-06u m=1
	mnb02 (net27 net27 net21 vssa) nmos1 l=180n w=1u m=1
	mnpd1 (net21 xpd vssa vssa) nmos1 l=180n w=1u m=1
	mn001 (out net13 vssa vssa) nmos1 l=180n w=1u m=1
	mnpd2 (net13 pd vssa vssa) nmos1 l=180n w=1u m=1
	mnc01 (net13 net69 net12 vssa) nmos1 l=180n w=1u m=1
	mpb02 (net27 net51 net158 vdda) pmos1 l=2.9e-07n w=1.6e-06u m=1
	mppd1 (net158 xpd vdda vdda) pmos1 l=180n w=1u m=1
	mps11 (net31 net158 vdda vdda) pmos1 l=180n w=1u m=1
	mpd11 (net56 inn net31 net31) pmos1 l=180n w=1u m=1
	mp001 (out net158 vdda vdda) pmos1 l=180n w=1u m=1
	mpd12 (net13 inp net31 net31) pmos1 l=180n w=1u m=1
	mpb01 (net158 net158 vdda vdda) pmos1 l=180n w=1u m=1
ends OPAMP1_variant416

subckt OPAMP1_variant417 inn inp out pd xpd vdda vssa
	xd1 (vssa vdda) prim_nwd AREA=6.13907e-9 PJ=476.6e-6 m=1
	xi0 (vssa net69) prim_nd AREA=1e-12 PJ=4e-6 m=1
	xi3 (net51 vdda) prim_pd AREA=790e-15 PJ=3.3e-6 m=1
	xr0 (vssa vdda net51) prim_rdiffp l=2.1e-6 w=700e-9 m=1
	xr1 (vdda vdda net69) prim_rdiffp l=2.1e-6 w=700e-9 m=1
	xcc01 (net12 out) prim_cpoly c=1p m=1
	mnm12 (net13 net56 vssa vssa) nmos1 l=2.3e-07n w=1.5e-06u m=1
	mnm11 (net56 net56 vssa vssa) nmos1 l=180n w=1u m=1
	mnb02 (net27 net27 net21 vssa) nmos1 l=1.7e-07n w=1.1e-06u m=1
	mnpd1 (net21 xpd vssa vssa) nmos1 l=180n w=1u m=1
	mn001 (out net13 vssa vssa) nmos1 l=2.3e-07n w=9.7e-07u m=1
	mnpd2 (net13 pd vssa vssa) nmos1 l=180n w=1u m=1
	mnc01 (net13 net69 net12 vssa) nmos1 l=180n w=1u m=1
	mpb02 (net27 net51 net158 vdda) pmos1 l=180n w=1u m=1
	mppd1 (net158 xpd vdda vdda) pmos1 l=180n w=1u m=1
	mps11 (net31 net158 vdda vdda) pmos1 l=180n w=1u m=1
	mpd11 (net56 inn net31 net31) pmos1 l=180n w=1u m=1
	mp001 (out net158 vdda vdda) pmos1 l=2.7e-07n w=1.3e-06u m=1
	mpd12 (net13 inp net31 net31) pmos1 l=180n w=1u m=1
	mpb01 (net158 net158 vdda vdda) pmos1 l=180n w=1u m=1
ends OPAMP1_variant417

subckt OPAMP1_variant418 inn inp out pd xpd vdda vssa
	xd1 (vssa vdda) prim_nwd AREA=3.4e-09 PJ=9.3e-05 m=1
	xi0 (vssa net69) prim_nd AREA=1e-12 PJ=4e-6 m=1
	xi3 (net51 vdda) prim_pd AREA=790e-15 PJ=3.3e-6 m=1
	xr0 (vssa vdda net51) prim_rdiffp l=1.3e-07 w=1.6e-06 m=1
	xr1 (vdda vdda net69) prim_rdiffp l=2.1e-6 w=700e-9 m=1
	xcc01 (net12 out) prim_cpoly c=1p m=1
	mnm12 (net13 net56 vssa vssa) nmos1 l=180n w=1u m=1
	mnm11 (net56 net56 vssa vssa) nmos1 l=180n w=1u m=1
	mnb02 (net27 net27 net21 vssa) nmos1 l=180n w=1u m=1
	mnpd1 (net21 xpd vssa vssa) nmos1 l=180n w=1u m=1
	mn001 (out net13 vssa vssa) nmos1 l=180n w=1u m=1
	mnpd2 (net13 pd vssa vssa) nmos1 l=180n w=1u m=1
	mnc01 (net13 net69 net12 vssa) nmos1 l=180n w=1u m=1
	mpb02 (net27 net51 net158 vdda) pmos1 l=180n w=1u m=1
	mppd1 (net158 xpd vdda vdda) pmos1 l=180n w=1u m=1
	mps11 (net31 net158 vdda vdda) pmos1 l=180n w=1u m=1
	mpd11 (net56 inn net31 net31) pmos1 l=180n w=1u m=1
	mp001 (out net158 vdda vdda) pmos1 l=2.7e-07n w=1.7e-06u m=1
	mpd12 (net13 inp net31 net31) pmos1 l=180n w=1u m=1
	mpb01 (net158 net158 vdda vdda) pmos1 l=180n w=1u m=1
ends OPAMP1_variant418

subckt OPAMP1_variant419 inn inp out pd xpd vdda vssa
	xd1 (vssa vdda) prim_nwd AREA=6.13907e-9 PJ=476.6e-6 m=1
	xi0 (vssa net69) prim_nd AREA=1e-12 PJ=4e-6 m=1
	xi3 (net51 vdda) prim_pd AREA=790e-15 PJ=3.3e-6 m=1
	xr0 (vssa vdda net51) prim_rdiffp l=2.1e-6 w=700e-9 m=1
	xr1 (vdda vdda net69) prim_rdiffp l=2.6e-07 w=7.8e-07 m=1
	xcc01 (net12 out) prim_cpoly c=1p m=1
	mnm12 (net13 net56 vssa vssa) nmos1 l=180n w=1u m=1
	mnm11 (net56 net56 vssa vssa) nmos1 l=180n w=1u m=1
	mnb02 (net27 net27 net21 vssa) nmos1 l=180n w=1u m=1
	mnpd1 (net21 xpd vssa vssa) nmos1 l=2.2e-07n w=7.6e-07u m=1
	mn001 (out net13 vssa vssa) nmos1 l=1.8e-07n w=8.9e-07u m=1
	mnpd2 (net13 pd vssa vssa) nmos1 l=180n w=1u m=1
	mnc01 (net13 net69 net12 vssa) nmos1 l=180n w=1u m=1
	mpb02 (net27 net51 net158 vdda) pmos1 l=180n w=1u m=1
	mppd1 (net158 xpd vdda vdda) pmos1 l=180n w=1u m=1
	mps11 (net31 net158 vdda vdda) pmos1 l=2.0e-07n w=8.9e-07u m=1
	mpd11 (net56 inn net31 net31) pmos1 l=180n w=1u m=1
	mp001 (out net158 vdda vdda) pmos1 l=180n w=1u m=1
	mpd12 (net13 inp net31 net31) pmos1 l=180n w=1u m=1
	mpb01 (net158 net158 vdda vdda) pmos1 l=180n w=1u m=1
ends OPAMP1_variant419

subckt OPAMP1_variant420 inn inp out pd xpd vdda vssa
	xd1 (vssa vdda) prim_nwd AREA=6.13907e-9 PJ=476.6e-6 m=1
	xi0 (vssa net69) prim_nd AREA=1e-12 PJ=4e-6 m=1
	xi3 (net51 vdda) prim_pd AREA=790e-15 PJ=3.3e-6 m=1
	xr0 (vssa vdda net51) prim_rdiffp l=2.1e-6 w=700e-9 m=1
	xr1 (vdda vdda net69) prim_rdiffp l=2.1e-6 w=700e-9 m=1
	xcc01 (net12 out) prim_cpoly c=1p m=1
	mnm12 (net13 net56 vssa vssa) nmos1 l=1.2e-07n w=1.2e-06u m=1
	mnm11 (net56 net56 vssa vssa) nmos1 l=180n w=1u m=1
	mnb02 (net27 net27 net21 vssa) nmos1 l=180n w=1u m=1
	mnpd1 (net21 xpd vssa vssa) nmos1 l=180n w=1u m=1
	mn001 (out net13 vssa vssa) nmos1 l=180n w=1u m=1
	mnpd2 (net13 pd vssa vssa) nmos1 l=180n w=1u m=1
	mnc01 (net13 net69 net12 vssa) nmos1 l=2.6e-07n w=5.8e-07u m=1
	mpb02 (net27 net51 net158 vdda) pmos1 l=180n w=1u m=1
	mppd1 (net158 xpd vdda vdda) pmos1 l=180n w=1u m=1
	mps11 (net31 net158 vdda vdda) pmos1 l=180n w=1u m=1
	mpd11 (net56 inn net31 net31) pmos1 l=180n w=1u m=1
	mp001 (out net158 vdda vdda) pmos1 l=180n w=1u m=1
	mpd12 (net13 inp net31 net31) pmos1 l=180n w=1u m=1
	mpb01 (net158 net158 vdda vdda) pmos1 l=180n w=1u m=1
ends OPAMP1_variant420

subckt OPAMP1_variant421 inn inp out pd xpd vdda vssa
	xd1 (vssa vdda) prim_nwd AREA=4.1e-09 PJ=1.8e-05 m=1
	xi0 (vssa net69) prim_nd AREA=1e-12 PJ=4e-6 m=1
	xi3 (net51 vdda) prim_pd AREA=790e-15 PJ=3.3e-6 m=1
	xr0 (vssa vdda net51) prim_rdiffp l=2.1e-6 w=700e-9 m=1
	xr1 (vdda vdda net69) prim_rdiffp l=2.1e-6 w=700e-9 m=1
	xcc01 (net12 out) prim_cpoly c=1p m=1
	mnm12 (net13 net56 vssa vssa) nmos1 l=180n w=1u m=1
	mnm11 (net56 net56 vssa vssa) nmos1 l=180n w=1u m=1
	mnb02 (net27 net27 net21 vssa) nmos1 l=2.2e-07n w=1.4e-06u m=1
	mnpd1 (net21 xpd vssa vssa) nmos1 l=180n w=1u m=1
	mn001 (out net13 vssa vssa) nmos1 l=180n w=1u m=1
	mnpd2 (net13 pd vssa vssa) nmos1 l=180n w=1u m=1
	mnc01 (net13 net69 net12 vssa) nmos1 l=180n w=1u m=1
	mpb02 (net27 net51 net158 vdda) pmos1 l=180n w=1u m=1
	mppd1 (net158 xpd vdda vdda) pmos1 l=180n w=1u m=1
	mps11 (net31 net158 vdda vdda) pmos1 l=180n w=1u m=1
	mpd11 (net56 inn net31 net31) pmos1 l=180n w=1u m=1
	mp001 (out net158 vdda vdda) pmos1 l=180n w=1u m=1
	mpd12 (net13 inp net31 net31) pmos1 l=180n w=1u m=1
	mpb01 (net158 net158 vdda vdda) pmos1 l=180n w=1u m=1
ends OPAMP1_variant421

subckt OPAMP1_variant422 inn inp out pd xpd vdda vssa
	xd1 (vssa vdda) prim_nwd AREA=6.13907e-9 PJ=476.6e-6 m=1
	xi0 (vssa net69) prim_nd AREA=6.5e-09 PJ=8.3e-05 m=1
	xi3 (net51 vdda) prim_pd AREA=790e-15 PJ=3.3e-6 m=1
	xr0 (vssa vdda net51) prim_rdiffp l=2.1e-6 w=700e-9 m=1
	xr1 (vdda vdda net69) prim_rdiffp l=2.1e-6 w=700e-9 m=1
	xcc01 (net12 out) prim_cpoly c=1p m=1
	mnm12 (net13 net56 vssa vssa) nmos1 l=180n w=1u m=1
	mnm11 (net56 net56 vssa vssa) nmos1 l=180n w=1u m=1
	mnb02 (net27 net27 net21 vssa) nmos1 l=2.5e-07n w=1.9e-06u m=1
	mnpd1 (net21 xpd vssa vssa) nmos1 l=180n w=1u m=1
	mn001 (out net13 vssa vssa) nmos1 l=1.8e-07n w=6.6e-07u m=1
	mnpd2 (net13 pd vssa vssa) nmos1 l=1.6e-07n w=9.1e-07u m=1
	mnc01 (net13 net69 net12 vssa) nmos1 l=180n w=1u m=1
	mpb02 (net27 net51 net158 vdda) pmos1 l=180n w=1u m=1
	mppd1 (net158 xpd vdda vdda) pmos1 l=2.3e-07n w=1.0e-06u m=1
	mps11 (net31 net158 vdda vdda) pmos1 l=180n w=1u m=1
	mpd11 (net56 inn net31 net31) pmos1 l=180n w=1u m=1
	mp001 (out net158 vdda vdda) pmos1 l=180n w=1u m=1
	mpd12 (net13 inp net31 net31) pmos1 l=180n w=1u m=1
	mpb01 (net158 net158 vdda vdda) pmos1 l=180n w=1u m=1
ends OPAMP1_variant422

subckt OPAMP1_variant423 inn inp out pd xpd vdda vssa
	xd1 (vssa vdda) prim_nwd AREA=6.13907e-9 PJ=476.6e-6 m=1
	xi0 (vssa net69) prim_nd AREA=1e-12 PJ=4e-6 m=1
	xi3 (net51 vdda) prim_pd AREA=790e-15 PJ=3.3e-6 m=1
	xr0 (vssa vdda net51) prim_rdiffp l=2.1e-6 w=700e-9 m=1
	xr1 (vdda vdda net69) prim_rdiffp l=2.9e-07 w=1.0e-06 m=1
	xcc01 (net12 out) prim_cpoly c=5.0e-13p m=1
	mnm12 (net13 net56 vssa vssa) nmos1 l=180n w=1u m=1
	mnm11 (net56 net56 vssa vssa) nmos1 l=1.4e-07n w=2.0e-06u m=1
	mnb02 (net27 net27 net21 vssa) nmos1 l=180n w=1u m=1
	mnpd1 (net21 xpd vssa vssa) nmos1 l=180n w=1u m=1
	mn001 (out net13 vssa vssa) nmos1 l=1.6e-07n w=1.9e-06u m=1
	mnpd2 (net13 pd vssa vssa) nmos1 l=180n w=1u m=1
	mnc01 (net13 net69 net12 vssa) nmos1 l=2.2e-07n w=1.9e-06u m=1
	mpb02 (net27 net51 net158 vdda) pmos1 l=180n w=1u m=1
	mppd1 (net158 xpd vdda vdda) pmos1 l=180n w=1u m=1
	mps11 (net31 net158 vdda vdda) pmos1 l=180n w=1u m=1
	mpd11 (net56 inn net31 net31) pmos1 l=180n w=1u m=1
	mp001 (out net158 vdda vdda) pmos1 l=180n w=1u m=1
	mpd12 (net13 inp net31 net31) pmos1 l=180n w=1u m=1
	mpb01 (net158 net158 vdda vdda) pmos1 l=180n w=1u m=1
ends OPAMP1_variant423

subckt OPAMP1_variant424 inn inp out pd xpd vdda vssa
	xd1 (vssa vdda) prim_nwd AREA=6.13907e-9 PJ=476.6e-6 m=1
	xi0 (vssa net69) prim_nd AREA=1e-12 PJ=4e-6 m=1
	xi3 (net51 vdda) prim_pd AREA=790e-15 PJ=3.3e-6 m=1
	xr0 (vssa vdda net51) prim_rdiffp l=2.1e-6 w=700e-9 m=1
	xr1 (vdda vdda net69) prim_rdiffp l=2.1e-6 w=700e-9 m=1
	xcc01 (net12 out) prim_cpoly c=7.5e-13p m=1
	mnm12 (net13 net56 vssa vssa) nmos1 l=180n w=1u m=1
	mnm11 (net56 net56 vssa vssa) nmos1 l=2.9e-07n w=1.5e-06u m=1
	mnb02 (net27 net27 net21 vssa) nmos1 l=1.7e-07n w=7.4e-07u m=1
	mnpd1 (net21 xpd vssa vssa) nmos1 l=180n w=1u m=1
	mn001 (out net13 vssa vssa) nmos1 l=180n w=1u m=1
	mnpd2 (net13 pd vssa vssa) nmos1 l=180n w=1u m=1
	mnc01 (net13 net69 net12 vssa) nmos1 l=180n w=1u m=1
	mpb02 (net27 net51 net158 vdda) pmos1 l=180n w=1u m=1
	mppd1 (net158 xpd vdda vdda) pmos1 l=180n w=1u m=1
	mps11 (net31 net158 vdda vdda) pmos1 l=180n w=1u m=1
	mpd11 (net56 inn net31 net31) pmos1 l=180n w=1u m=1
	mp001 (out net158 vdda vdda) pmos1 l=2.1e-07n w=1.1e-06u m=1
	mpd12 (net13 inp net31 net31) pmos1 l=180n w=1u m=1
	mpb01 (net158 net158 vdda vdda) pmos1 l=180n w=1u m=1
ends OPAMP1_variant424

subckt OPAMP1_variant425 inn inp out pd xpd vdda vssa
	xd1 (vssa vdda) prim_nwd AREA=6.13907e-9 PJ=476.6e-6 m=1
	xi0 (vssa net69) prim_nd AREA=1e-12 PJ=4e-6 m=1
	xi3 (net51 vdda) prim_pd AREA=790e-15 PJ=3.3e-6 m=1
	xr0 (vssa vdda net51) prim_rdiffp l=2.1e-6 w=700e-9 m=1
	xr1 (vdda vdda net69) prim_rdiffp l=2.1e-6 w=700e-9 m=1
	xcc01 (net12 out) prim_cpoly c=1p m=1
	mnm12 (net13 net56 vssa vssa) nmos1 l=180n w=1u m=1
	mnm11 (net56 net56 vssa vssa) nmos1 l=180n w=1u m=1
	mnb02 (net27 net27 net21 vssa) nmos1 l=180n w=1u m=1
	mnpd1 (net21 xpd vssa vssa) nmos1 l=180n w=1u m=1
	mn001 (out net13 vssa vssa) nmos1 l=180n w=1u m=1
	mnpd2 (net13 pd vssa vssa) nmos1 l=2.5e-07n w=1.3e-06u m=1
	mnc01 (net13 net69 net12 vssa) nmos1 l=180n w=1u m=1
	mpb02 (net27 net51 net158 vdda) pmos1 l=1.7e-07n w=6.3e-07u m=1
	mppd1 (net158 xpd vdda vdda) pmos1 l=180n w=1u m=1
	mps11 (net31 net158 vdda vdda) pmos1 l=180n w=1u m=1
	mpd11 (net56 inn net31 net31) pmos1 l=180n w=1u m=1
	mp001 (out net158 vdda vdda) pmos1 l=180n w=1u m=1
	mpd12 (net13 inp net31 net31) pmos1 l=180n w=1u m=1
	mpb01 (net158 net158 vdda vdda) pmos1 l=180n w=1u m=1
ends OPAMP1_variant425

subckt OPAMP1_variant426 inn inp out pd xpd vdda vssa
	xd1 (vssa vdda) prim_nwd AREA=9.4e-09 PJ=8.8e-05 m=1
	xi0 (vssa net69) prim_nd AREA=2.6e-09 PJ=8.5e-05 m=1
	xi3 (net51 vdda) prim_pd AREA=790e-15 PJ=3.3e-6 m=1
	xr0 (vssa vdda net51) prim_rdiffp l=2.1e-6 w=700e-9 m=1
	xr1 (vdda vdda net69) prim_rdiffp l=2.8e-07 w=1.1e-06 m=1
	xcc01 (net12 out) prim_cpoly c=1p m=1
	mnm12 (net13 net56 vssa vssa) nmos1 l=180n w=1u m=1
	mnm11 (net56 net56 vssa vssa) nmos1 l=180n w=1u m=1
	mnb02 (net27 net27 net21 vssa) nmos1 l=180n w=1u m=1
	mnpd1 (net21 xpd vssa vssa) nmos1 l=180n w=1u m=1
	mn001 (out net13 vssa vssa) nmos1 l=180n w=1u m=1
	mnpd2 (net13 pd vssa vssa) nmos1 l=180n w=1u m=1
	mnc01 (net13 net69 net12 vssa) nmos1 l=180n w=1u m=1
	mpb02 (net27 net51 net158 vdda) pmos1 l=180n w=1u m=1
	mppd1 (net158 xpd vdda vdda) pmos1 l=1.9e-07n w=1.6e-06u m=1
	mps11 (net31 net158 vdda vdda) pmos1 l=180n w=1u m=1
	mpd11 (net56 inn net31 net31) pmos1 l=2.3e-07n w=1.4e-06u m=1
	mp001 (out net158 vdda vdda) pmos1 l=180n w=1u m=1
	mpd12 (net13 inp net31 net31) pmos1 l=180n w=1u m=1
	mpb01 (net158 net158 vdda vdda) pmos1 l=180n w=1u m=1
ends OPAMP1_variant426

subckt OPAMP1_variant427 inn inp out pd xpd vdda vssa
	xd1 (vssa vdda) prim_nwd AREA=6.13907e-9 PJ=476.6e-6 m=1
	xi0 (vssa net69) prim_nd AREA=1e-12 PJ=4e-6 m=1
	xi3 (net51 vdda) prim_pd AREA=790e-15 PJ=3.3e-6 m=1
	xr0 (vssa vdda net51) prim_rdiffp l=2.1e-6 w=700e-9 m=1
	xr1 (vdda vdda net69) prim_rdiffp l=1.9e-07 w=1.5e-06 m=1
	xcc01 (net12 out) prim_cpoly c=1p m=1
	mnm12 (net13 net56 vssa vssa) nmos1 l=180n w=1u m=1
	mnm11 (net56 net56 vssa vssa) nmos1 l=180n w=1u m=1
	mnb02 (net27 net27 net21 vssa) nmos1 l=180n w=1u m=1
	mnpd1 (net21 xpd vssa vssa) nmos1 l=180n w=1u m=1
	mn001 (out net13 vssa vssa) nmos1 l=180n w=1u m=1
	mnpd2 (net13 pd vssa vssa) nmos1 l=180n w=1u m=1
	mnc01 (net13 net69 net12 vssa) nmos1 l=180n w=1u m=1
	mpb02 (net27 net51 net158 vdda) pmos1 l=180n w=1u m=1
	mppd1 (net158 xpd vdda vdda) pmos1 l=180n w=1u m=1
	mps11 (net31 net158 vdda vdda) pmos1 l=2.3e-07n w=1.0e-06u m=1
	mpd11 (net56 inn net31 net31) pmos1 l=180n w=1u m=1
	mp001 (out net158 vdda vdda) pmos1 l=180n w=1u m=1
	mpd12 (net13 inp net31 net31) pmos1 l=180n w=1u m=1
	mpb01 (net158 net158 vdda vdda) pmos1 l=180n w=1u m=1
ends OPAMP1_variant427

subckt OPAMP1_variant428 inn inp out pd xpd vdda vssa
	xd1 (vssa vdda) prim_nwd AREA=6.13907e-9 PJ=476.6e-6 m=1
	xi0 (vssa net69) prim_nd AREA=1e-12 PJ=4e-6 m=1
	xi3 (net51 vdda) prim_pd AREA=790e-15 PJ=3.3e-6 m=1
	xr0 (vssa vdda net51) prim_rdiffp l=2.1e-6 w=700e-9 m=1
	xr1 (vdda vdda net69) prim_rdiffp l=2.1e-6 w=700e-9 m=1
	xcc01 (net12 out) prim_cpoly c=1p m=1
	mnm12 (net13 net56 vssa vssa) nmos1 l=180n w=1u m=1
	mnm11 (net56 net56 vssa vssa) nmos1 l=180n w=1u m=1
	mnb02 (net27 net27 net21 vssa) nmos1 l=180n w=1u m=1
	mnpd1 (net21 xpd vssa vssa) nmos1 l=180n w=1u m=1
	mn001 (out net13 vssa vssa) nmos1 l=180n w=1u m=1
	mnpd2 (net13 pd vssa vssa) nmos1 l=180n w=1u m=1
	mnc01 (net13 net69 net12 vssa) nmos1 l=180n w=1u m=1
	mpb02 (net27 net51 net158 vdda) pmos1 l=180n w=1u m=1
	mppd1 (net158 xpd vdda vdda) pmos1 l=3.0e-07n w=1.7e-06u m=1
	mps11 (net31 net158 vdda vdda) pmos1 l=180n w=1u m=1
	mpd11 (net56 inn net31 net31) pmos1 l=180n w=1u m=1
	mp001 (out net158 vdda vdda) pmos1 l=2.7e-07n w=6.4e-07u m=1
	mpd12 (net13 inp net31 net31) pmos1 l=180n w=1u m=1
	mpb01 (net158 net158 vdda vdda) pmos1 l=180n w=1u m=1
ends OPAMP1_variant428

subckt OPAMP1_variant429 inn inp out pd xpd vdda vssa
	xd1 (vssa vdda) prim_nwd AREA=6.13907e-9 PJ=476.6e-6 m=1
	xi0 (vssa net69) prim_nd AREA=9.0e-09 PJ=7.5e-05 m=1
	xi3 (net51 vdda) prim_pd AREA=6.1e-10 PJ=2.0e-05 m=1
	xr0 (vssa vdda net51) prim_rdiffp l=1.5e-07 w=7.0e-07 m=1
	xr1 (vdda vdda net69) prim_rdiffp l=2.1e-6 w=700e-9 m=1
	xcc01 (net12 out) prim_cpoly c=1p m=1
	mnm12 (net13 net56 vssa vssa) nmos1 l=180n w=1u m=1
	mnm11 (net56 net56 vssa vssa) nmos1 l=180n w=1u m=1
	mnb02 (net27 net27 net21 vssa) nmos1 l=180n w=1u m=1
	mnpd1 (net21 xpd vssa vssa) nmos1 l=180n w=1u m=1
	mn001 (out net13 vssa vssa) nmos1 l=180n w=1u m=1
	mnpd2 (net13 pd vssa vssa) nmos1 l=2.0e-07n w=1.8e-06u m=1
	mnc01 (net13 net69 net12 vssa) nmos1 l=180n w=1u m=1
	mpb02 (net27 net51 net158 vdda) pmos1 l=2.0e-07n w=7.0e-07u m=1
	mppd1 (net158 xpd vdda vdda) pmos1 l=180n w=1u m=1
	mps11 (net31 net158 vdda vdda) pmos1 l=180n w=1u m=1
	mpd11 (net56 inn net31 net31) pmos1 l=180n w=1u m=1
	mp001 (out net158 vdda vdda) pmos1 l=180n w=1u m=1
	mpd12 (net13 inp net31 net31) pmos1 l=180n w=1u m=1
	mpb01 (net158 net158 vdda vdda) pmos1 l=180n w=1u m=1
ends OPAMP1_variant429

subckt OPAMP1_variant430 inn inp out pd xpd vdda vssa
	xd1 (vssa vdda) prim_nwd AREA=6.13907e-9 PJ=476.6e-6 m=1
	xi0 (vssa net69) prim_nd AREA=1e-12 PJ=4e-6 m=1
	xi3 (net51 vdda) prim_pd AREA=3.3e-09 PJ=3.6e-06 m=1
	xr0 (vssa vdda net51) prim_rdiffp l=2.1e-6 w=700e-9 m=1
	xr1 (vdda vdda net69) prim_rdiffp l=2.1e-6 w=700e-9 m=1
	xcc01 (net12 out) prim_cpoly c=1p m=1
	mnm12 (net13 net56 vssa vssa) nmos1 l=180n w=1u m=1
	mnm11 (net56 net56 vssa vssa) nmos1 l=180n w=1u m=1
	mnb02 (net27 net27 net21 vssa) nmos1 l=180n w=1u m=1
	mnpd1 (net21 xpd vssa vssa) nmos1 l=2.2e-07n w=1.5e-06u m=1
	mn001 (out net13 vssa vssa) nmos1 l=180n w=1u m=1
	mnpd2 (net13 pd vssa vssa) nmos1 l=180n w=1u m=1
	mnc01 (net13 net69 net12 vssa) nmos1 l=1.1e-07n w=1.4e-06u m=1
	mpb02 (net27 net51 net158 vdda) pmos1 l=180n w=1u m=1
	mppd1 (net158 xpd vdda vdda) pmos1 l=180n w=1u m=1
	mps11 (net31 net158 vdda vdda) pmos1 l=180n w=1u m=1
	mpd11 (net56 inn net31 net31) pmos1 l=180n w=1u m=1
	mp001 (out net158 vdda vdda) pmos1 l=1.3e-07n w=1.0e-06u m=1
	mpd12 (net13 inp net31 net31) pmos1 l=180n w=1u m=1
	mpb01 (net158 net158 vdda vdda) pmos1 l=180n w=1u m=1
ends OPAMP1_variant430

subckt OPAMP1_variant431 inn inp out pd xpd vdda vssa
	xd1 (vssa vdda) prim_nwd AREA=6.13907e-9 PJ=476.6e-6 m=1
	xi0 (vssa net69) prim_nd AREA=1e-12 PJ=4e-6 m=1
	xi3 (net51 vdda) prim_pd AREA=790e-15 PJ=3.3e-6 m=1
	xr0 (vssa vdda net51) prim_rdiffp l=1.5e-07 w=1.9e-06 m=1
	xr1 (vdda vdda net69) prim_rdiffp l=2.1e-6 w=700e-9 m=1
	xcc01 (net12 out) prim_cpoly c=1p m=1
	mnm12 (net13 net56 vssa vssa) nmos1 l=180n w=1u m=1
	mnm11 (net56 net56 vssa vssa) nmos1 l=180n w=1u m=1
	mnb02 (net27 net27 net21 vssa) nmos1 l=180n w=1u m=1
	mnpd1 (net21 xpd vssa vssa) nmos1 l=180n w=1u m=1
	mn001 (out net13 vssa vssa) nmos1 l=180n w=1u m=1
	mnpd2 (net13 pd vssa vssa) nmos1 l=180n w=1u m=1
	mnc01 (net13 net69 net12 vssa) nmos1 l=1.9e-07n w=5.8e-07u m=1
	mpb02 (net27 net51 net158 vdda) pmos1 l=180n w=1u m=1
	mppd1 (net158 xpd vdda vdda) pmos1 l=180n w=1u m=1
	mps11 (net31 net158 vdda vdda) pmos1 l=180n w=1u m=1
	mpd11 (net56 inn net31 net31) pmos1 l=180n w=1u m=1
	mp001 (out net158 vdda vdda) pmos1 l=180n w=1u m=1
	mpd12 (net13 inp net31 net31) pmos1 l=180n w=1u m=1
	mpb01 (net158 net158 vdda vdda) pmos1 l=180n w=1u m=1
ends OPAMP1_variant431

subckt OPAMP1_variant432 inn inp out pd xpd vdda vssa
	xd1 (vssa vdda) prim_nwd AREA=6.13907e-9 PJ=476.6e-6 m=1
	xi0 (vssa net69) prim_nd AREA=9.9e-09 PJ=1.9e-05 m=1
	xi3 (net51 vdda) prim_pd AREA=790e-15 PJ=3.3e-6 m=1
	xr0 (vssa vdda net51) prim_rdiffp l=1.1e-07 w=8.8e-07 m=1
	xr1 (vdda vdda net69) prim_rdiffp l=2.1e-6 w=700e-9 m=1
	xcc01 (net12 out) prim_cpoly c=1p m=1
	mnm12 (net13 net56 vssa vssa) nmos1 l=180n w=1u m=1
	mnm11 (net56 net56 vssa vssa) nmos1 l=1.9e-07n w=8.0e-07u m=1
	mnb02 (net27 net27 net21 vssa) nmos1 l=1.4e-07n w=5.5e-07u m=1
	mnpd1 (net21 xpd vssa vssa) nmos1 l=180n w=1u m=1
	mn001 (out net13 vssa vssa) nmos1 l=180n w=1u m=1
	mnpd2 (net13 pd vssa vssa) nmos1 l=180n w=1u m=1
	mnc01 (net13 net69 net12 vssa) nmos1 l=180n w=1u m=1
	mpb02 (net27 net51 net158 vdda) pmos1 l=180n w=1u m=1
	mppd1 (net158 xpd vdda vdda) pmos1 l=180n w=1u m=1
	mps11 (net31 net158 vdda vdda) pmos1 l=180n w=1u m=1
	mpd11 (net56 inn net31 net31) pmos1 l=180n w=1u m=1
	mp001 (out net158 vdda vdda) pmos1 l=180n w=1u m=1
	mpd12 (net13 inp net31 net31) pmos1 l=180n w=1u m=1
	mpb01 (net158 net158 vdda vdda) pmos1 l=180n w=1u m=1
ends OPAMP1_variant432

subckt OPAMP1_variant433 inn inp out pd xpd vdda vssa
	xd1 (vssa vdda) prim_nwd AREA=6.13907e-9 PJ=476.6e-6 m=1
	xi0 (vssa net69) prim_nd AREA=1e-12 PJ=4e-6 m=1
	xi3 (net51 vdda) prim_pd AREA=790e-15 PJ=3.3e-6 m=1
	xr0 (vssa vdda net51) prim_rdiffp l=2.1e-6 w=700e-9 m=1
	xr1 (vdda vdda net69) prim_rdiffp l=2.1e-6 w=700e-9 m=1
	xcc01 (net12 out) prim_cpoly c=1p m=1
	mnm12 (net13 net56 vssa vssa) nmos1 l=180n w=1u m=1
	mnm11 (net56 net56 vssa vssa) nmos1 l=180n w=1u m=1
	mnb02 (net27 net27 net21 vssa) nmos1 l=180n w=1u m=1
	mnpd1 (net21 xpd vssa vssa) nmos1 l=180n w=1u m=1
	mn001 (out net13 vssa vssa) nmos1 l=180n w=1u m=1
	mnpd2 (net13 pd vssa vssa) nmos1 l=1.0e-07n w=1.4e-06u m=1
	mnc01 (net13 net69 net12 vssa) nmos1 l=180n w=1u m=1
	mpb02 (net27 net51 net158 vdda) pmos1 l=1.5e-07n w=8.3e-07u m=1
	mppd1 (net158 xpd vdda vdda) pmos1 l=180n w=1u m=1
	mps11 (net31 net158 vdda vdda) pmos1 l=180n w=1u m=1
	mpd11 (net56 inn net31 net31) pmos1 l=180n w=1u m=1
	mp001 (out net158 vdda vdda) pmos1 l=180n w=1u m=1
	mpd12 (net13 inp net31 net31) pmos1 l=180n w=1u m=1
	mpb01 (net158 net158 vdda vdda) pmos1 l=2.1e-07n w=1.8e-06u m=1
ends OPAMP1_variant433

subckt OPAMP1_variant434 inn inp out pd xpd vdda vssa
	xd1 (vssa vdda) prim_nwd AREA=8.9e-10 PJ=6.4e-05 m=1
	xi0 (vssa net69) prim_nd AREA=1e-12 PJ=4e-6 m=1
	xi3 (net51 vdda) prim_pd AREA=790e-15 PJ=3.3e-6 m=1
	xr0 (vssa vdda net51) prim_rdiffp l=2.1e-6 w=700e-9 m=1
	xr1 (vdda vdda net69) prim_rdiffp l=1.9e-07 w=8.5e-07 m=1
	xcc01 (net12 out) prim_cpoly c=1p m=1
	mnm12 (net13 net56 vssa vssa) nmos1 l=180n w=1u m=1
	mnm11 (net56 net56 vssa vssa) nmos1 l=180n w=1u m=1
	mnb02 (net27 net27 net21 vssa) nmos1 l=180n w=1u m=1
	mnpd1 (net21 xpd vssa vssa) nmos1 l=180n w=1u m=1
	mn001 (out net13 vssa vssa) nmos1 l=180n w=1u m=1
	mnpd2 (net13 pd vssa vssa) nmos1 l=180n w=1u m=1
	mnc01 (net13 net69 net12 vssa) nmos1 l=180n w=1u m=1
	mpb02 (net27 net51 net158 vdda) pmos1 l=1.3e-07n w=1.6e-06u m=1
	mppd1 (net158 xpd vdda vdda) pmos1 l=180n w=1u m=1
	mps11 (net31 net158 vdda vdda) pmos1 l=180n w=1u m=1
	mpd11 (net56 inn net31 net31) pmos1 l=180n w=1u m=1
	mp001 (out net158 vdda vdda) pmos1 l=180n w=1u m=1
	mpd12 (net13 inp net31 net31) pmos1 l=180n w=1u m=1
	mpb01 (net158 net158 vdda vdda) pmos1 l=180n w=1u m=1
ends OPAMP1_variant434

subckt OPAMP1_variant435 inn inp out pd xpd vdda vssa
	xd1 (vssa vdda) prim_nwd AREA=6.13907e-9 PJ=476.6e-6 m=1
	xi0 (vssa net69) prim_nd AREA=1e-12 PJ=4e-6 m=1
	xi3 (net51 vdda) prim_pd AREA=790e-15 PJ=3.3e-6 m=1
	xr0 (vssa vdda net51) prim_rdiffp l=2.1e-6 w=700e-9 m=1
	xr1 (vdda vdda net69) prim_rdiffp l=2.8e-07 w=8.7e-07 m=1
	xcc01 (net12 out) prim_cpoly c=1p m=1
	mnm12 (net13 net56 vssa vssa) nmos1 l=180n w=1u m=1
	mnm11 (net56 net56 vssa vssa) nmos1 l=2.9e-07n w=6.0e-07u m=1
	mnb02 (net27 net27 net21 vssa) nmos1 l=180n w=1u m=1
	mnpd1 (net21 xpd vssa vssa) nmos1 l=180n w=1u m=1
	mn001 (out net13 vssa vssa) nmos1 l=180n w=1u m=1
	mnpd2 (net13 pd vssa vssa) nmos1 l=180n w=1u m=1
	mnc01 (net13 net69 net12 vssa) nmos1 l=2.7e-07n w=1.3e-06u m=1
	mpb02 (net27 net51 net158 vdda) pmos1 l=180n w=1u m=1
	mppd1 (net158 xpd vdda vdda) pmos1 l=180n w=1u m=1
	mps11 (net31 net158 vdda vdda) pmos1 l=180n w=1u m=1
	mpd11 (net56 inn net31 net31) pmos1 l=180n w=1u m=1
	mp001 (out net158 vdda vdda) pmos1 l=1.7e-07n w=1.1e-06u m=1
	mpd12 (net13 inp net31 net31) pmos1 l=2.2e-07n w=1.4e-06u m=1
	mpb01 (net158 net158 vdda vdda) pmos1 l=180n w=1u m=1
ends OPAMP1_variant435

subckt OPAMP1_variant436 inn inp out pd xpd vdda vssa
	xd1 (vssa vdda) prim_nwd AREA=6.13907e-9 PJ=476.6e-6 m=1
	xi0 (vssa net69) prim_nd AREA=1e-12 PJ=4e-6 m=1
	xi3 (net51 vdda) prim_pd AREA=790e-15 PJ=3.3e-6 m=1
	xr0 (vssa vdda net51) prim_rdiffp l=2.1e-6 w=700e-9 m=1
	xr1 (vdda vdda net69) prim_rdiffp l=2.1e-6 w=700e-9 m=1
	xcc01 (net12 out) prim_cpoly c=1p m=1
	mnm12 (net13 net56 vssa vssa) nmos1 l=180n w=1u m=1
	mnm11 (net56 net56 vssa vssa) nmos1 l=180n w=1u m=1
	mnb02 (net27 net27 net21 vssa) nmos1 l=180n w=1u m=1
	mnpd1 (net21 xpd vssa vssa) nmos1 l=2.5e-07n w=1.3e-06u m=1
	mn001 (out net13 vssa vssa) nmos1 l=180n w=1u m=1
	mnpd2 (net13 pd vssa vssa) nmos1 l=180n w=1u m=1
	mnc01 (net13 net69 net12 vssa) nmos1 l=180n w=1u m=1
	mpb02 (net27 net51 net158 vdda) pmos1 l=180n w=1u m=1
	mppd1 (net158 xpd vdda vdda) pmos1 l=1.3e-07n w=9.0e-07u m=1
	mps11 (net31 net158 vdda vdda) pmos1 l=180n w=1u m=1
	mpd11 (net56 inn net31 net31) pmos1 l=180n w=1u m=1
	mp001 (out net158 vdda vdda) pmos1 l=180n w=1u m=1
	mpd12 (net13 inp net31 net31) pmos1 l=180n w=1u m=1
	mpb01 (net158 net158 vdda vdda) pmos1 l=180n w=1u m=1
ends OPAMP1_variant436

subckt OPAMP1_variant437 inn inp out pd xpd vdda vssa
	xd1 (vssa vdda) prim_nwd AREA=6.13907e-9 PJ=476.6e-6 m=1
	xi0 (vssa net69) prim_nd AREA=1e-12 PJ=4e-6 m=1
	xi3 (net51 vdda) prim_pd AREA=790e-15 PJ=3.3e-6 m=1
	xr0 (vssa vdda net51) prim_rdiffp l=2.1e-6 w=700e-9 m=1
	xr1 (vdda vdda net69) prim_rdiffp l=2.1e-6 w=700e-9 m=1
	xcc01 (net12 out) prim_cpoly c=1p m=1
	mnm12 (net13 net56 vssa vssa) nmos1 l=180n w=1u m=1
	mnm11 (net56 net56 vssa vssa) nmos1 l=180n w=1u m=1
	mnb02 (net27 net27 net21 vssa) nmos1 l=2.2e-07n w=1.5e-06u m=1
	mnpd1 (net21 xpd vssa vssa) nmos1 l=180n w=1u m=1
	mn001 (out net13 vssa vssa) nmos1 l=180n w=1u m=1
	mnpd2 (net13 pd vssa vssa) nmos1 l=180n w=1u m=1
	mnc01 (net13 net69 net12 vssa) nmos1 l=180n w=1u m=1
	mpb02 (net27 net51 net158 vdda) pmos1 l=180n w=1u m=1
	mppd1 (net158 xpd vdda vdda) pmos1 l=180n w=1u m=1
	mps11 (net31 net158 vdda vdda) pmos1 l=180n w=1u m=1
	mpd11 (net56 inn net31 net31) pmos1 l=2.2e-07n w=1.5e-06u m=1
	mp001 (out net158 vdda vdda) pmos1 l=180n w=1u m=1
	mpd12 (net13 inp net31 net31) pmos1 l=180n w=1u m=1
	mpb01 (net158 net158 vdda vdda) pmos1 l=180n w=1u m=1
ends OPAMP1_variant437

subckt OPAMP1_variant438 inn inp out pd xpd vdda vssa
	xd1 (vssa vdda) prim_nwd AREA=3.4e-09 PJ=5.8e-05 m=1
	xi0 (vssa net69) prim_nd AREA=1e-12 PJ=4e-6 m=1
	xi3 (net51 vdda) prim_pd AREA=790e-15 PJ=3.3e-6 m=1
	xr0 (vssa vdda net51) prim_rdiffp l=1.0e-07 w=1.8e-06 m=1
	xr1 (vdda vdda net69) prim_rdiffp l=1.8e-07 w=1.5e-06 m=1
	xcc01 (net12 out) prim_cpoly c=1p m=1
	mnm12 (net13 net56 vssa vssa) nmos1 l=1.3e-07n w=1.4e-06u m=1
	mnm11 (net56 net56 vssa vssa) nmos1 l=180n w=1u m=1
	mnb02 (net27 net27 net21 vssa) nmos1 l=180n w=1u m=1
	mnpd1 (net21 xpd vssa vssa) nmos1 l=180n w=1u m=1
	mn001 (out net13 vssa vssa) nmos1 l=180n w=1u m=1
	mnpd2 (net13 pd vssa vssa) nmos1 l=180n w=1u m=1
	mnc01 (net13 net69 net12 vssa) nmos1 l=180n w=1u m=1
	mpb02 (net27 net51 net158 vdda) pmos1 l=180n w=1u m=1
	mppd1 (net158 xpd vdda vdda) pmos1 l=180n w=1u m=1
	mps11 (net31 net158 vdda vdda) pmos1 l=180n w=1u m=1
	mpd11 (net56 inn net31 net31) pmos1 l=180n w=1u m=1
	mp001 (out net158 vdda vdda) pmos1 l=180n w=1u m=1
	mpd12 (net13 inp net31 net31) pmos1 l=3.0e-07n w=8.1e-07u m=1
	mpb01 (net158 net158 vdda vdda) pmos1 l=180n w=1u m=1
ends OPAMP1_variant438

subckt OPAMP1_variant439 inn inp out pd xpd vdda vssa
	xd1 (vssa vdda) prim_nwd AREA=6.13907e-9 PJ=476.6e-6 m=1
	xi0 (vssa net69) prim_nd AREA=7.7e-09 PJ=5.4e-05 m=1
	xi3 (net51 vdda) prim_pd AREA=790e-15 PJ=3.3e-6 m=1
	xr0 (vssa vdda net51) prim_rdiffp l=2.2e-07 w=1.4e-06 m=1
	xr1 (vdda vdda net69) prim_rdiffp l=2.1e-6 w=700e-9 m=1
	xcc01 (net12 out) prim_cpoly c=1p m=1
	mnm12 (net13 net56 vssa vssa) nmos1 l=180n w=1u m=1
	mnm11 (net56 net56 vssa vssa) nmos1 l=180n w=1u m=1
	mnb02 (net27 net27 net21 vssa) nmos1 l=1.7e-07n w=1.6e-06u m=1
	mnpd1 (net21 xpd vssa vssa) nmos1 l=180n w=1u m=1
	mn001 (out net13 vssa vssa) nmos1 l=180n w=1u m=1
	mnpd2 (net13 pd vssa vssa) nmos1 l=180n w=1u m=1
	mnc01 (net13 net69 net12 vssa) nmos1 l=180n w=1u m=1
	mpb02 (net27 net51 net158 vdda) pmos1 l=180n w=1u m=1
	mppd1 (net158 xpd vdda vdda) pmos1 l=180n w=1u m=1
	mps11 (net31 net158 vdda vdda) pmos1 l=180n w=1u m=1
	mpd11 (net56 inn net31 net31) pmos1 l=180n w=1u m=1
	mp001 (out net158 vdda vdda) pmos1 l=180n w=1u m=1
	mpd12 (net13 inp net31 net31) pmos1 l=180n w=1u m=1
	mpb01 (net158 net158 vdda vdda) pmos1 l=180n w=1u m=1
ends OPAMP1_variant439

subckt OPAMP1_variant440 inn inp out pd xpd vdda vssa
	xd1 (vssa vdda) prim_nwd AREA=6.13907e-9 PJ=476.6e-6 m=1
	xi0 (vssa net69) prim_nd AREA=1e-12 PJ=4e-6 m=1
	xi3 (net51 vdda) prim_pd AREA=790e-15 PJ=3.3e-6 m=1
	xr0 (vssa vdda net51) prim_rdiffp l=2.1e-6 w=700e-9 m=1
	xr1 (vdda vdda net69) prim_rdiffp l=2.1e-6 w=700e-9 m=1
	xcc01 (net12 out) prim_cpoly c=1p m=1
	mnm12 (net13 net56 vssa vssa) nmos1 l=180n w=1u m=1
	mnm11 (net56 net56 vssa vssa) nmos1 l=180n w=1u m=1
	mnb02 (net27 net27 net21 vssa) nmos1 l=180n w=1u m=1
	mnpd1 (net21 xpd vssa vssa) nmos1 l=180n w=1u m=1
	mn001 (out net13 vssa vssa) nmos1 l=180n w=1u m=1
	mnpd2 (net13 pd vssa vssa) nmos1 l=1.4e-07n w=6.8e-07u m=1
	mnc01 (net13 net69 net12 vssa) nmos1 l=180n w=1u m=1
	mpb02 (net27 net51 net158 vdda) pmos1 l=180n w=1u m=1
	mppd1 (net158 xpd vdda vdda) pmos1 l=180n w=1u m=1
	mps11 (net31 net158 vdda vdda) pmos1 l=180n w=1u m=1
	mpd11 (net56 inn net31 net31) pmos1 l=2.1e-07n w=1.2e-06u m=1
	mp001 (out net158 vdda vdda) pmos1 l=180n w=1u m=1
	mpd12 (net13 inp net31 net31) pmos1 l=180n w=1u m=1
	mpb01 (net158 net158 vdda vdda) pmos1 l=180n w=1u m=1
ends OPAMP1_variant440

subckt OPAMP1_variant441 inn inp out pd xpd vdda vssa
	xd1 (vssa vdda) prim_nwd AREA=6.13907e-9 PJ=476.6e-6 m=1
	xi0 (vssa net69) prim_nd AREA=1e-12 PJ=4e-6 m=1
	xi3 (net51 vdda) prim_pd AREA=790e-15 PJ=3.3e-6 m=1
	xr0 (vssa vdda net51) prim_rdiffp l=2.2e-07 w=5.6e-07 m=1
	xr1 (vdda vdda net69) prim_rdiffp l=2.1e-6 w=700e-9 m=1
	xcc01 (net12 out) prim_cpoly c=1p m=1
	mnm12 (net13 net56 vssa vssa) nmos1 l=180n w=1u m=1
	mnm11 (net56 net56 vssa vssa) nmos1 l=180n w=1u m=1
	mnb02 (net27 net27 net21 vssa) nmos1 l=180n w=1u m=1
	mnpd1 (net21 xpd vssa vssa) nmos1 l=180n w=1u m=1
	mn001 (out net13 vssa vssa) nmos1 l=180n w=1u m=1
	mnpd2 (net13 pd vssa vssa) nmos1 l=180n w=1u m=1
	mnc01 (net13 net69 net12 vssa) nmos1 l=180n w=1u m=1
	mpb02 (net27 net51 net158 vdda) pmos1 l=180n w=1u m=1
	mppd1 (net158 xpd vdda vdda) pmos1 l=180n w=1u m=1
	mps11 (net31 net158 vdda vdda) pmos1 l=2.5e-07n w=1.0e-06u m=1
	mpd11 (net56 inn net31 net31) pmos1 l=180n w=1u m=1
	mp001 (out net158 vdda vdda) pmos1 l=180n w=1u m=1
	mpd12 (net13 inp net31 net31) pmos1 l=180n w=1u m=1
	mpb01 (net158 net158 vdda vdda) pmos1 l=180n w=1u m=1
ends OPAMP1_variant441

subckt OPAMP1_variant442 inn inp out pd xpd vdda vssa
	xd1 (vssa vdda) prim_nwd AREA=6.13907e-9 PJ=476.6e-6 m=1
	xi0 (vssa net69) prim_nd AREA=1e-12 PJ=4e-6 m=1
	xi3 (net51 vdda) prim_pd AREA=790e-15 PJ=3.3e-6 m=1
	xr0 (vssa vdda net51) prim_rdiffp l=2.1e-6 w=700e-9 m=1
	xr1 (vdda vdda net69) prim_rdiffp l=2.1e-6 w=700e-9 m=1
	xcc01 (net12 out) prim_cpoly c=1p m=1
	mnm12 (net13 net56 vssa vssa) nmos1 l=180n w=1u m=1
	mnm11 (net56 net56 vssa vssa) nmos1 l=1.2e-07n w=1.8e-06u m=1
	mnb02 (net27 net27 net21 vssa) nmos1 l=180n w=1u m=1
	mnpd1 (net21 xpd vssa vssa) nmos1 l=1.5e-07n w=1.1e-06u m=1
	mn001 (out net13 vssa vssa) nmos1 l=180n w=1u m=1
	mnpd2 (net13 pd vssa vssa) nmos1 l=180n w=1u m=1
	mnc01 (net13 net69 net12 vssa) nmos1 l=180n w=1u m=1
	mpb02 (net27 net51 net158 vdda) pmos1 l=2.0e-07n w=1.6e-06u m=1
	mppd1 (net158 xpd vdda vdda) pmos1 l=180n w=1u m=1
	mps11 (net31 net158 vdda vdda) pmos1 l=1.9e-07n w=1.5e-06u m=1
	mpd11 (net56 inn net31 net31) pmos1 l=180n w=1u m=1
	mp001 (out net158 vdda vdda) pmos1 l=180n w=1u m=1
	mpd12 (net13 inp net31 net31) pmos1 l=180n w=1u m=1
	mpb01 (net158 net158 vdda vdda) pmos1 l=180n w=1u m=1
ends OPAMP1_variant442

subckt OPAMP1_variant443 inn inp out pd xpd vdda vssa
	xd1 (vssa vdda) prim_nwd AREA=7.2e-09 PJ=1.7e-05 m=1
	xi0 (vssa net69) prim_nd AREA=1e-12 PJ=4e-6 m=1
	xi3 (net51 vdda) prim_pd AREA=790e-15 PJ=3.3e-6 m=1
	xr0 (vssa vdda net51) prim_rdiffp l=2.1e-6 w=700e-9 m=1
	xr1 (vdda vdda net69) prim_rdiffp l=2.1e-6 w=700e-9 m=1
	xcc01 (net12 out) prim_cpoly c=1.6e-12p m=1
	mnm12 (net13 net56 vssa vssa) nmos1 l=180n w=1u m=1
	mnm11 (net56 net56 vssa vssa) nmos1 l=180n w=1u m=1
	mnb02 (net27 net27 net21 vssa) nmos1 l=180n w=1u m=1
	mnpd1 (net21 xpd vssa vssa) nmos1 l=180n w=1u m=1
	mn001 (out net13 vssa vssa) nmos1 l=180n w=1u m=1
	mnpd2 (net13 pd vssa vssa) nmos1 l=180n w=1u m=1
	mnc01 (net13 net69 net12 vssa) nmos1 l=180n w=1u m=1
	mpb02 (net27 net51 net158 vdda) pmos1 l=180n w=1u m=1
	mppd1 (net158 xpd vdda vdda) pmos1 l=180n w=1u m=1
	mps11 (net31 net158 vdda vdda) pmos1 l=180n w=1u m=1
	mpd11 (net56 inn net31 net31) pmos1 l=180n w=1u m=1
	mp001 (out net158 vdda vdda) pmos1 l=180n w=1u m=1
	mpd12 (net13 inp net31 net31) pmos1 l=180n w=1u m=1
	mpb01 (net158 net158 vdda vdda) pmos1 l=180n w=1u m=1
ends OPAMP1_variant443

subckt OPAMP1_variant444 inn inp out pd xpd vdda vssa
	xd1 (vssa vdda) prim_nwd AREA=6.13907e-9 PJ=476.6e-6 m=1
	xi0 (vssa net69) prim_nd AREA=1e-12 PJ=4e-6 m=1
	xi3 (net51 vdda) prim_pd AREA=790e-15 PJ=3.3e-6 m=1
	xr0 (vssa vdda net51) prim_rdiffp l=2.1e-6 w=700e-9 m=1
	xr1 (vdda vdda net69) prim_rdiffp l=2.1e-6 w=700e-9 m=1
	xcc01 (net12 out) prim_cpoly c=1p m=1
	mnm12 (net13 net56 vssa vssa) nmos1 l=1.8e-07n w=1.6e-06u m=1
	mnm11 (net56 net56 vssa vssa) nmos1 l=180n w=1u m=1
	mnb02 (net27 net27 net21 vssa) nmos1 l=180n w=1u m=1
	mnpd1 (net21 xpd vssa vssa) nmos1 l=180n w=1u m=1
	mn001 (out net13 vssa vssa) nmos1 l=180n w=1u m=1
	mnpd2 (net13 pd vssa vssa) nmos1 l=180n w=1u m=1
	mnc01 (net13 net69 net12 vssa) nmos1 l=180n w=1u m=1
	mpb02 (net27 net51 net158 vdda) pmos1 l=180n w=1u m=1
	mppd1 (net158 xpd vdda vdda) pmos1 l=180n w=1u m=1
	mps11 (net31 net158 vdda vdda) pmos1 l=180n w=1u m=1
	mpd11 (net56 inn net31 net31) pmos1 l=2.6e-07n w=1.5e-06u m=1
	mp001 (out net158 vdda vdda) pmos1 l=180n w=1u m=1
	mpd12 (net13 inp net31 net31) pmos1 l=180n w=1u m=1
	mpb01 (net158 net158 vdda vdda) pmos1 l=180n w=1u m=1
ends OPAMP1_variant444

subckt OPAMP1_variant445 inn inp out pd xpd vdda vssa
	xd1 (vssa vdda) prim_nwd AREA=6.13907e-9 PJ=476.6e-6 m=1
	xi0 (vssa net69) prim_nd AREA=1.0e-09 PJ=6.2e-05 m=1
	xi3 (net51 vdda) prim_pd AREA=790e-15 PJ=3.3e-6 m=1
	xr0 (vssa vdda net51) prim_rdiffp l=2.1e-07 w=1.9e-06 m=1
	xr1 (vdda vdda net69) prim_rdiffp l=2.1e-6 w=700e-9 m=1
	xcc01 (net12 out) prim_cpoly c=2.0e-12p m=1
	mnm12 (net13 net56 vssa vssa) nmos1 l=180n w=1u m=1
	mnm11 (net56 net56 vssa vssa) nmos1 l=180n w=1u m=1
	mnb02 (net27 net27 net21 vssa) nmos1 l=180n w=1u m=1
	mnpd1 (net21 xpd vssa vssa) nmos1 l=2.0e-07n w=5.4e-07u m=1
	mn001 (out net13 vssa vssa) nmos1 l=180n w=1u m=1
	mnpd2 (net13 pd vssa vssa) nmos1 l=180n w=1u m=1
	mnc01 (net13 net69 net12 vssa) nmos1 l=180n w=1u m=1
	mpb02 (net27 net51 net158 vdda) pmos1 l=180n w=1u m=1
	mppd1 (net158 xpd vdda vdda) pmos1 l=180n w=1u m=1
	mps11 (net31 net158 vdda vdda) pmos1 l=180n w=1u m=1
	mpd11 (net56 inn net31 net31) pmos1 l=180n w=1u m=1
	mp001 (out net158 vdda vdda) pmos1 l=180n w=1u m=1
	mpd12 (net13 inp net31 net31) pmos1 l=2.7e-07n w=6.2e-07u m=1
	mpb01 (net158 net158 vdda vdda) pmos1 l=180n w=1u m=1
ends OPAMP1_variant445

subckt OPAMP1_variant446 inn inp out pd xpd vdda vssa
	xd1 (vssa vdda) prim_nwd AREA=6.4e-09 PJ=8.9e-05 m=1
	xi0 (vssa net69) prim_nd AREA=1e-12 PJ=4e-6 m=1
	xi3 (net51 vdda) prim_pd AREA=790e-15 PJ=3.3e-6 m=1
	xr0 (vssa vdda net51) prim_rdiffp l=1.7e-07 w=9.3e-07 m=1
	xr1 (vdda vdda net69) prim_rdiffp l=2.1e-6 w=700e-9 m=1
	xcc01 (net12 out) prim_cpoly c=1p m=1
	mnm12 (net13 net56 vssa vssa) nmos1 l=2.2e-07n w=1.6e-06u m=1
	mnm11 (net56 net56 vssa vssa) nmos1 l=180n w=1u m=1
	mnb02 (net27 net27 net21 vssa) nmos1 l=1.1e-07n w=8.2e-07u m=1
	mnpd1 (net21 xpd vssa vssa) nmos1 l=180n w=1u m=1
	mn001 (out net13 vssa vssa) nmos1 l=180n w=1u m=1
	mnpd2 (net13 pd vssa vssa) nmos1 l=180n w=1u m=1
	mnc01 (net13 net69 net12 vssa) nmos1 l=180n w=1u m=1
	mpb02 (net27 net51 net158 vdda) pmos1 l=180n w=1u m=1
	mppd1 (net158 xpd vdda vdda) pmos1 l=180n w=1u m=1
	mps11 (net31 net158 vdda vdda) pmos1 l=180n w=1u m=1
	mpd11 (net56 inn net31 net31) pmos1 l=180n w=1u m=1
	mp001 (out net158 vdda vdda) pmos1 l=180n w=1u m=1
	mpd12 (net13 inp net31 net31) pmos1 l=180n w=1u m=1
	mpb01 (net158 net158 vdda vdda) pmos1 l=180n w=1u m=1
ends OPAMP1_variant446

subckt OPAMP1_variant447 inn inp out pd xpd vdda vssa
	xd1 (vssa vdda) prim_nwd AREA=6.13907e-9 PJ=476.6e-6 m=1
	xi0 (vssa net69) prim_nd AREA=3.3e-09 PJ=8.6e-05 m=1
	xi3 (net51 vdda) prim_pd AREA=790e-15 PJ=3.3e-6 m=1
	xr0 (vssa vdda net51) prim_rdiffp l=2.1e-6 w=700e-9 m=1
	xr1 (vdda vdda net69) prim_rdiffp l=2.1e-6 w=700e-9 m=1
	xcc01 (net12 out) prim_cpoly c=1p m=1
	mnm12 (net13 net56 vssa vssa) nmos1 l=180n w=1u m=1
	mnm11 (net56 net56 vssa vssa) nmos1 l=180n w=1u m=1
	mnb02 (net27 net27 net21 vssa) nmos1 l=180n w=1u m=1
	mnpd1 (net21 xpd vssa vssa) nmos1 l=180n w=1u m=1
	mn001 (out net13 vssa vssa) nmos1 l=180n w=1u m=1
	mnpd2 (net13 pd vssa vssa) nmos1 l=1.9e-07n w=9.9e-07u m=1
	mnc01 (net13 net69 net12 vssa) nmos1 l=180n w=1u m=1
	mpb02 (net27 net51 net158 vdda) pmos1 l=1.9e-07n w=1.3e-06u m=1
	mppd1 (net158 xpd vdda vdda) pmos1 l=180n w=1u m=1
	mps11 (net31 net158 vdda vdda) pmos1 l=180n w=1u m=1
	mpd11 (net56 inn net31 net31) pmos1 l=180n w=1u m=1
	mp001 (out net158 vdda vdda) pmos1 l=180n w=1u m=1
	mpd12 (net13 inp net31 net31) pmos1 l=180n w=1u m=1
	mpb01 (net158 net158 vdda vdda) pmos1 l=180n w=1u m=1
ends OPAMP1_variant447

subckt OPAMP1_variant448 inn inp out pd xpd vdda vssa
	xd1 (vssa vdda) prim_nwd AREA=6.13907e-9 PJ=476.6e-6 m=1
	xi0 (vssa net69) prim_nd AREA=1e-12 PJ=4e-6 m=1
	xi3 (net51 vdda) prim_pd AREA=790e-15 PJ=3.3e-6 m=1
	xr0 (vssa vdda net51) prim_rdiffp l=2.1e-6 w=700e-9 m=1
	xr1 (vdda vdda net69) prim_rdiffp l=2.1e-6 w=700e-9 m=1
	xcc01 (net12 out) prim_cpoly c=1p m=1
	mnm12 (net13 net56 vssa vssa) nmos1 l=180n w=1u m=1
	mnm11 (net56 net56 vssa vssa) nmos1 l=1.1e-07n w=1.2e-06u m=1
	mnb02 (net27 net27 net21 vssa) nmos1 l=180n w=1u m=1
	mnpd1 (net21 xpd vssa vssa) nmos1 l=180n w=1u m=1
	mn001 (out net13 vssa vssa) nmos1 l=180n w=1u m=1
	mnpd2 (net13 pd vssa vssa) nmos1 l=180n w=1u m=1
	mnc01 (net13 net69 net12 vssa) nmos1 l=180n w=1u m=1
	mpb02 (net27 net51 net158 vdda) pmos1 l=180n w=1u m=1
	mppd1 (net158 xpd vdda vdda) pmos1 l=2.8e-07n w=1.5e-06u m=1
	mps11 (net31 net158 vdda vdda) pmos1 l=180n w=1u m=1
	mpd11 (net56 inn net31 net31) pmos1 l=180n w=1u m=1
	mp001 (out net158 vdda vdda) pmos1 l=180n w=1u m=1
	mpd12 (net13 inp net31 net31) pmos1 l=3.0e-07n w=2.0e-06u m=1
	mpb01 (net158 net158 vdda vdda) pmos1 l=180n w=1u m=1
ends OPAMP1_variant448

subckt OPAMP1_variant449 inn inp out pd xpd vdda vssa
	xd1 (vssa vdda) prim_nwd AREA=6.13907e-9 PJ=476.6e-6 m=1
	xi0 (vssa net69) prim_nd AREA=1e-12 PJ=4e-6 m=1
	xi3 (net51 vdda) prim_pd AREA=790e-15 PJ=3.3e-6 m=1
	xr0 (vssa vdda net51) prim_rdiffp l=2.1e-6 w=700e-9 m=1
	xr1 (vdda vdda net69) prim_rdiffp l=2.4e-07 w=1.4e-06 m=1
	xcc01 (net12 out) prim_cpoly c=1p m=1
	mnm12 (net13 net56 vssa vssa) nmos1 l=180n w=1u m=1
	mnm11 (net56 net56 vssa vssa) nmos1 l=180n w=1u m=1
	mnb02 (net27 net27 net21 vssa) nmos1 l=180n w=1u m=1
	mnpd1 (net21 xpd vssa vssa) nmos1 l=180n w=1u m=1
	mn001 (out net13 vssa vssa) nmos1 l=180n w=1u m=1
	mnpd2 (net13 pd vssa vssa) nmos1 l=1.2e-07n w=1.7e-06u m=1
	mnc01 (net13 net69 net12 vssa) nmos1 l=180n w=1u m=1
	mpb02 (net27 net51 net158 vdda) pmos1 l=180n w=1u m=1
	mppd1 (net158 xpd vdda vdda) pmos1 l=180n w=1u m=1
	mps11 (net31 net158 vdda vdda) pmos1 l=180n w=1u m=1
	mpd11 (net56 inn net31 net31) pmos1 l=180n w=1u m=1
	mp001 (out net158 vdda vdda) pmos1 l=180n w=1u m=1
	mpd12 (net13 inp net31 net31) pmos1 l=180n w=1u m=1
	mpb01 (net158 net158 vdda vdda) pmos1 l=180n w=1u m=1
ends OPAMP1_variant449

subckt OPAMP1_variant450 inn inp out pd xpd vdda vssa
	xd1 (vssa vdda) prim_nwd AREA=6.13907e-9 PJ=476.6e-6 m=1
	xi0 (vssa net69) prim_nd AREA=4.2e-09 PJ=4.6e-05 m=1
	xi3 (net51 vdda) prim_pd AREA=790e-15 PJ=3.3e-6 m=1
	xr0 (vssa vdda net51) prim_rdiffp l=2.1e-6 w=700e-9 m=1
	xr1 (vdda vdda net69) prim_rdiffp l=1.4e-07 w=1.7e-06 m=1
	xcc01 (net12 out) prim_cpoly c=1p m=1
	mnm12 (net13 net56 vssa vssa) nmos1 l=180n w=1u m=1
	mnm11 (net56 net56 vssa vssa) nmos1 l=180n w=1u m=1
	mnb02 (net27 net27 net21 vssa) nmos1 l=180n w=1u m=1
	mnpd1 (net21 xpd vssa vssa) nmos1 l=180n w=1u m=1
	mn001 (out net13 vssa vssa) nmos1 l=1.3e-07n w=9.0e-07u m=1
	mnpd2 (net13 pd vssa vssa) nmos1 l=180n w=1u m=1
	mnc01 (net13 net69 net12 vssa) nmos1 l=180n w=1u m=1
	mpb02 (net27 net51 net158 vdda) pmos1 l=180n w=1u m=1
	mppd1 (net158 xpd vdda vdda) pmos1 l=180n w=1u m=1
	mps11 (net31 net158 vdda vdda) pmos1 l=180n w=1u m=1
	mpd11 (net56 inn net31 net31) pmos1 l=180n w=1u m=1
	mp001 (out net158 vdda vdda) pmos1 l=180n w=1u m=1
	mpd12 (net13 inp net31 net31) pmos1 l=180n w=1u m=1
	mpb01 (net158 net158 vdda vdda) pmos1 l=180n w=1u m=1
ends OPAMP1_variant450

subckt OPAMP1_variant451 inn inp out pd xpd vdda vssa
	xd1 (vssa vdda) prim_nwd AREA=6.13907e-9 PJ=476.6e-6 m=1
	xi0 (vssa net69) prim_nd AREA=1e-12 PJ=4e-6 m=1
	xi3 (net51 vdda) prim_pd AREA=790e-15 PJ=3.3e-6 m=1
	xr0 (vssa vdda net51) prim_rdiffp l=2.1e-6 w=700e-9 m=1
	xr1 (vdda vdda net69) prim_rdiffp l=2.1e-6 w=700e-9 m=1
	xcc01 (net12 out) prim_cpoly c=1p m=1
	mnm12 (net13 net56 vssa vssa) nmos1 l=2.4e-07n w=1.8e-06u m=1
	mnm11 (net56 net56 vssa vssa) nmos1 l=180n w=1u m=1
	mnb02 (net27 net27 net21 vssa) nmos1 l=180n w=1u m=1
	mnpd1 (net21 xpd vssa vssa) nmos1 l=180n w=1u m=1
	mn001 (out net13 vssa vssa) nmos1 l=180n w=1u m=1
	mnpd2 (net13 pd vssa vssa) nmos1 l=180n w=1u m=1
	mnc01 (net13 net69 net12 vssa) nmos1 l=180n w=1u m=1
	mpb02 (net27 net51 net158 vdda) pmos1 l=2.3e-07n w=1.3e-06u m=1
	mppd1 (net158 xpd vdda vdda) pmos1 l=180n w=1u m=1
	mps11 (net31 net158 vdda vdda) pmos1 l=180n w=1u m=1
	mpd11 (net56 inn net31 net31) pmos1 l=180n w=1u m=1
	mp001 (out net158 vdda vdda) pmos1 l=180n w=1u m=1
	mpd12 (net13 inp net31 net31) pmos1 l=180n w=1u m=1
	mpb01 (net158 net158 vdda vdda) pmos1 l=180n w=1u m=1
ends OPAMP1_variant451

subckt OPAMP1_variant452 inn inp out pd xpd vdda vssa
	xd1 (vssa vdda) prim_nwd AREA=6.13907e-9 PJ=476.6e-6 m=1
	xi0 (vssa net69) prim_nd AREA=8.6e-09 PJ=3.6e-05 m=1
	xi3 (net51 vdda) prim_pd AREA=2.6e-09 PJ=9.7e-05 m=1
	xr0 (vssa vdda net51) prim_rdiffp l=2.1e-6 w=700e-9 m=1
	xr1 (vdda vdda net69) prim_rdiffp l=2.1e-6 w=700e-9 m=1
	xcc01 (net12 out) prim_cpoly c=1p m=1
	mnm12 (net13 net56 vssa vssa) nmos1 l=180n w=1u m=1
	mnm11 (net56 net56 vssa vssa) nmos1 l=1.7e-07n w=6.8e-07u m=1
	mnb02 (net27 net27 net21 vssa) nmos1 l=180n w=1u m=1
	mnpd1 (net21 xpd vssa vssa) nmos1 l=180n w=1u m=1
	mn001 (out net13 vssa vssa) nmos1 l=2.2e-07n w=1.2e-06u m=1
	mnpd2 (net13 pd vssa vssa) nmos1 l=180n w=1u m=1
	mnc01 (net13 net69 net12 vssa) nmos1 l=1.3e-07n w=1.4e-06u m=1
	mpb02 (net27 net51 net158 vdda) pmos1 l=180n w=1u m=1
	mppd1 (net158 xpd vdda vdda) pmos1 l=180n w=1u m=1
	mps11 (net31 net158 vdda vdda) pmos1 l=180n w=1u m=1
	mpd11 (net56 inn net31 net31) pmos1 l=180n w=1u m=1
	mp001 (out net158 vdda vdda) pmos1 l=180n w=1u m=1
	mpd12 (net13 inp net31 net31) pmos1 l=180n w=1u m=1
	mpb01 (net158 net158 vdda vdda) pmos1 l=180n w=1u m=1
ends OPAMP1_variant452

subckt OPAMP1_variant453 inn inp out pd xpd vdda vssa
	xd1 (vssa vdda) prim_nwd AREA=6.13907e-9 PJ=476.6e-6 m=1
	xi0 (vssa net69) prim_nd AREA=1e-12 PJ=4e-6 m=1
	xi3 (net51 vdda) prim_pd AREA=790e-15 PJ=3.3e-6 m=1
	xr0 (vssa vdda net51) prim_rdiffp l=2.3e-07 w=1.6e-06 m=1
	xr1 (vdda vdda net69) prim_rdiffp l=2.1e-6 w=700e-9 m=1
	xcc01 (net12 out) prim_cpoly c=1p m=1
	mnm12 (net13 net56 vssa vssa) nmos1 l=180n w=1u m=1
	mnm11 (net56 net56 vssa vssa) nmos1 l=180n w=1u m=1
	mnb02 (net27 net27 net21 vssa) nmos1 l=180n w=1u m=1
	mnpd1 (net21 xpd vssa vssa) nmos1 l=2.7e-07n w=8.9e-07u m=1
	mn001 (out net13 vssa vssa) nmos1 l=2.0e-07n w=9.9e-07u m=1
	mnpd2 (net13 pd vssa vssa) nmos1 l=180n w=1u m=1
	mnc01 (net13 net69 net12 vssa) nmos1 l=180n w=1u m=1
	mpb02 (net27 net51 net158 vdda) pmos1 l=180n w=1u m=1
	mppd1 (net158 xpd vdda vdda) pmos1 l=1.2e-07n w=9.8e-07u m=1
	mps11 (net31 net158 vdda vdda) pmos1 l=1.5e-07n w=6.3e-07u m=1
	mpd11 (net56 inn net31 net31) pmos1 l=180n w=1u m=1
	mp001 (out net158 vdda vdda) pmos1 l=180n w=1u m=1
	mpd12 (net13 inp net31 net31) pmos1 l=180n w=1u m=1
	mpb01 (net158 net158 vdda vdda) pmos1 l=180n w=1u m=1
ends OPAMP1_variant453

subckt OPAMP1_variant454 inn inp out pd xpd vdda vssa
	xd1 (vssa vdda) prim_nwd AREA=6.9e-09 PJ=8.6e-05 m=1
	xi0 (vssa net69) prim_nd AREA=1e-12 PJ=4e-6 m=1
	xi3 (net51 vdda) prim_pd AREA=790e-15 PJ=3.3e-6 m=1
	xr0 (vssa vdda net51) prim_rdiffp l=2.1e-6 w=700e-9 m=1
	xr1 (vdda vdda net69) prim_rdiffp l=2.1e-6 w=700e-9 m=1
	xcc01 (net12 out) prim_cpoly c=1p m=1
	mnm12 (net13 net56 vssa vssa) nmos1 l=2.3e-07n w=2.0e-06u m=1
	mnm11 (net56 net56 vssa vssa) nmos1 l=180n w=1u m=1
	mnb02 (net27 net27 net21 vssa) nmos1 l=2.6e-07n w=5.4e-07u m=1
	mnpd1 (net21 xpd vssa vssa) nmos1 l=180n w=1u m=1
	mn001 (out net13 vssa vssa) nmos1 l=180n w=1u m=1
	mnpd2 (net13 pd vssa vssa) nmos1 l=180n w=1u m=1
	mnc01 (net13 net69 net12 vssa) nmos1 l=180n w=1u m=1
	mpb02 (net27 net51 net158 vdda) pmos1 l=180n w=1u m=1
	mppd1 (net158 xpd vdda vdda) pmos1 l=2.8e-07n w=1.6e-06u m=1
	mps11 (net31 net158 vdda vdda) pmos1 l=180n w=1u m=1
	mpd11 (net56 inn net31 net31) pmos1 l=180n w=1u m=1
	mp001 (out net158 vdda vdda) pmos1 l=180n w=1u m=1
	mpd12 (net13 inp net31 net31) pmos1 l=2.6e-07n w=1.5e-06u m=1
	mpb01 (net158 net158 vdda vdda) pmos1 l=180n w=1u m=1
ends OPAMP1_variant454

subckt OPAMP1_variant455 inn inp out pd xpd vdda vssa
	xd1 (vssa vdda) prim_nwd AREA=6.13907e-9 PJ=476.6e-6 m=1
	xi0 (vssa net69) prim_nd AREA=1e-12 PJ=4e-6 m=1
	xi3 (net51 vdda) prim_pd AREA=790e-15 PJ=3.3e-6 m=1
	xr0 (vssa vdda net51) prim_rdiffp l=1.9e-07 w=1.5e-06 m=1
	xr1 (vdda vdda net69) prim_rdiffp l=2.1e-6 w=700e-9 m=1
	xcc01 (net12 out) prim_cpoly c=1.1e-12p m=1
	mnm12 (net13 net56 vssa vssa) nmos1 l=180n w=1u m=1
	mnm11 (net56 net56 vssa vssa) nmos1 l=180n w=1u m=1
	mnb02 (net27 net27 net21 vssa) nmos1 l=180n w=1u m=1
	mnpd1 (net21 xpd vssa vssa) nmos1 l=180n w=1u m=1
	mn001 (out net13 vssa vssa) nmos1 l=180n w=1u m=1
	mnpd2 (net13 pd vssa vssa) nmos1 l=1.7e-07n w=1.4e-06u m=1
	mnc01 (net13 net69 net12 vssa) nmos1 l=180n w=1u m=1
	mpb02 (net27 net51 net158 vdda) pmos1 l=180n w=1u m=1
	mppd1 (net158 xpd vdda vdda) pmos1 l=1.9e-07n w=1.9e-06u m=1
	mps11 (net31 net158 vdda vdda) pmos1 l=2.8e-07n w=5.5e-07u m=1
	mpd11 (net56 inn net31 net31) pmos1 l=180n w=1u m=1
	mp001 (out net158 vdda vdda) pmos1 l=180n w=1u m=1
	mpd12 (net13 inp net31 net31) pmos1 l=180n w=1u m=1
	mpb01 (net158 net158 vdda vdda) pmos1 l=180n w=1u m=1
ends OPAMP1_variant455

subckt OPAMP1_variant456 inn inp out pd xpd vdda vssa
	xd1 (vssa vdda) prim_nwd AREA=6.13907e-9 PJ=476.6e-6 m=1
	xi0 (vssa net69) prim_nd AREA=1e-12 PJ=4e-6 m=1
	xi3 (net51 vdda) prim_pd AREA=790e-15 PJ=3.3e-6 m=1
	xr0 (vssa vdda net51) prim_rdiffp l=2.1e-07 w=6.8e-07 m=1
	xr1 (vdda vdda net69) prim_rdiffp l=2.1e-6 w=700e-9 m=1
	xcc01 (net12 out) prim_cpoly c=1p m=1
	mnm12 (net13 net56 vssa vssa) nmos1 l=1.3e-07n w=5.5e-07u m=1
	mnm11 (net56 net56 vssa vssa) nmos1 l=180n w=1u m=1
	mnb02 (net27 net27 net21 vssa) nmos1 l=180n w=1u m=1
	mnpd1 (net21 xpd vssa vssa) nmos1 l=180n w=1u m=1
	mn001 (out net13 vssa vssa) nmos1 l=180n w=1u m=1
	mnpd2 (net13 pd vssa vssa) nmos1 l=180n w=1u m=1
	mnc01 (net13 net69 net12 vssa) nmos1 l=180n w=1u m=1
	mpb02 (net27 net51 net158 vdda) pmos1 l=180n w=1u m=1
	mppd1 (net158 xpd vdda vdda) pmos1 l=180n w=1u m=1
	mps11 (net31 net158 vdda vdda) pmos1 l=180n w=1u m=1
	mpd11 (net56 inn net31 net31) pmos1 l=180n w=1u m=1
	mp001 (out net158 vdda vdda) pmos1 l=180n w=1u m=1
	mpd12 (net13 inp net31 net31) pmos1 l=180n w=1u m=1
	mpb01 (net158 net158 vdda vdda) pmos1 l=180n w=1u m=1
ends OPAMP1_variant456

subckt OPAMP1_variant457 inn inp out pd xpd vdda vssa
	xd1 (vssa vdda) prim_nwd AREA=6.13907e-9 PJ=476.6e-6 m=1
	xi0 (vssa net69) prim_nd AREA=1e-12 PJ=4e-6 m=1
	xi3 (net51 vdda) prim_pd AREA=790e-15 PJ=3.3e-6 m=1
	xr0 (vssa vdda net51) prim_rdiffp l=2.1e-6 w=700e-9 m=1
	xr1 (vdda vdda net69) prim_rdiffp l=2.1e-6 w=700e-9 m=1
	xcc01 (net12 out) prim_cpoly c=1p m=1
	mnm12 (net13 net56 vssa vssa) nmos1 l=180n w=1u m=1
	mnm11 (net56 net56 vssa vssa) nmos1 l=180n w=1u m=1
	mnb02 (net27 net27 net21 vssa) nmos1 l=180n w=1u m=1
	mnpd1 (net21 xpd vssa vssa) nmos1 l=1.0e-07n w=1.7e-06u m=1
	mn001 (out net13 vssa vssa) nmos1 l=180n w=1u m=1
	mnpd2 (net13 pd vssa vssa) nmos1 l=180n w=1u m=1
	mnc01 (net13 net69 net12 vssa) nmos1 l=2.4e-07n w=1.5e-06u m=1
	mpb02 (net27 net51 net158 vdda) pmos1 l=1.7e-07n w=1.7e-06u m=1
	mppd1 (net158 xpd vdda vdda) pmos1 l=180n w=1u m=1
	mps11 (net31 net158 vdda vdda) pmos1 l=180n w=1u m=1
	mpd11 (net56 inn net31 net31) pmos1 l=180n w=1u m=1
	mp001 (out net158 vdda vdda) pmos1 l=180n w=1u m=1
	mpd12 (net13 inp net31 net31) pmos1 l=2.7e-07n w=1.7e-06u m=1
	mpb01 (net158 net158 vdda vdda) pmos1 l=2.3e-07n w=1.4e-06u m=1
ends OPAMP1_variant457

subckt OPAMP1_variant458 inn inp out pd xpd vdda vssa
	xd1 (vssa vdda) prim_nwd AREA=6.13907e-9 PJ=476.6e-6 m=1
	xi0 (vssa net69) prim_nd AREA=1e-12 PJ=4e-6 m=1
	xi3 (net51 vdda) prim_pd AREA=790e-15 PJ=3.3e-6 m=1
	xr0 (vssa vdda net51) prim_rdiffp l=2.1e-6 w=700e-9 m=1
	xr1 (vdda vdda net69) prim_rdiffp l=2.1e-6 w=700e-9 m=1
	xcc01 (net12 out) prim_cpoly c=1p m=1
	mnm12 (net13 net56 vssa vssa) nmos1 l=180n w=1u m=1
	mnm11 (net56 net56 vssa vssa) nmos1 l=180n w=1u m=1
	mnb02 (net27 net27 net21 vssa) nmos1 l=2.1e-07n w=1.1e-06u m=1
	mnpd1 (net21 xpd vssa vssa) nmos1 l=180n w=1u m=1
	mn001 (out net13 vssa vssa) nmos1 l=180n w=1u m=1
	mnpd2 (net13 pd vssa vssa) nmos1 l=180n w=1u m=1
	mnc01 (net13 net69 net12 vssa) nmos1 l=180n w=1u m=1
	mpb02 (net27 net51 net158 vdda) pmos1 l=180n w=1u m=1
	mppd1 (net158 xpd vdda vdda) pmos1 l=1.5e-07n w=1.6e-06u m=1
	mps11 (net31 net158 vdda vdda) pmos1 l=180n w=1u m=1
	mpd11 (net56 inn net31 net31) pmos1 l=180n w=1u m=1
	mp001 (out net158 vdda vdda) pmos1 l=180n w=1u m=1
	mpd12 (net13 inp net31 net31) pmos1 l=180n w=1u m=1
	mpb01 (net158 net158 vdda vdda) pmos1 l=180n w=1u m=1
ends OPAMP1_variant458

subckt OPAMP1_variant459 inn inp out pd xpd vdda vssa
	xd1 (vssa vdda) prim_nwd AREA=7.4e-09 PJ=6.5e-05 m=1
	xi0 (vssa net69) prim_nd AREA=1e-12 PJ=4e-6 m=1
	xi3 (net51 vdda) prim_pd AREA=790e-15 PJ=3.3e-6 m=1
	xr0 (vssa vdda net51) prim_rdiffp l=2.1e-6 w=700e-9 m=1
	xr1 (vdda vdda net69) prim_rdiffp l=2.2e-07 w=6.7e-07 m=1
	xcc01 (net12 out) prim_cpoly c=1p m=1
	mnm12 (net13 net56 vssa vssa) nmos1 l=180n w=1u m=1
	mnm11 (net56 net56 vssa vssa) nmos1 l=180n w=1u m=1
	mnb02 (net27 net27 net21 vssa) nmos1 l=180n w=1u m=1
	mnpd1 (net21 xpd vssa vssa) nmos1 l=180n w=1u m=1
	mn001 (out net13 vssa vssa) nmos1 l=2.4e-07n w=8.7e-07u m=1
	mnpd2 (net13 pd vssa vssa) nmos1 l=180n w=1u m=1
	mnc01 (net13 net69 net12 vssa) nmos1 l=180n w=1u m=1
	mpb02 (net27 net51 net158 vdda) pmos1 l=180n w=1u m=1
	mppd1 (net158 xpd vdda vdda) pmos1 l=180n w=1u m=1
	mps11 (net31 net158 vdda vdda) pmos1 l=2.9e-07n w=1.4e-06u m=1
	mpd11 (net56 inn net31 net31) pmos1 l=180n w=1u m=1
	mp001 (out net158 vdda vdda) pmos1 l=180n w=1u m=1
	mpd12 (net13 inp net31 net31) pmos1 l=2.0e-07n w=1.0e-06u m=1
	mpb01 (net158 net158 vdda vdda) pmos1 l=180n w=1u m=1
ends OPAMP1_variant459

subckt OPAMP1_variant460 inn inp out pd xpd vdda vssa
	xd1 (vssa vdda) prim_nwd AREA=6.13907e-9 PJ=476.6e-6 m=1
	xi0 (vssa net69) prim_nd AREA=1e-12 PJ=4e-6 m=1
	xi3 (net51 vdda) prim_pd AREA=790e-15 PJ=3.3e-6 m=1
	xr0 (vssa vdda net51) prim_rdiffp l=2.8e-07 w=1.0e-06 m=1
	xr1 (vdda vdda net69) prim_rdiffp l=2.1e-6 w=700e-9 m=1
	xcc01 (net12 out) prim_cpoly c=1p m=1
	mnm12 (net13 net56 vssa vssa) nmos1 l=180n w=1u m=1
	mnm11 (net56 net56 vssa vssa) nmos1 l=180n w=1u m=1
	mnb02 (net27 net27 net21 vssa) nmos1 l=180n w=1u m=1
	mnpd1 (net21 xpd vssa vssa) nmos1 l=180n w=1u m=1
	mn001 (out net13 vssa vssa) nmos1 l=180n w=1u m=1
	mnpd2 (net13 pd vssa vssa) nmos1 l=180n w=1u m=1
	mnc01 (net13 net69 net12 vssa) nmos1 l=180n w=1u m=1
	mpb02 (net27 net51 net158 vdda) pmos1 l=180n w=1u m=1
	mppd1 (net158 xpd vdda vdda) pmos1 l=180n w=1u m=1
	mps11 (net31 net158 vdda vdda) pmos1 l=180n w=1u m=1
	mpd11 (net56 inn net31 net31) pmos1 l=180n w=1u m=1
	mp001 (out net158 vdda vdda) pmos1 l=180n w=1u m=1
	mpd12 (net13 inp net31 net31) pmos1 l=2.3e-07n w=9.1e-07u m=1
	mpb01 (net158 net158 vdda vdda) pmos1 l=1.2e-07n w=1.8e-06u m=1
ends OPAMP1_variant460

subckt OPAMP1_variant461 inn inp out pd xpd vdda vssa
	xd1 (vssa vdda) prim_nwd AREA=6.13907e-9 PJ=476.6e-6 m=1
	xi0 (vssa net69) prim_nd AREA=1e-12 PJ=4e-6 m=1
	xi3 (net51 vdda) prim_pd AREA=1.1e-09 PJ=5.3e-05 m=1
	xr0 (vssa vdda net51) prim_rdiffp l=2.1e-6 w=700e-9 m=1
	xr1 (vdda vdda net69) prim_rdiffp l=2.1e-6 w=700e-9 m=1
	xcc01 (net12 out) prim_cpoly c=1p m=1
	mnm12 (net13 net56 vssa vssa) nmos1 l=180n w=1u m=1
	mnm11 (net56 net56 vssa vssa) nmos1 l=1.6e-07n w=5.7e-07u m=1
	mnb02 (net27 net27 net21 vssa) nmos1 l=180n w=1u m=1
	mnpd1 (net21 xpd vssa vssa) nmos1 l=180n w=1u m=1
	mn001 (out net13 vssa vssa) nmos1 l=180n w=1u m=1
	mnpd2 (net13 pd vssa vssa) nmos1 l=180n w=1u m=1
	mnc01 (net13 net69 net12 vssa) nmos1 l=180n w=1u m=1
	mpb02 (net27 net51 net158 vdda) pmos1 l=180n w=1u m=1
	mppd1 (net158 xpd vdda vdda) pmos1 l=180n w=1u m=1
	mps11 (net31 net158 vdda vdda) pmos1 l=180n w=1u m=1
	mpd11 (net56 inn net31 net31) pmos1 l=1.6e-07n w=1.6e-06u m=1
	mp001 (out net158 vdda vdda) pmos1 l=180n w=1u m=1
	mpd12 (net13 inp net31 net31) pmos1 l=1.8e-07n w=8.4e-07u m=1
	mpb01 (net158 net158 vdda vdda) pmos1 l=2.2e-07n w=1.6e-06u m=1
ends OPAMP1_variant461

subckt OPAMP1_variant462 inn inp out pd xpd vdda vssa
	xd1 (vssa vdda) prim_nwd AREA=6.13907e-9 PJ=476.6e-6 m=1
	xi0 (vssa net69) prim_nd AREA=1.9e-09 PJ=3.7e-05 m=1
	xi3 (net51 vdda) prim_pd AREA=790e-15 PJ=3.3e-6 m=1
	xr0 (vssa vdda net51) prim_rdiffp l=2.1e-6 w=700e-9 m=1
	xr1 (vdda vdda net69) prim_rdiffp l=2.1e-6 w=700e-9 m=1
	xcc01 (net12 out) prim_cpoly c=1.8e-12p m=1
	mnm12 (net13 net56 vssa vssa) nmos1 l=180n w=1u m=1
	mnm11 (net56 net56 vssa vssa) nmos1 l=1.2e-07n w=1.8e-06u m=1
	mnb02 (net27 net27 net21 vssa) nmos1 l=180n w=1u m=1
	mnpd1 (net21 xpd vssa vssa) nmos1 l=180n w=1u m=1
	mn001 (out net13 vssa vssa) nmos1 l=180n w=1u m=1
	mnpd2 (net13 pd vssa vssa) nmos1 l=180n w=1u m=1
	mnc01 (net13 net69 net12 vssa) nmos1 l=180n w=1u m=1
	mpb02 (net27 net51 net158 vdda) pmos1 l=180n w=1u m=1
	mppd1 (net158 xpd vdda vdda) pmos1 l=2.0e-07n w=1.9e-06u m=1
	mps11 (net31 net158 vdda vdda) pmos1 l=180n w=1u m=1
	mpd11 (net56 inn net31 net31) pmos1 l=180n w=1u m=1
	mp001 (out net158 vdda vdda) pmos1 l=180n w=1u m=1
	mpd12 (net13 inp net31 net31) pmos1 l=180n w=1u m=1
	mpb01 (net158 net158 vdda vdda) pmos1 l=1.5e-07n w=1.5e-06u m=1
ends OPAMP1_variant462

subckt OPAMP1_variant463 inn inp out pd xpd vdda vssa
	xd1 (vssa vdda) prim_nwd AREA=6.13907e-9 PJ=476.6e-6 m=1
	xi0 (vssa net69) prim_nd AREA=3.5e-09 PJ=1.9e-06 m=1
	xi3 (net51 vdda) prim_pd AREA=1.0e-09 PJ=4.5e-05 m=1
	xr0 (vssa vdda net51) prim_rdiffp l=2.1e-6 w=700e-9 m=1
	xr1 (vdda vdda net69) prim_rdiffp l=2.1e-6 w=700e-9 m=1
	xcc01 (net12 out) prim_cpoly c=1p m=1
	mnm12 (net13 net56 vssa vssa) nmos1 l=180n w=1u m=1
	mnm11 (net56 net56 vssa vssa) nmos1 l=180n w=1u m=1
	mnb02 (net27 net27 net21 vssa) nmos1 l=180n w=1u m=1
	mnpd1 (net21 xpd vssa vssa) nmos1 l=180n w=1u m=1
	mn001 (out net13 vssa vssa) nmos1 l=180n w=1u m=1
	mnpd2 (net13 pd vssa vssa) nmos1 l=180n w=1u m=1
	mnc01 (net13 net69 net12 vssa) nmos1 l=180n w=1u m=1
	mpb02 (net27 net51 net158 vdda) pmos1 l=1.9e-07n w=1.8e-06u m=1
	mppd1 (net158 xpd vdda vdda) pmos1 l=2.2e-07n w=1.4e-06u m=1
	mps11 (net31 net158 vdda vdda) pmos1 l=180n w=1u m=1
	mpd11 (net56 inn net31 net31) pmos1 l=2.8e-07n w=1.9e-06u m=1
	mp001 (out net158 vdda vdda) pmos1 l=180n w=1u m=1
	mpd12 (net13 inp net31 net31) pmos1 l=180n w=1u m=1
	mpb01 (net158 net158 vdda vdda) pmos1 l=180n w=1u m=1
ends OPAMP1_variant463

subckt OPAMP1_variant464 inn inp out pd xpd vdda vssa
	xd1 (vssa vdda) prim_nwd AREA=6.13907e-9 PJ=476.6e-6 m=1
	xi0 (vssa net69) prim_nd AREA=1e-12 PJ=4e-6 m=1
	xi3 (net51 vdda) prim_pd AREA=9.5e-09 PJ=8.0e-05 m=1
	xr0 (vssa vdda net51) prim_rdiffp l=1.7e-07 w=1.0e-06 m=1
	xr1 (vdda vdda net69) prim_rdiffp l=2.1e-6 w=700e-9 m=1
	xcc01 (net12 out) prim_cpoly c=1p m=1
	mnm12 (net13 net56 vssa vssa) nmos1 l=180n w=1u m=1
	mnm11 (net56 net56 vssa vssa) nmos1 l=180n w=1u m=1
	mnb02 (net27 net27 net21 vssa) nmos1 l=180n w=1u m=1
	mnpd1 (net21 xpd vssa vssa) nmos1 l=180n w=1u m=1
	mn001 (out net13 vssa vssa) nmos1 l=180n w=1u m=1
	mnpd2 (net13 pd vssa vssa) nmos1 l=2.5e-07n w=6.1e-07u m=1
	mnc01 (net13 net69 net12 vssa) nmos1 l=1.1e-07n w=1.5e-06u m=1
	mpb02 (net27 net51 net158 vdda) pmos1 l=1.9e-07n w=8.1e-07u m=1
	mppd1 (net158 xpd vdda vdda) pmos1 l=180n w=1u m=1
	mps11 (net31 net158 vdda vdda) pmos1 l=180n w=1u m=1
	mpd11 (net56 inn net31 net31) pmos1 l=180n w=1u m=1
	mp001 (out net158 vdda vdda) pmos1 l=180n w=1u m=1
	mpd12 (net13 inp net31 net31) pmos1 l=180n w=1u m=1
	mpb01 (net158 net158 vdda vdda) pmos1 l=180n w=1u m=1
ends OPAMP1_variant464

subckt OPAMP1_variant465 inn inp out pd xpd vdda vssa
	xd1 (vssa vdda) prim_nwd AREA=6.13907e-9 PJ=476.6e-6 m=1
	xi0 (vssa net69) prim_nd AREA=1e-12 PJ=4e-6 m=1
	xi3 (net51 vdda) prim_pd AREA=790e-15 PJ=3.3e-6 m=1
	xr0 (vssa vdda net51) prim_rdiffp l=2.1e-6 w=700e-9 m=1
	xr1 (vdda vdda net69) prim_rdiffp l=2.1e-6 w=700e-9 m=1
	xcc01 (net12 out) prim_cpoly c=1p m=1
	mnm12 (net13 net56 vssa vssa) nmos1 l=180n w=1u m=1
	mnm11 (net56 net56 vssa vssa) nmos1 l=180n w=1u m=1
	mnb02 (net27 net27 net21 vssa) nmos1 l=180n w=1u m=1
	mnpd1 (net21 xpd vssa vssa) nmos1 l=180n w=1u m=1
	mn001 (out net13 vssa vssa) nmos1 l=180n w=1u m=1
	mnpd2 (net13 pd vssa vssa) nmos1 l=2.5e-07n w=2.0e-06u m=1
	mnc01 (net13 net69 net12 vssa) nmos1 l=180n w=1u m=1
	mpb02 (net27 net51 net158 vdda) pmos1 l=180n w=1u m=1
	mppd1 (net158 xpd vdda vdda) pmos1 l=180n w=1u m=1
	mps11 (net31 net158 vdda vdda) pmos1 l=1.6e-07n w=5.3e-07u m=1
	mpd11 (net56 inn net31 net31) pmos1 l=180n w=1u m=1
	mp001 (out net158 vdda vdda) pmos1 l=180n w=1u m=1
	mpd12 (net13 inp net31 net31) pmos1 l=180n w=1u m=1
	mpb01 (net158 net158 vdda vdda) pmos1 l=180n w=1u m=1
ends OPAMP1_variant465

subckt OPAMP1_variant466 inn inp out pd xpd vdda vssa
	xd1 (vssa vdda) prim_nwd AREA=6.13907e-9 PJ=476.6e-6 m=1
	xi0 (vssa net69) prim_nd AREA=4.8e-09 PJ=7.9e-05 m=1
	xi3 (net51 vdda) prim_pd AREA=9.6e-09 PJ=5.7e-05 m=1
	xr0 (vssa vdda net51) prim_rdiffp l=2.1e-6 w=700e-9 m=1
	xr1 (vdda vdda net69) prim_rdiffp l=2.1e-6 w=700e-9 m=1
	xcc01 (net12 out) prim_cpoly c=1p m=1
	mnm12 (net13 net56 vssa vssa) nmos1 l=1.6e-07n w=1.6e-06u m=1
	mnm11 (net56 net56 vssa vssa) nmos1 l=180n w=1u m=1
	mnb02 (net27 net27 net21 vssa) nmos1 l=180n w=1u m=1
	mnpd1 (net21 xpd vssa vssa) nmos1 l=180n w=1u m=1
	mn001 (out net13 vssa vssa) nmos1 l=180n w=1u m=1
	mnpd2 (net13 pd vssa vssa) nmos1 l=180n w=1u m=1
	mnc01 (net13 net69 net12 vssa) nmos1 l=2.2e-07n w=9.9e-07u m=1
	mpb02 (net27 net51 net158 vdda) pmos1 l=180n w=1u m=1
	mppd1 (net158 xpd vdda vdda) pmos1 l=180n w=1u m=1
	mps11 (net31 net158 vdda vdda) pmos1 l=180n w=1u m=1
	mpd11 (net56 inn net31 net31) pmos1 l=180n w=1u m=1
	mp001 (out net158 vdda vdda) pmos1 l=180n w=1u m=1
	mpd12 (net13 inp net31 net31) pmos1 l=180n w=1u m=1
	mpb01 (net158 net158 vdda vdda) pmos1 l=180n w=1u m=1
ends OPAMP1_variant466

subckt OPAMP1_variant467 inn inp out pd xpd vdda vssa
	xd1 (vssa vdda) prim_nwd AREA=6.13907e-9 PJ=476.6e-6 m=1
	xi0 (vssa net69) prim_nd AREA=1e-12 PJ=4e-6 m=1
	xi3 (net51 vdda) prim_pd AREA=790e-15 PJ=3.3e-6 m=1
	xr0 (vssa vdda net51) prim_rdiffp l=1.6e-07 w=1.8e-06 m=1
	xr1 (vdda vdda net69) prim_rdiffp l=2.1e-6 w=700e-9 m=1
	xcc01 (net12 out) prim_cpoly c=1.6e-12p m=1
	mnm12 (net13 net56 vssa vssa) nmos1 l=180n w=1u m=1
	mnm11 (net56 net56 vssa vssa) nmos1 l=180n w=1u m=1
	mnb02 (net27 net27 net21 vssa) nmos1 l=180n w=1u m=1
	mnpd1 (net21 xpd vssa vssa) nmos1 l=180n w=1u m=1
	mn001 (out net13 vssa vssa) nmos1 l=180n w=1u m=1
	mnpd2 (net13 pd vssa vssa) nmos1 l=180n w=1u m=1
	mnc01 (net13 net69 net12 vssa) nmos1 l=180n w=1u m=1
	mpb02 (net27 net51 net158 vdda) pmos1 l=180n w=1u m=1
	mppd1 (net158 xpd vdda vdda) pmos1 l=180n w=1u m=1
	mps11 (net31 net158 vdda vdda) pmos1 l=180n w=1u m=1
	mpd11 (net56 inn net31 net31) pmos1 l=180n w=1u m=1
	mp001 (out net158 vdda vdda) pmos1 l=180n w=1u m=1
	mpd12 (net13 inp net31 net31) pmos1 l=180n w=1u m=1
	mpb01 (net158 net158 vdda vdda) pmos1 l=180n w=1u m=1
ends OPAMP1_variant467

subckt OPAMP1_variant468 inn inp out pd xpd vdda vssa
	xd1 (vssa vdda) prim_nwd AREA=6.13907e-9 PJ=476.6e-6 m=1
	xi0 (vssa net69) prim_nd AREA=1e-12 PJ=4e-6 m=1
	xi3 (net51 vdda) prim_pd AREA=790e-15 PJ=3.3e-6 m=1
	xr0 (vssa vdda net51) prim_rdiffp l=2.1e-6 w=700e-9 m=1
	xr1 (vdda vdda net69) prim_rdiffp l=2.1e-6 w=700e-9 m=1
	xcc01 (net12 out) prim_cpoly c=1p m=1
	mnm12 (net13 net56 vssa vssa) nmos1 l=180n w=1u m=1
	mnm11 (net56 net56 vssa vssa) nmos1 l=180n w=1u m=1
	mnb02 (net27 net27 net21 vssa) nmos1 l=2.8e-07n w=1.3e-06u m=1
	mnpd1 (net21 xpd vssa vssa) nmos1 l=180n w=1u m=1
	mn001 (out net13 vssa vssa) nmos1 l=180n w=1u m=1
	mnpd2 (net13 pd vssa vssa) nmos1 l=1.1e-07n w=8.1e-07u m=1
	mnc01 (net13 net69 net12 vssa) nmos1 l=180n w=1u m=1
	mpb02 (net27 net51 net158 vdda) pmos1 l=180n w=1u m=1
	mppd1 (net158 xpd vdda vdda) pmos1 l=180n w=1u m=1
	mps11 (net31 net158 vdda vdda) pmos1 l=1.6e-07n w=1.5e-06u m=1
	mpd11 (net56 inn net31 net31) pmos1 l=180n w=1u m=1
	mp001 (out net158 vdda vdda) pmos1 l=1.2e-07n w=6.3e-07u m=1
	mpd12 (net13 inp net31 net31) pmos1 l=2.8e-07n w=1.0e-06u m=1
	mpb01 (net158 net158 vdda vdda) pmos1 l=180n w=1u m=1
ends OPAMP1_variant468

subckt OPAMP1_variant469 inn inp out pd xpd vdda vssa
	xd1 (vssa vdda) prim_nwd AREA=6.1e-09 PJ=8.9e-05 m=1
	xi0 (vssa net69) prim_nd AREA=1e-12 PJ=4e-6 m=1
	xi3 (net51 vdda) prim_pd AREA=790e-15 PJ=3.3e-6 m=1
	xr0 (vssa vdda net51) prim_rdiffp l=2.1e-6 w=700e-9 m=1
	xr1 (vdda vdda net69) prim_rdiffp l=2.1e-6 w=700e-9 m=1
	xcc01 (net12 out) prim_cpoly c=1p m=1
	mnm12 (net13 net56 vssa vssa) nmos1 l=180n w=1u m=1
	mnm11 (net56 net56 vssa vssa) nmos1 l=180n w=1u m=1
	mnb02 (net27 net27 net21 vssa) nmos1 l=180n w=1u m=1
	mnpd1 (net21 xpd vssa vssa) nmos1 l=180n w=1u m=1
	mn001 (out net13 vssa vssa) nmos1 l=180n w=1u m=1
	mnpd2 (net13 pd vssa vssa) nmos1 l=180n w=1u m=1
	mnc01 (net13 net69 net12 vssa) nmos1 l=180n w=1u m=1
	mpb02 (net27 net51 net158 vdda) pmos1 l=180n w=1u m=1
	mppd1 (net158 xpd vdda vdda) pmos1 l=180n w=1u m=1
	mps11 (net31 net158 vdda vdda) pmos1 l=1.5e-07n w=9.2e-07u m=1
	mpd11 (net56 inn net31 net31) pmos1 l=180n w=1u m=1
	mp001 (out net158 vdda vdda) pmos1 l=180n w=1u m=1
	mpd12 (net13 inp net31 net31) pmos1 l=2.2e-07n w=6.0e-07u m=1
	mpb01 (net158 net158 vdda vdda) pmos1 l=2.6e-07n w=8.1e-07u m=1
ends OPAMP1_variant469

subckt OPAMP1_variant470 inn inp out pd xpd vdda vssa
	xd1 (vssa vdda) prim_nwd AREA=6.8e-09 PJ=4.7e-05 m=1
	xi0 (vssa net69) prim_nd AREA=5.0e-09 PJ=6.5e-05 m=1
	xi3 (net51 vdda) prim_pd AREA=790e-15 PJ=3.3e-6 m=1
	xr0 (vssa vdda net51) prim_rdiffp l=2.1e-6 w=700e-9 m=1
	xr1 (vdda vdda net69) prim_rdiffp l=2.1e-6 w=700e-9 m=1
	xcc01 (net12 out) prim_cpoly c=1p m=1
	mnm12 (net13 net56 vssa vssa) nmos1 l=180n w=1u m=1
	mnm11 (net56 net56 vssa vssa) nmos1 l=180n w=1u m=1
	mnb02 (net27 net27 net21 vssa) nmos1 l=180n w=1u m=1
	mnpd1 (net21 xpd vssa vssa) nmos1 l=180n w=1u m=1
	mn001 (out net13 vssa vssa) nmos1 l=180n w=1u m=1
	mnpd2 (net13 pd vssa vssa) nmos1 l=2.7e-07n w=1.0e-06u m=1
	mnc01 (net13 net69 net12 vssa) nmos1 l=1.6e-07n w=1.9e-06u m=1
	mpb02 (net27 net51 net158 vdda) pmos1 l=180n w=1u m=1
	mppd1 (net158 xpd vdda vdda) pmos1 l=180n w=1u m=1
	mps11 (net31 net158 vdda vdda) pmos1 l=180n w=1u m=1
	mpd11 (net56 inn net31 net31) pmos1 l=180n w=1u m=1
	mp001 (out net158 vdda vdda) pmos1 l=180n w=1u m=1
	mpd12 (net13 inp net31 net31) pmos1 l=180n w=1u m=1
	mpb01 (net158 net158 vdda vdda) pmos1 l=180n w=1u m=1
ends OPAMP1_variant470

subckt OPAMP1_variant471 inn inp out pd xpd vdda vssa
	xd1 (vssa vdda) prim_nwd AREA=6.13907e-9 PJ=476.6e-6 m=1
	xi0 (vssa net69) prim_nd AREA=1e-12 PJ=4e-6 m=1
	xi3 (net51 vdda) prim_pd AREA=9.8e-09 PJ=5.1e-05 m=1
	xr0 (vssa vdda net51) prim_rdiffp l=2.1e-6 w=700e-9 m=1
	xr1 (vdda vdda net69) prim_rdiffp l=2.1e-6 w=700e-9 m=1
	xcc01 (net12 out) prim_cpoly c=1p m=1
	mnm12 (net13 net56 vssa vssa) nmos1 l=180n w=1u m=1
	mnm11 (net56 net56 vssa vssa) nmos1 l=180n w=1u m=1
	mnb02 (net27 net27 net21 vssa) nmos1 l=180n w=1u m=1
	mnpd1 (net21 xpd vssa vssa) nmos1 l=180n w=1u m=1
	mn001 (out net13 vssa vssa) nmos1 l=180n w=1u m=1
	mnpd2 (net13 pd vssa vssa) nmos1 l=180n w=1u m=1
	mnc01 (net13 net69 net12 vssa) nmos1 l=180n w=1u m=1
	mpb02 (net27 net51 net158 vdda) pmos1 l=180n w=1u m=1
	mppd1 (net158 xpd vdda vdda) pmos1 l=180n w=1u m=1
	mps11 (net31 net158 vdda vdda) pmos1 l=2.0e-07n w=1.2e-06u m=1
	mpd11 (net56 inn net31 net31) pmos1 l=1.7e-07n w=6.5e-07u m=1
	mp001 (out net158 vdda vdda) pmos1 l=1.4e-07n w=8.1e-07u m=1
	mpd12 (net13 inp net31 net31) pmos1 l=180n w=1u m=1
	mpb01 (net158 net158 vdda vdda) pmos1 l=2.1e-07n w=1.3e-06u m=1
ends OPAMP1_variant471

subckt OPAMP1_variant472 inn inp out pd xpd vdda vssa
	xd1 (vssa vdda) prim_nwd AREA=6.13907e-9 PJ=476.6e-6 m=1
	xi0 (vssa net69) prim_nd AREA=1.5e-10 PJ=6.1e-05 m=1
	xi3 (net51 vdda) prim_pd AREA=6.5e-09 PJ=1.3e-05 m=1
	xr0 (vssa vdda net51) prim_rdiffp l=2.1e-6 w=700e-9 m=1
	xr1 (vdda vdda net69) prim_rdiffp l=2.1e-6 w=700e-9 m=1
	xcc01 (net12 out) prim_cpoly c=1p m=1
	mnm12 (net13 net56 vssa vssa) nmos1 l=180n w=1u m=1
	mnm11 (net56 net56 vssa vssa) nmos1 l=180n w=1u m=1
	mnb02 (net27 net27 net21 vssa) nmos1 l=180n w=1u m=1
	mnpd1 (net21 xpd vssa vssa) nmos1 l=1.2e-07n w=1.5e-06u m=1
	mn001 (out net13 vssa vssa) nmos1 l=180n w=1u m=1
	mnpd2 (net13 pd vssa vssa) nmos1 l=180n w=1u m=1
	mnc01 (net13 net69 net12 vssa) nmos1 l=180n w=1u m=1
	mpb02 (net27 net51 net158 vdda) pmos1 l=180n w=1u m=1
	mppd1 (net158 xpd vdda vdda) pmos1 l=180n w=1u m=1
	mps11 (net31 net158 vdda vdda) pmos1 l=180n w=1u m=1
	mpd11 (net56 inn net31 net31) pmos1 l=180n w=1u m=1
	mp001 (out net158 vdda vdda) pmos1 l=180n w=1u m=1
	mpd12 (net13 inp net31 net31) pmos1 l=180n w=1u m=1
	mpb01 (net158 net158 vdda vdda) pmos1 l=1.5e-07n w=8.5e-07u m=1
ends OPAMP1_variant472

subckt OPAMP1_variant473 inn inp out pd xpd vdda vssa
	xd1 (vssa vdda) prim_nwd AREA=6.13907e-9 PJ=476.6e-6 m=1
	xi0 (vssa net69) prim_nd AREA=9.3e-09 PJ=8.2e-05 m=1
	xi3 (net51 vdda) prim_pd AREA=790e-15 PJ=3.3e-6 m=1
	xr0 (vssa vdda net51) prim_rdiffp l=2.1e-6 w=700e-9 m=1
	xr1 (vdda vdda net69) prim_rdiffp l=2.1e-6 w=700e-9 m=1
	xcc01 (net12 out) prim_cpoly c=1p m=1
	mnm12 (net13 net56 vssa vssa) nmos1 l=2.7e-07n w=1.3e-06u m=1
	mnm11 (net56 net56 vssa vssa) nmos1 l=180n w=1u m=1
	mnb02 (net27 net27 net21 vssa) nmos1 l=180n w=1u m=1
	mnpd1 (net21 xpd vssa vssa) nmos1 l=180n w=1u m=1
	mn001 (out net13 vssa vssa) nmos1 l=180n w=1u m=1
	mnpd2 (net13 pd vssa vssa) nmos1 l=180n w=1u m=1
	mnc01 (net13 net69 net12 vssa) nmos1 l=180n w=1u m=1
	mpb02 (net27 net51 net158 vdda) pmos1 l=180n w=1u m=1
	mppd1 (net158 xpd vdda vdda) pmos1 l=180n w=1u m=1
	mps11 (net31 net158 vdda vdda) pmos1 l=180n w=1u m=1
	mpd11 (net56 inn net31 net31) pmos1 l=1.1e-07n w=1.3e-06u m=1
	mp001 (out net158 vdda vdda) pmos1 l=180n w=1u m=1
	mpd12 (net13 inp net31 net31) pmos1 l=180n w=1u m=1
	mpb01 (net158 net158 vdda vdda) pmos1 l=180n w=1u m=1
ends OPAMP1_variant473

subckt OPAMP1_variant474 inn inp out pd xpd vdda vssa
	xd1 (vssa vdda) prim_nwd AREA=1.8e-09 PJ=9.8e-05 m=1
	xi0 (vssa net69) prim_nd AREA=1e-12 PJ=4e-6 m=1
	xi3 (net51 vdda) prim_pd AREA=790e-15 PJ=3.3e-6 m=1
	xr0 (vssa vdda net51) prim_rdiffp l=2.1e-6 w=700e-9 m=1
	xr1 (vdda vdda net69) prim_rdiffp l=2.1e-6 w=700e-9 m=1
	xcc01 (net12 out) prim_cpoly c=1p m=1
	mnm12 (net13 net56 vssa vssa) nmos1 l=1.9e-07n w=1.2e-06u m=1
	mnm11 (net56 net56 vssa vssa) nmos1 l=180n w=1u m=1
	mnb02 (net27 net27 net21 vssa) nmos1 l=180n w=1u m=1
	mnpd1 (net21 xpd vssa vssa) nmos1 l=180n w=1u m=1
	mn001 (out net13 vssa vssa) nmos1 l=180n w=1u m=1
	mnpd2 (net13 pd vssa vssa) nmos1 l=2.8e-07n w=1.2e-06u m=1
	mnc01 (net13 net69 net12 vssa) nmos1 l=180n w=1u m=1
	mpb02 (net27 net51 net158 vdda) pmos1 l=180n w=1u m=1
	mppd1 (net158 xpd vdda vdda) pmos1 l=180n w=1u m=1
	mps11 (net31 net158 vdda vdda) pmos1 l=180n w=1u m=1
	mpd11 (net56 inn net31 net31) pmos1 l=1.2e-07n w=1.5e-06u m=1
	mp001 (out net158 vdda vdda) pmos1 l=180n w=1u m=1
	mpd12 (net13 inp net31 net31) pmos1 l=1.9e-07n w=1.8e-06u m=1
	mpb01 (net158 net158 vdda vdda) pmos1 l=180n w=1u m=1
ends OPAMP1_variant474

subckt OPAMP1_variant475 inn inp out pd xpd vdda vssa
	xd1 (vssa vdda) prim_nwd AREA=6.13907e-9 PJ=476.6e-6 m=1
	xi0 (vssa net69) prim_nd AREA=1e-12 PJ=4e-6 m=1
	xi3 (net51 vdda) prim_pd AREA=790e-15 PJ=3.3e-6 m=1
	xr0 (vssa vdda net51) prim_rdiffp l=2.1e-6 w=700e-9 m=1
	xr1 (vdda vdda net69) prim_rdiffp l=1.4e-07 w=9.0e-07 m=1
	xcc01 (net12 out) prim_cpoly c=1p m=1
	mnm12 (net13 net56 vssa vssa) nmos1 l=180n w=1u m=1
	mnm11 (net56 net56 vssa vssa) nmos1 l=180n w=1u m=1
	mnb02 (net27 net27 net21 vssa) nmos1 l=2.6e-07n w=2.0e-06u m=1
	mnpd1 (net21 xpd vssa vssa) nmos1 l=2.4e-07n w=6.3e-07u m=1
	mn001 (out net13 vssa vssa) nmos1 l=180n w=1u m=1
	mnpd2 (net13 pd vssa vssa) nmos1 l=1.1e-07n w=5.7e-07u m=1
	mnc01 (net13 net69 net12 vssa) nmos1 l=180n w=1u m=1
	mpb02 (net27 net51 net158 vdda) pmos1 l=180n w=1u m=1
	mppd1 (net158 xpd vdda vdda) pmos1 l=180n w=1u m=1
	mps11 (net31 net158 vdda vdda) pmos1 l=180n w=1u m=1
	mpd11 (net56 inn net31 net31) pmos1 l=180n w=1u m=1
	mp001 (out net158 vdda vdda) pmos1 l=1.0e-07n w=1.6e-06u m=1
	mpd12 (net13 inp net31 net31) pmos1 l=180n w=1u m=1
	mpb01 (net158 net158 vdda vdda) pmos1 l=180n w=1u m=1
ends OPAMP1_variant475

subckt OPAMP1_variant476 inn inp out pd xpd vdda vssa
	xd1 (vssa vdda) prim_nwd AREA=6.13907e-9 PJ=476.6e-6 m=1
	xi0 (vssa net69) prim_nd AREA=1e-12 PJ=4e-6 m=1
	xi3 (net51 vdda) prim_pd AREA=4.6e-09 PJ=4.5e-05 m=1
	xr0 (vssa vdda net51) prim_rdiffp l=1.5e-07 w=2.0e-06 m=1
	xr1 (vdda vdda net69) prim_rdiffp l=1.4e-07 w=6.1e-07 m=1
	xcc01 (net12 out) prim_cpoly c=1p m=1
	mnm12 (net13 net56 vssa vssa) nmos1 l=180n w=1u m=1
	mnm11 (net56 net56 vssa vssa) nmos1 l=180n w=1u m=1
	mnb02 (net27 net27 net21 vssa) nmos1 l=180n w=1u m=1
	mnpd1 (net21 xpd vssa vssa) nmos1 l=180n w=1u m=1
	mn001 (out net13 vssa vssa) nmos1 l=180n w=1u m=1
	mnpd2 (net13 pd vssa vssa) nmos1 l=2.1e-07n w=1.1e-06u m=1
	mnc01 (net13 net69 net12 vssa) nmos1 l=180n w=1u m=1
	mpb02 (net27 net51 net158 vdda) pmos1 l=180n w=1u m=1
	mppd1 (net158 xpd vdda vdda) pmos1 l=180n w=1u m=1
	mps11 (net31 net158 vdda vdda) pmos1 l=1.2e-07n w=1.1e-06u m=1
	mpd11 (net56 inn net31 net31) pmos1 l=180n w=1u m=1
	mp001 (out net158 vdda vdda) pmos1 l=180n w=1u m=1
	mpd12 (net13 inp net31 net31) pmos1 l=180n w=1u m=1
	mpb01 (net158 net158 vdda vdda) pmos1 l=180n w=1u m=1
ends OPAMP1_variant476

subckt OPAMP1_variant477 inn inp out pd xpd vdda vssa
	xd1 (vssa vdda) prim_nwd AREA=6.13907e-9 PJ=476.6e-6 m=1
	xi0 (vssa net69) prim_nd AREA=1e-12 PJ=4e-6 m=1
	xi3 (net51 vdda) prim_pd AREA=7.8e-09 PJ=7.7e-05 m=1
	xr0 (vssa vdda net51) prim_rdiffp l=2.1e-6 w=700e-9 m=1
	xr1 (vdda vdda net69) prim_rdiffp l=2.1e-6 w=700e-9 m=1
	xcc01 (net12 out) prim_cpoly c=1p m=1
	mnm12 (net13 net56 vssa vssa) nmos1 l=180n w=1u m=1
	mnm11 (net56 net56 vssa vssa) nmos1 l=180n w=1u m=1
	mnb02 (net27 net27 net21 vssa) nmos1 l=2.6e-07n w=1.7e-06u m=1
	mnpd1 (net21 xpd vssa vssa) nmos1 l=1.9e-07n w=7.3e-07u m=1
	mn001 (out net13 vssa vssa) nmos1 l=180n w=1u m=1
	mnpd2 (net13 pd vssa vssa) nmos1 l=180n w=1u m=1
	mnc01 (net13 net69 net12 vssa) nmos1 l=180n w=1u m=1
	mpb02 (net27 net51 net158 vdda) pmos1 l=180n w=1u m=1
	mppd1 (net158 xpd vdda vdda) pmos1 l=2.8e-07n w=1.6e-06u m=1
	mps11 (net31 net158 vdda vdda) pmos1 l=180n w=1u m=1
	mpd11 (net56 inn net31 net31) pmos1 l=180n w=1u m=1
	mp001 (out net158 vdda vdda) pmos1 l=180n w=1u m=1
	mpd12 (net13 inp net31 net31) pmos1 l=180n w=1u m=1
	mpb01 (net158 net158 vdda vdda) pmos1 l=1.2e-07n w=8.6e-07u m=1
ends OPAMP1_variant477

subckt OPAMP1_variant478 inn inp out pd xpd vdda vssa
	xd1 (vssa vdda) prim_nwd AREA=6.13907e-9 PJ=476.6e-6 m=1
	xi0 (vssa net69) prim_nd AREA=1e-12 PJ=4e-6 m=1
	xi3 (net51 vdda) prim_pd AREA=3.5e-10 PJ=8.0e-05 m=1
	xr0 (vssa vdda net51) prim_rdiffp l=2.1e-6 w=700e-9 m=1
	xr1 (vdda vdda net69) prim_rdiffp l=2.1e-6 w=700e-9 m=1
	xcc01 (net12 out) prim_cpoly c=1p m=1
	mnm12 (net13 net56 vssa vssa) nmos1 l=2.7e-07n w=8.4e-07u m=1
	mnm11 (net56 net56 vssa vssa) nmos1 l=180n w=1u m=1
	mnb02 (net27 net27 net21 vssa) nmos1 l=180n w=1u m=1
	mnpd1 (net21 xpd vssa vssa) nmos1 l=180n w=1u m=1
	mn001 (out net13 vssa vssa) nmos1 l=180n w=1u m=1
	mnpd2 (net13 pd vssa vssa) nmos1 l=180n w=1u m=1
	mnc01 (net13 net69 net12 vssa) nmos1 l=2.1e-07n w=1.8e-06u m=1
	mpb02 (net27 net51 net158 vdda) pmos1 l=3.0e-07n w=1.5e-06u m=1
	mppd1 (net158 xpd vdda vdda) pmos1 l=180n w=1u m=1
	mps11 (net31 net158 vdda vdda) pmos1 l=180n w=1u m=1
	mpd11 (net56 inn net31 net31) pmos1 l=1.1e-07n w=8.9e-07u m=1
	mp001 (out net158 vdda vdda) pmos1 l=180n w=1u m=1
	mpd12 (net13 inp net31 net31) pmos1 l=180n w=1u m=1
	mpb01 (net158 net158 vdda vdda) pmos1 l=180n w=1u m=1
ends OPAMP1_variant478

subckt OPAMP1_variant479 inn inp out pd xpd vdda vssa
	xd1 (vssa vdda) prim_nwd AREA=6.13907e-9 PJ=476.6e-6 m=1
	xi0 (vssa net69) prim_nd AREA=1e-12 PJ=4e-6 m=1
	xi3 (net51 vdda) prim_pd AREA=790e-15 PJ=3.3e-6 m=1
	xr0 (vssa vdda net51) prim_rdiffp l=2.1e-6 w=700e-9 m=1
	xr1 (vdda vdda net69) prim_rdiffp l=2.1e-6 w=700e-9 m=1
	xcc01 (net12 out) prim_cpoly c=1p m=1
	mnm12 (net13 net56 vssa vssa) nmos1 l=180n w=1u m=1
	mnm11 (net56 net56 vssa vssa) nmos1 l=180n w=1u m=1
	mnb02 (net27 net27 net21 vssa) nmos1 l=1.9e-07n w=1.4e-06u m=1
	mnpd1 (net21 xpd vssa vssa) nmos1 l=180n w=1u m=1
	mn001 (out net13 vssa vssa) nmos1 l=180n w=1u m=1
	mnpd2 (net13 pd vssa vssa) nmos1 l=2.3e-07n w=5.6e-07u m=1
	mnc01 (net13 net69 net12 vssa) nmos1 l=180n w=1u m=1
	mpb02 (net27 net51 net158 vdda) pmos1 l=180n w=1u m=1
	mppd1 (net158 xpd vdda vdda) pmos1 l=180n w=1u m=1
	mps11 (net31 net158 vdda vdda) pmos1 l=180n w=1u m=1
	mpd11 (net56 inn net31 net31) pmos1 l=2.3e-07n w=1.8e-06u m=1
	mp001 (out net158 vdda vdda) pmos1 l=180n w=1u m=1
	mpd12 (net13 inp net31 net31) pmos1 l=180n w=1u m=1
	mpb01 (net158 net158 vdda vdda) pmos1 l=180n w=1u m=1
ends OPAMP1_variant479

subckt OPAMP1_variant480 inn inp out pd xpd vdda vssa
	xd1 (vssa vdda) prim_nwd AREA=6.13907e-9 PJ=476.6e-6 m=1
	xi0 (vssa net69) prim_nd AREA=1e-12 PJ=4e-6 m=1
	xi3 (net51 vdda) prim_pd AREA=790e-15 PJ=3.3e-6 m=1
	xr0 (vssa vdda net51) prim_rdiffp l=2.4e-07 w=1.6e-06 m=1
	xr1 (vdda vdda net69) prim_rdiffp l=2.1e-6 w=700e-9 m=1
	xcc01 (net12 out) prim_cpoly c=1p m=1
	mnm12 (net13 net56 vssa vssa) nmos1 l=2.1e-07n w=1.4e-06u m=1
	mnm11 (net56 net56 vssa vssa) nmos1 l=180n w=1u m=1
	mnb02 (net27 net27 net21 vssa) nmos1 l=180n w=1u m=1
	mnpd1 (net21 xpd vssa vssa) nmos1 l=180n w=1u m=1
	mn001 (out net13 vssa vssa) nmos1 l=180n w=1u m=1
	mnpd2 (net13 pd vssa vssa) nmos1 l=180n w=1u m=1
	mnc01 (net13 net69 net12 vssa) nmos1 l=1.5e-07n w=1.6e-06u m=1
	mpb02 (net27 net51 net158 vdda) pmos1 l=180n w=1u m=1
	mppd1 (net158 xpd vdda vdda) pmos1 l=180n w=1u m=1
	mps11 (net31 net158 vdda vdda) pmos1 l=180n w=1u m=1
	mpd11 (net56 inn net31 net31) pmos1 l=1.2e-07n w=2.0e-06u m=1
	mp001 (out net158 vdda vdda) pmos1 l=180n w=1u m=1
	mpd12 (net13 inp net31 net31) pmos1 l=180n w=1u m=1
	mpb01 (net158 net158 vdda vdda) pmos1 l=2.0e-07n w=9.9e-07u m=1
ends OPAMP1_variant480

subckt OPAMP1_variant481 inn inp out pd xpd vdda vssa
	xd1 (vssa vdda) prim_nwd AREA=6.13907e-9 PJ=476.6e-6 m=1
	xi0 (vssa net69) prim_nd AREA=1e-12 PJ=4e-6 m=1
	xi3 (net51 vdda) prim_pd AREA=2.8e-09 PJ=8.8e-05 m=1
	xr0 (vssa vdda net51) prim_rdiffp l=2.1e-6 w=700e-9 m=1
	xr1 (vdda vdda net69) prim_rdiffp l=2.1e-6 w=700e-9 m=1
	xcc01 (net12 out) prim_cpoly c=1p m=1
	mnm12 (net13 net56 vssa vssa) nmos1 l=2.1e-07n w=5.1e-07u m=1
	mnm11 (net56 net56 vssa vssa) nmos1 l=180n w=1u m=1
	mnb02 (net27 net27 net21 vssa) nmos1 l=180n w=1u m=1
	mnpd1 (net21 xpd vssa vssa) nmos1 l=180n w=1u m=1
	mn001 (out net13 vssa vssa) nmos1 l=180n w=1u m=1
	mnpd2 (net13 pd vssa vssa) nmos1 l=180n w=1u m=1
	mnc01 (net13 net69 net12 vssa) nmos1 l=180n w=1u m=1
	mpb02 (net27 net51 net158 vdda) pmos1 l=180n w=1u m=1
	mppd1 (net158 xpd vdda vdda) pmos1 l=180n w=1u m=1
	mps11 (net31 net158 vdda vdda) pmos1 l=180n w=1u m=1
	mpd11 (net56 inn net31 net31) pmos1 l=180n w=1u m=1
	mp001 (out net158 vdda vdda) pmos1 l=180n w=1u m=1
	mpd12 (net13 inp net31 net31) pmos1 l=180n w=1u m=1
	mpb01 (net158 net158 vdda vdda) pmos1 l=1.6e-07n w=7.1e-07u m=1
ends OPAMP1_variant481

subckt OPAMP1_variant482 inn inp out pd xpd vdda vssa
	xd1 (vssa vdda) prim_nwd AREA=6.13907e-9 PJ=476.6e-6 m=1
	xi0 (vssa net69) prim_nd AREA=1e-12 PJ=4e-6 m=1
	xi3 (net51 vdda) prim_pd AREA=2.7e-09 PJ=9.1e-05 m=1
	xr0 (vssa vdda net51) prim_rdiffp l=2.1e-6 w=700e-9 m=1
	xr1 (vdda vdda net69) prim_rdiffp l=3.0e-07 w=1.5e-06 m=1
	xcc01 (net12 out) prim_cpoly c=1p m=1
	mnm12 (net13 net56 vssa vssa) nmos1 l=180n w=1u m=1
	mnm11 (net56 net56 vssa vssa) nmos1 l=180n w=1u m=1
	mnb02 (net27 net27 net21 vssa) nmos1 l=180n w=1u m=1
	mnpd1 (net21 xpd vssa vssa) nmos1 l=180n w=1u m=1
	mn001 (out net13 vssa vssa) nmos1 l=1.2e-07n w=1.4e-06u m=1
	mnpd2 (net13 pd vssa vssa) nmos1 l=180n w=1u m=1
	mnc01 (net13 net69 net12 vssa) nmos1 l=180n w=1u m=1
	mpb02 (net27 net51 net158 vdda) pmos1 l=180n w=1u m=1
	mppd1 (net158 xpd vdda vdda) pmos1 l=2.8e-07n w=7.5e-07u m=1
	mps11 (net31 net158 vdda vdda) pmos1 l=2.4e-07n w=7.8e-07u m=1
	mpd11 (net56 inn net31 net31) pmos1 l=180n w=1u m=1
	mp001 (out net158 vdda vdda) pmos1 l=180n w=1u m=1
	mpd12 (net13 inp net31 net31) pmos1 l=180n w=1u m=1
	mpb01 (net158 net158 vdda vdda) pmos1 l=180n w=1u m=1
ends OPAMP1_variant482

subckt OPAMP1_variant483 inn inp out pd xpd vdda vssa
	xd1 (vssa vdda) prim_nwd AREA=2.8e-09 PJ=5.2e-05 m=1
	xi0 (vssa net69) prim_nd AREA=1e-12 PJ=4e-6 m=1
	xi3 (net51 vdda) prim_pd AREA=790e-15 PJ=3.3e-6 m=1
	xr0 (vssa vdda net51) prim_rdiffp l=2.1e-6 w=700e-9 m=1
	xr1 (vdda vdda net69) prim_rdiffp l=2.1e-6 w=700e-9 m=1
	xcc01 (net12 out) prim_cpoly c=1p m=1
	mnm12 (net13 net56 vssa vssa) nmos1 l=180n w=1u m=1
	mnm11 (net56 net56 vssa vssa) nmos1 l=180n w=1u m=1
	mnb02 (net27 net27 net21 vssa) nmos1 l=180n w=1u m=1
	mnpd1 (net21 xpd vssa vssa) nmos1 l=180n w=1u m=1
	mn001 (out net13 vssa vssa) nmos1 l=180n w=1u m=1
	mnpd2 (net13 pd vssa vssa) nmos1 l=180n w=1u m=1
	mnc01 (net13 net69 net12 vssa) nmos1 l=2.7e-07n w=1.1e-06u m=1
	mpb02 (net27 net51 net158 vdda) pmos1 l=180n w=1u m=1
	mppd1 (net158 xpd vdda vdda) pmos1 l=180n w=1u m=1
	mps11 (net31 net158 vdda vdda) pmos1 l=180n w=1u m=1
	mpd11 (net56 inn net31 net31) pmos1 l=180n w=1u m=1
	mp001 (out net158 vdda vdda) pmos1 l=180n w=1u m=1
	mpd12 (net13 inp net31 net31) pmos1 l=180n w=1u m=1
	mpb01 (net158 net158 vdda vdda) pmos1 l=180n w=1u m=1
ends OPAMP1_variant483

subckt OPAMP1_variant484 inn inp out pd xpd vdda vssa
	xd1 (vssa vdda) prim_nwd AREA=6.13907e-9 PJ=476.6e-6 m=1
	xi0 (vssa net69) prim_nd AREA=1e-12 PJ=4e-6 m=1
	xi3 (net51 vdda) prim_pd AREA=790e-15 PJ=3.3e-6 m=1
	xr0 (vssa vdda net51) prim_rdiffp l=2.1e-6 w=700e-9 m=1
	xr1 (vdda vdda net69) prim_rdiffp l=2.8e-07 w=1.1e-06 m=1
	xcc01 (net12 out) prim_cpoly c=1p m=1
	mnm12 (net13 net56 vssa vssa) nmos1 l=180n w=1u m=1
	mnm11 (net56 net56 vssa vssa) nmos1 l=180n w=1u m=1
	mnb02 (net27 net27 net21 vssa) nmos1 l=180n w=1u m=1
	mnpd1 (net21 xpd vssa vssa) nmos1 l=180n w=1u m=1
	mn001 (out net13 vssa vssa) nmos1 l=180n w=1u m=1
	mnpd2 (net13 pd vssa vssa) nmos1 l=180n w=1u m=1
	mnc01 (net13 net69 net12 vssa) nmos1 l=180n w=1u m=1
	mpb02 (net27 net51 net158 vdda) pmos1 l=180n w=1u m=1
	mppd1 (net158 xpd vdda vdda) pmos1 l=180n w=1u m=1
	mps11 (net31 net158 vdda vdda) pmos1 l=180n w=1u m=1
	mpd11 (net56 inn net31 net31) pmos1 l=180n w=1u m=1
	mp001 (out net158 vdda vdda) pmos1 l=180n w=1u m=1
	mpd12 (net13 inp net31 net31) pmos1 l=180n w=1u m=1
	mpb01 (net158 net158 vdda vdda) pmos1 l=1.5e-07n w=1.2e-06u m=1
ends OPAMP1_variant484

subckt OPAMP1_variant485 inn inp out pd xpd vdda vssa
	xd1 (vssa vdda) prim_nwd AREA=6.13907e-9 PJ=476.6e-6 m=1
	xi0 (vssa net69) prim_nd AREA=1e-12 PJ=4e-6 m=1
	xi3 (net51 vdda) prim_pd AREA=790e-15 PJ=3.3e-6 m=1
	xr0 (vssa vdda net51) prim_rdiffp l=2.3e-07 w=1.6e-06 m=1
	xr1 (vdda vdda net69) prim_rdiffp l=2.1e-6 w=700e-9 m=1
	xcc01 (net12 out) prim_cpoly c=1p m=1
	mnm12 (net13 net56 vssa vssa) nmos1 l=180n w=1u m=1
	mnm11 (net56 net56 vssa vssa) nmos1 l=180n w=1u m=1
	mnb02 (net27 net27 net21 vssa) nmos1 l=180n w=1u m=1
	mnpd1 (net21 xpd vssa vssa) nmos1 l=1.4e-07n w=1.3e-06u m=1
	mn001 (out net13 vssa vssa) nmos1 l=180n w=1u m=1
	mnpd2 (net13 pd vssa vssa) nmos1 l=180n w=1u m=1
	mnc01 (net13 net69 net12 vssa) nmos1 l=1.8e-07n w=6.2e-07u m=1
	mpb02 (net27 net51 net158 vdda) pmos1 l=2.0e-07n w=1.4e-06u m=1
	mppd1 (net158 xpd vdda vdda) pmos1 l=180n w=1u m=1
	mps11 (net31 net158 vdda vdda) pmos1 l=180n w=1u m=1
	mpd11 (net56 inn net31 net31) pmos1 l=180n w=1u m=1
	mp001 (out net158 vdda vdda) pmos1 l=180n w=1u m=1
	mpd12 (net13 inp net31 net31) pmos1 l=180n w=1u m=1
	mpb01 (net158 net158 vdda vdda) pmos1 l=1.5e-07n w=1.2e-06u m=1
ends OPAMP1_variant485

subckt OPAMP1_variant486 inn inp out pd xpd vdda vssa
	xd1 (vssa vdda) prim_nwd AREA=6.13907e-9 PJ=476.6e-6 m=1
	xi0 (vssa net69) prim_nd AREA=1e-12 PJ=4e-6 m=1
	xi3 (net51 vdda) prim_pd AREA=790e-15 PJ=3.3e-6 m=1
	xr0 (vssa vdda net51) prim_rdiffp l=2.1e-6 w=700e-9 m=1
	xr1 (vdda vdda net69) prim_rdiffp l=2.2e-07 w=6.2e-07 m=1
	xcc01 (net12 out) prim_cpoly c=1p m=1
	mnm12 (net13 net56 vssa vssa) nmos1 l=180n w=1u m=1
	mnm11 (net56 net56 vssa vssa) nmos1 l=180n w=1u m=1
	mnb02 (net27 net27 net21 vssa) nmos1 l=2.6e-07n w=1.5e-06u m=1
	mnpd1 (net21 xpd vssa vssa) nmos1 l=180n w=1u m=1
	mn001 (out net13 vssa vssa) nmos1 l=180n w=1u m=1
	mnpd2 (net13 pd vssa vssa) nmos1 l=180n w=1u m=1
	mnc01 (net13 net69 net12 vssa) nmos1 l=180n w=1u m=1
	mpb02 (net27 net51 net158 vdda) pmos1 l=180n w=1u m=1
	mppd1 (net158 xpd vdda vdda) pmos1 l=180n w=1u m=1
	mps11 (net31 net158 vdda vdda) pmos1 l=180n w=1u m=1
	mpd11 (net56 inn net31 net31) pmos1 l=180n w=1u m=1
	mp001 (out net158 vdda vdda) pmos1 l=180n w=1u m=1
	mpd12 (net13 inp net31 net31) pmos1 l=180n w=1u m=1
	mpb01 (net158 net158 vdda vdda) pmos1 l=180n w=1u m=1
ends OPAMP1_variant486

subckt OPAMP1_variant487 inn inp out pd xpd vdda vssa
	xd1 (vssa vdda) prim_nwd AREA=6.13907e-9 PJ=476.6e-6 m=1
	xi0 (vssa net69) prim_nd AREA=9.7e-09 PJ=2.2e-05 m=1
	xi3 (net51 vdda) prim_pd AREA=790e-15 PJ=3.3e-6 m=1
	xr0 (vssa vdda net51) prim_rdiffp l=2.1e-6 w=700e-9 m=1
	xr1 (vdda vdda net69) prim_rdiffp l=2.1e-6 w=700e-9 m=1
	xcc01 (net12 out) prim_cpoly c=1p m=1
	mnm12 (net13 net56 vssa vssa) nmos1 l=180n w=1u m=1
	mnm11 (net56 net56 vssa vssa) nmos1 l=180n w=1u m=1
	mnb02 (net27 net27 net21 vssa) nmos1 l=2.2e-07n w=7.8e-07u m=1
	mnpd1 (net21 xpd vssa vssa) nmos1 l=180n w=1u m=1
	mn001 (out net13 vssa vssa) nmos1 l=180n w=1u m=1
	mnpd2 (net13 pd vssa vssa) nmos1 l=2.1e-07n w=6.5e-07u m=1
	mnc01 (net13 net69 net12 vssa) nmos1 l=180n w=1u m=1
	mpb02 (net27 net51 net158 vdda) pmos1 l=180n w=1u m=1
	mppd1 (net158 xpd vdda vdda) pmos1 l=2.7e-07n w=1.9e-06u m=1
	mps11 (net31 net158 vdda vdda) pmos1 l=180n w=1u m=1
	mpd11 (net56 inn net31 net31) pmos1 l=180n w=1u m=1
	mp001 (out net158 vdda vdda) pmos1 l=180n w=1u m=1
	mpd12 (net13 inp net31 net31) pmos1 l=180n w=1u m=1
	mpb01 (net158 net158 vdda vdda) pmos1 l=2.9e-07n w=1.9e-06u m=1
ends OPAMP1_variant487

subckt OPAMP1_variant488 inn inp out pd xpd vdda vssa
	xd1 (vssa vdda) prim_nwd AREA=6.13907e-9 PJ=476.6e-6 m=1
	xi0 (vssa net69) prim_nd AREA=1e-12 PJ=4e-6 m=1
	xi3 (net51 vdda) prim_pd AREA=790e-15 PJ=3.3e-6 m=1
	xr0 (vssa vdda net51) prim_rdiffp l=2.9e-07 w=1.7e-06 m=1
	xr1 (vdda vdda net69) prim_rdiffp l=1.0e-07 w=1.2e-06 m=1
	xcc01 (net12 out) prim_cpoly c=1p m=1
	mnm12 (net13 net56 vssa vssa) nmos1 l=180n w=1u m=1
	mnm11 (net56 net56 vssa vssa) nmos1 l=180n w=1u m=1
	mnb02 (net27 net27 net21 vssa) nmos1 l=180n w=1u m=1
	mnpd1 (net21 xpd vssa vssa) nmos1 l=180n w=1u m=1
	mn001 (out net13 vssa vssa) nmos1 l=180n w=1u m=1
	mnpd2 (net13 pd vssa vssa) nmos1 l=180n w=1u m=1
	mnc01 (net13 net69 net12 vssa) nmos1 l=180n w=1u m=1
	mpb02 (net27 net51 net158 vdda) pmos1 l=180n w=1u m=1
	mppd1 (net158 xpd vdda vdda) pmos1 l=2.7e-07n w=1.1e-06u m=1
	mps11 (net31 net158 vdda vdda) pmos1 l=180n w=1u m=1
	mpd11 (net56 inn net31 net31) pmos1 l=180n w=1u m=1
	mp001 (out net158 vdda vdda) pmos1 l=180n w=1u m=1
	mpd12 (net13 inp net31 net31) pmos1 l=180n w=1u m=1
	mpb01 (net158 net158 vdda vdda) pmos1 l=180n w=1u m=1
ends OPAMP1_variant488

subckt OPAMP1_variant489 inn inp out pd xpd vdda vssa
	xd1 (vssa vdda) prim_nwd AREA=6.13907e-9 PJ=476.6e-6 m=1
	xi0 (vssa net69) prim_nd AREA=7.2e-09 PJ=4.6e-05 m=1
	xi3 (net51 vdda) prim_pd AREA=790e-15 PJ=3.3e-6 m=1
	xr0 (vssa vdda net51) prim_rdiffp l=2.1e-6 w=700e-9 m=1
	xr1 (vdda vdda net69) prim_rdiffp l=2.1e-6 w=700e-9 m=1
	xcc01 (net12 out) prim_cpoly c=1.6e-12p m=1
	mnm12 (net13 net56 vssa vssa) nmos1 l=180n w=1u m=1
	mnm11 (net56 net56 vssa vssa) nmos1 l=2.5e-07n w=1.8e-06u m=1
	mnb02 (net27 net27 net21 vssa) nmos1 l=180n w=1u m=1
	mnpd1 (net21 xpd vssa vssa) nmos1 l=180n w=1u m=1
	mn001 (out net13 vssa vssa) nmos1 l=180n w=1u m=1
	mnpd2 (net13 pd vssa vssa) nmos1 l=180n w=1u m=1
	mnc01 (net13 net69 net12 vssa) nmos1 l=180n w=1u m=1
	mpb02 (net27 net51 net158 vdda) pmos1 l=180n w=1u m=1
	mppd1 (net158 xpd vdda vdda) pmos1 l=180n w=1u m=1
	mps11 (net31 net158 vdda vdda) pmos1 l=1.9e-07n w=9.6e-07u m=1
	mpd11 (net56 inn net31 net31) pmos1 l=180n w=1u m=1
	mp001 (out net158 vdda vdda) pmos1 l=180n w=1u m=1
	mpd12 (net13 inp net31 net31) pmos1 l=180n w=1u m=1
	mpb01 (net158 net158 vdda vdda) pmos1 l=2.1e-07n w=1.8e-06u m=1
ends OPAMP1_variant489

subckt OPAMP1_variant490 inn inp out pd xpd vdda vssa
	xd1 (vssa vdda) prim_nwd AREA=6.13907e-9 PJ=476.6e-6 m=1
	xi0 (vssa net69) prim_nd AREA=8.1e-09 PJ=2.9e-05 m=1
	xi3 (net51 vdda) prim_pd AREA=790e-15 PJ=3.3e-6 m=1
	xr0 (vssa vdda net51) prim_rdiffp l=2.9e-07 w=8.1e-07 m=1
	xr1 (vdda vdda net69) prim_rdiffp l=2.7e-07 w=8.2e-07 m=1
	xcc01 (net12 out) prim_cpoly c=1p m=1
	mnm12 (net13 net56 vssa vssa) nmos1 l=180n w=1u m=1
	mnm11 (net56 net56 vssa vssa) nmos1 l=1.2e-07n w=1.0e-06u m=1
	mnb02 (net27 net27 net21 vssa) nmos1 l=180n w=1u m=1
	mnpd1 (net21 xpd vssa vssa) nmos1 l=180n w=1u m=1
	mn001 (out net13 vssa vssa) nmos1 l=180n w=1u m=1
	mnpd2 (net13 pd vssa vssa) nmos1 l=180n w=1u m=1
	mnc01 (net13 net69 net12 vssa) nmos1 l=180n w=1u m=1
	mpb02 (net27 net51 net158 vdda) pmos1 l=180n w=1u m=1
	mppd1 (net158 xpd vdda vdda) pmos1 l=180n w=1u m=1
	mps11 (net31 net158 vdda vdda) pmos1 l=180n w=1u m=1
	mpd11 (net56 inn net31 net31) pmos1 l=180n w=1u m=1
	mp001 (out net158 vdda vdda) pmos1 l=180n w=1u m=1
	mpd12 (net13 inp net31 net31) pmos1 l=180n w=1u m=1
	mpb01 (net158 net158 vdda vdda) pmos1 l=1.9e-07n w=5.2e-07u m=1
ends OPAMP1_variant490

subckt OPAMP1_variant491 inn inp out pd xpd vdda vssa
	xd1 (vssa vdda) prim_nwd AREA=6.13907e-9 PJ=476.6e-6 m=1
	xi0 (vssa net69) prim_nd AREA=1e-12 PJ=4e-6 m=1
	xi3 (net51 vdda) prim_pd AREA=790e-15 PJ=3.3e-6 m=1
	xr0 (vssa vdda net51) prim_rdiffp l=2.1e-6 w=700e-9 m=1
	xr1 (vdda vdda net69) prim_rdiffp l=2.1e-6 w=700e-9 m=1
	xcc01 (net12 out) prim_cpoly c=1p m=1
	mnm12 (net13 net56 vssa vssa) nmos1 l=180n w=1u m=1
	mnm11 (net56 net56 vssa vssa) nmos1 l=1.2e-07n w=7.9e-07u m=1
	mnb02 (net27 net27 net21 vssa) nmos1 l=180n w=1u m=1
	mnpd1 (net21 xpd vssa vssa) nmos1 l=180n w=1u m=1
	mn001 (out net13 vssa vssa) nmos1 l=2.5e-07n w=1.8e-06u m=1
	mnpd2 (net13 pd vssa vssa) nmos1 l=180n w=1u m=1
	mnc01 (net13 net69 net12 vssa) nmos1 l=180n w=1u m=1
	mpb02 (net27 net51 net158 vdda) pmos1 l=180n w=1u m=1
	mppd1 (net158 xpd vdda vdda) pmos1 l=180n w=1u m=1
	mps11 (net31 net158 vdda vdda) pmos1 l=180n w=1u m=1
	mpd11 (net56 inn net31 net31) pmos1 l=1.7e-07n w=1.0e-06u m=1
	mp001 (out net158 vdda vdda) pmos1 l=180n w=1u m=1
	mpd12 (net13 inp net31 net31) pmos1 l=180n w=1u m=1
	mpb01 (net158 net158 vdda vdda) pmos1 l=180n w=1u m=1
ends OPAMP1_variant491

subckt OPAMP1_variant492 inn inp out pd xpd vdda vssa
	xd1 (vssa vdda) prim_nwd AREA=6.13907e-9 PJ=476.6e-6 m=1
	xi0 (vssa net69) prim_nd AREA=1e-12 PJ=4e-6 m=1
	xi3 (net51 vdda) prim_pd AREA=790e-15 PJ=3.3e-6 m=1
	xr0 (vssa vdda net51) prim_rdiffp l=2.1e-6 w=700e-9 m=1
	xr1 (vdda vdda net69) prim_rdiffp l=2.1e-6 w=700e-9 m=1
	xcc01 (net12 out) prim_cpoly c=1p m=1
	mnm12 (net13 net56 vssa vssa) nmos1 l=1.8e-07n w=1.7e-06u m=1
	mnm11 (net56 net56 vssa vssa) nmos1 l=180n w=1u m=1
	mnb02 (net27 net27 net21 vssa) nmos1 l=180n w=1u m=1
	mnpd1 (net21 xpd vssa vssa) nmos1 l=180n w=1u m=1
	mn001 (out net13 vssa vssa) nmos1 l=180n w=1u m=1
	mnpd2 (net13 pd vssa vssa) nmos1 l=180n w=1u m=1
	mnc01 (net13 net69 net12 vssa) nmos1 l=2.6e-07n w=1.3e-06u m=1
	mpb02 (net27 net51 net158 vdda) pmos1 l=1.3e-07n w=1.0e-06u m=1
	mppd1 (net158 xpd vdda vdda) pmos1 l=180n w=1u m=1
	mps11 (net31 net158 vdda vdda) pmos1 l=180n w=1u m=1
	mpd11 (net56 inn net31 net31) pmos1 l=180n w=1u m=1
	mp001 (out net158 vdda vdda) pmos1 l=180n w=1u m=1
	mpd12 (net13 inp net31 net31) pmos1 l=180n w=1u m=1
	mpb01 (net158 net158 vdda vdda) pmos1 l=180n w=1u m=1
ends OPAMP1_variant492

subckt OPAMP1_variant493 inn inp out pd xpd vdda vssa
	xd1 (vssa vdda) prim_nwd AREA=6.13907e-9 PJ=476.6e-6 m=1
	xi0 (vssa net69) prim_nd AREA=1e-12 PJ=4e-6 m=1
	xi3 (net51 vdda) prim_pd AREA=790e-15 PJ=3.3e-6 m=1
	xr0 (vssa vdda net51) prim_rdiffp l=2.1e-6 w=700e-9 m=1
	xr1 (vdda vdda net69) prim_rdiffp l=2.1e-6 w=700e-9 m=1
	xcc01 (net12 out) prim_cpoly c=1p m=1
	mnm12 (net13 net56 vssa vssa) nmos1 l=180n w=1u m=1
	mnm11 (net56 net56 vssa vssa) nmos1 l=180n w=1u m=1
	mnb02 (net27 net27 net21 vssa) nmos1 l=180n w=1u m=1
	mnpd1 (net21 xpd vssa vssa) nmos1 l=180n w=1u m=1
	mn001 (out net13 vssa vssa) nmos1 l=180n w=1u m=1
	mnpd2 (net13 pd vssa vssa) nmos1 l=2.6e-07n w=2.0e-06u m=1
	mnc01 (net13 net69 net12 vssa) nmos1 l=180n w=1u m=1
	mpb02 (net27 net51 net158 vdda) pmos1 l=180n w=1u m=1
	mppd1 (net158 xpd vdda vdda) pmos1 l=180n w=1u m=1
	mps11 (net31 net158 vdda vdda) pmos1 l=180n w=1u m=1
	mpd11 (net56 inn net31 net31) pmos1 l=180n w=1u m=1
	mp001 (out net158 vdda vdda) pmos1 l=180n w=1u m=1
	mpd12 (net13 inp net31 net31) pmos1 l=180n w=1u m=1
	mpb01 (net158 net158 vdda vdda) pmos1 l=2.8e-07n w=7.7e-07u m=1
ends OPAMP1_variant493

subckt OPAMP1_variant494 inn inp out pd xpd vdda vssa
	xd1 (vssa vdda) prim_nwd AREA=6.13907e-9 PJ=476.6e-6 m=1
	xi0 (vssa net69) prim_nd AREA=1e-12 PJ=4e-6 m=1
	xi3 (net51 vdda) prim_pd AREA=790e-15 PJ=3.3e-6 m=1
	xr0 (vssa vdda net51) prim_rdiffp l=3.0e-07 w=1.1e-06 m=1
	xr1 (vdda vdda net69) prim_rdiffp l=2.1e-6 w=700e-9 m=1
	xcc01 (net12 out) prim_cpoly c=1p m=1
	mnm12 (net13 net56 vssa vssa) nmos1 l=180n w=1u m=1
	mnm11 (net56 net56 vssa vssa) nmos1 l=180n w=1u m=1
	mnb02 (net27 net27 net21 vssa) nmos1 l=180n w=1u m=1
	mnpd1 (net21 xpd vssa vssa) nmos1 l=2.1e-07n w=9.3e-07u m=1
	mn001 (out net13 vssa vssa) nmos1 l=180n w=1u m=1
	mnpd2 (net13 pd vssa vssa) nmos1 l=180n w=1u m=1
	mnc01 (net13 net69 net12 vssa) nmos1 l=180n w=1u m=1
	mpb02 (net27 net51 net158 vdda) pmos1 l=180n w=1u m=1
	mppd1 (net158 xpd vdda vdda) pmos1 l=180n w=1u m=1
	mps11 (net31 net158 vdda vdda) pmos1 l=180n w=1u m=1
	mpd11 (net56 inn net31 net31) pmos1 l=2.2e-07n w=9.3e-07u m=1
	mp001 (out net158 vdda vdda) pmos1 l=180n w=1u m=1
	mpd12 (net13 inp net31 net31) pmos1 l=180n w=1u m=1
	mpb01 (net158 net158 vdda vdda) pmos1 l=180n w=1u m=1
ends OPAMP1_variant494

subckt OPAMP1_variant495 inn inp out pd xpd vdda vssa
	xd1 (vssa vdda) prim_nwd AREA=6.13907e-9 PJ=476.6e-6 m=1
	xi0 (vssa net69) prim_nd AREA=1e-12 PJ=4e-6 m=1
	xi3 (net51 vdda) prim_pd AREA=790e-15 PJ=3.3e-6 m=1
	xr0 (vssa vdda net51) prim_rdiffp l=2.1e-6 w=700e-9 m=1
	xr1 (vdda vdda net69) prim_rdiffp l=1.8e-07 w=1.9e-06 m=1
	xcc01 (net12 out) prim_cpoly c=1p m=1
	mnm12 (net13 net56 vssa vssa) nmos1 l=180n w=1u m=1
	mnm11 (net56 net56 vssa vssa) nmos1 l=1.8e-07n w=1.7e-06u m=1
	mnb02 (net27 net27 net21 vssa) nmos1 l=180n w=1u m=1
	mnpd1 (net21 xpd vssa vssa) nmos1 l=180n w=1u m=1
	mn001 (out net13 vssa vssa) nmos1 l=1.4e-07n w=1.6e-06u m=1
	mnpd2 (net13 pd vssa vssa) nmos1 l=180n w=1u m=1
	mnc01 (net13 net69 net12 vssa) nmos1 l=180n w=1u m=1
	mpb02 (net27 net51 net158 vdda) pmos1 l=1.3e-07n w=8.7e-07u m=1
	mppd1 (net158 xpd vdda vdda) pmos1 l=180n w=1u m=1
	mps11 (net31 net158 vdda vdda) pmos1 l=180n w=1u m=1
	mpd11 (net56 inn net31 net31) pmos1 l=180n w=1u m=1
	mp001 (out net158 vdda vdda) pmos1 l=180n w=1u m=1
	mpd12 (net13 inp net31 net31) pmos1 l=1.6e-07n w=1.6e-06u m=1
	mpb01 (net158 net158 vdda vdda) pmos1 l=180n w=1u m=1
ends OPAMP1_variant495

subckt OPAMP1_variant496 inn inp out pd xpd vdda vssa
	xd1 (vssa vdda) prim_nwd AREA=6.13907e-9 PJ=476.6e-6 m=1
	xi0 (vssa net69) prim_nd AREA=1.2e-09 PJ=3.8e-05 m=1
	xi3 (net51 vdda) prim_pd AREA=790e-15 PJ=3.3e-6 m=1
	xr0 (vssa vdda net51) prim_rdiffp l=2.7e-07 w=1.1e-06 m=1
	xr1 (vdda vdda net69) prim_rdiffp l=2.1e-6 w=700e-9 m=1
	xcc01 (net12 out) prim_cpoly c=1p m=1
	mnm12 (net13 net56 vssa vssa) nmos1 l=180n w=1u m=1
	mnm11 (net56 net56 vssa vssa) nmos1 l=180n w=1u m=1
	mnb02 (net27 net27 net21 vssa) nmos1 l=180n w=1u m=1
	mnpd1 (net21 xpd vssa vssa) nmos1 l=180n w=1u m=1
	mn001 (out net13 vssa vssa) nmos1 l=180n w=1u m=1
	mnpd2 (net13 pd vssa vssa) nmos1 l=180n w=1u m=1
	mnc01 (net13 net69 net12 vssa) nmos1 l=180n w=1u m=1
	mpb02 (net27 net51 net158 vdda) pmos1 l=2.1e-07n w=1.3e-06u m=1
	mppd1 (net158 xpd vdda vdda) pmos1 l=180n w=1u m=1
	mps11 (net31 net158 vdda vdda) pmos1 l=180n w=1u m=1
	mpd11 (net56 inn net31 net31) pmos1 l=1.5e-07n w=1.4e-06u m=1
	mp001 (out net158 vdda vdda) pmos1 l=2.5e-07n w=1.6e-06u m=1
	mpd12 (net13 inp net31 net31) pmos1 l=180n w=1u m=1
	mpb01 (net158 net158 vdda vdda) pmos1 l=180n w=1u m=1
ends OPAMP1_variant496

subckt OPAMP1_variant497 inn inp out pd xpd vdda vssa
	xd1 (vssa vdda) prim_nwd AREA=6.13907e-9 PJ=476.6e-6 m=1
	xi0 (vssa net69) prim_nd AREA=1e-12 PJ=4e-6 m=1
	xi3 (net51 vdda) prim_pd AREA=790e-15 PJ=3.3e-6 m=1
	xr0 (vssa vdda net51) prim_rdiffp l=2.1e-6 w=700e-9 m=1
	xr1 (vdda vdda net69) prim_rdiffp l=2.1e-6 w=700e-9 m=1
	xcc01 (net12 out) prim_cpoly c=1p m=1
	mnm12 (net13 net56 vssa vssa) nmos1 l=180n w=1u m=1
	mnm11 (net56 net56 vssa vssa) nmos1 l=180n w=1u m=1
	mnb02 (net27 net27 net21 vssa) nmos1 l=180n w=1u m=1
	mnpd1 (net21 xpd vssa vssa) nmos1 l=180n w=1u m=1
	mn001 (out net13 vssa vssa) nmos1 l=180n w=1u m=1
	mnpd2 (net13 pd vssa vssa) nmos1 l=180n w=1u m=1
	mnc01 (net13 net69 net12 vssa) nmos1 l=180n w=1u m=1
	mpb02 (net27 net51 net158 vdda) pmos1 l=180n w=1u m=1
	mppd1 (net158 xpd vdda vdda) pmos1 l=1.6e-07n w=1.2e-06u m=1
	mps11 (net31 net158 vdda vdda) pmos1 l=1.7e-07n w=6.7e-07u m=1
	mpd11 (net56 inn net31 net31) pmos1 l=180n w=1u m=1
	mp001 (out net158 vdda vdda) pmos1 l=180n w=1u m=1
	mpd12 (net13 inp net31 net31) pmos1 l=180n w=1u m=1
	mpb01 (net158 net158 vdda vdda) pmos1 l=180n w=1u m=1
ends OPAMP1_variant497

subckt OPAMP1_variant498 inn inp out pd xpd vdda vssa
	xd1 (vssa vdda) prim_nwd AREA=6.13907e-9 PJ=476.6e-6 m=1
	xi0 (vssa net69) prim_nd AREA=1e-12 PJ=4e-6 m=1
	xi3 (net51 vdda) prim_pd AREA=790e-15 PJ=3.3e-6 m=1
	xr0 (vssa vdda net51) prim_rdiffp l=2.1e-6 w=700e-9 m=1
	xr1 (vdda vdda net69) prim_rdiffp l=2.1e-6 w=700e-9 m=1
	xcc01 (net12 out) prim_cpoly c=1p m=1
	mnm12 (net13 net56 vssa vssa) nmos1 l=180n w=1u m=1
	mnm11 (net56 net56 vssa vssa) nmos1 l=180n w=1u m=1
	mnb02 (net27 net27 net21 vssa) nmos1 l=2.7e-07n w=1.2e-06u m=1
	mnpd1 (net21 xpd vssa vssa) nmos1 l=180n w=1u m=1
	mn001 (out net13 vssa vssa) nmos1 l=180n w=1u m=1
	mnpd2 (net13 pd vssa vssa) nmos1 l=180n w=1u m=1
	mnc01 (net13 net69 net12 vssa) nmos1 l=180n w=1u m=1
	mpb02 (net27 net51 net158 vdda) pmos1 l=2.9e-07n w=1.4e-06u m=1
	mppd1 (net158 xpd vdda vdda) pmos1 l=180n w=1u m=1
	mps11 (net31 net158 vdda vdda) pmos1 l=180n w=1u m=1
	mpd11 (net56 inn net31 net31) pmos1 l=180n w=1u m=1
	mp001 (out net158 vdda vdda) pmos1 l=180n w=1u m=1
	mpd12 (net13 inp net31 net31) pmos1 l=180n w=1u m=1
	mpb01 (net158 net158 vdda vdda) pmos1 l=180n w=1u m=1
ends OPAMP1_variant498

subckt OPAMP1_variant499 inn inp out pd xpd vdda vssa
	xd1 (vssa vdda) prim_nwd AREA=2.5e-10 PJ=3.1e-05 m=1
	xi0 (vssa net69) prim_nd AREA=1e-12 PJ=4e-6 m=1
	xi3 (net51 vdda) prim_pd AREA=790e-15 PJ=3.3e-6 m=1
	xr0 (vssa vdda net51) prim_rdiffp l=2.1e-6 w=700e-9 m=1
	xr1 (vdda vdda net69) prim_rdiffp l=2.1e-6 w=700e-9 m=1
	xcc01 (net12 out) prim_cpoly c=1p m=1
	mnm12 (net13 net56 vssa vssa) nmos1 l=180n w=1u m=1
	mnm11 (net56 net56 vssa vssa) nmos1 l=180n w=1u m=1
	mnb02 (net27 net27 net21 vssa) nmos1 l=2.3e-07n w=1.6e-06u m=1
	mnpd1 (net21 xpd vssa vssa) nmos1 l=180n w=1u m=1
	mn001 (out net13 vssa vssa) nmos1 l=180n w=1u m=1
	mnpd2 (net13 pd vssa vssa) nmos1 l=180n w=1u m=1
	mnc01 (net13 net69 net12 vssa) nmos1 l=180n w=1u m=1
	mpb02 (net27 net51 net158 vdda) pmos1 l=1.4e-07n w=1.7e-06u m=1
	mppd1 (net158 xpd vdda vdda) pmos1 l=180n w=1u m=1
	mps11 (net31 net158 vdda vdda) pmos1 l=2.0e-07n w=1.5e-06u m=1
	mpd11 (net56 inn net31 net31) pmos1 l=180n w=1u m=1
	mp001 (out net158 vdda vdda) pmos1 l=180n w=1u m=1
	mpd12 (net13 inp net31 net31) pmos1 l=180n w=1u m=1
	mpb01 (net158 net158 vdda vdda) pmos1 l=180n w=1u m=1
ends OPAMP1_variant499

subckt OPAMP1_variant500 inn inp out pd xpd vdda vssa
	xd1 (vssa vdda) prim_nwd AREA=9.8e-09 PJ=5.5e-05 m=1
	xi0 (vssa net69) prim_nd AREA=1e-12 PJ=4e-6 m=1
	xi3 (net51 vdda) prim_pd AREA=790e-15 PJ=3.3e-6 m=1
	xr0 (vssa vdda net51) prim_rdiffp l=2.1e-6 w=700e-9 m=1
	xr1 (vdda vdda net69) prim_rdiffp l=2.1e-6 w=700e-9 m=1
	xcc01 (net12 out) prim_cpoly c=1p m=1
	mnm12 (net13 net56 vssa vssa) nmos1 l=180n w=1u m=1
	mnm11 (net56 net56 vssa vssa) nmos1 l=180n w=1u m=1
	mnb02 (net27 net27 net21 vssa) nmos1 l=180n w=1u m=1
	mnpd1 (net21 xpd vssa vssa) nmos1 l=180n w=1u m=1
	mn001 (out net13 vssa vssa) nmos1 l=1.5e-07n w=1.1e-06u m=1
	mnpd2 (net13 pd vssa vssa) nmos1 l=180n w=1u m=1
	mnc01 (net13 net69 net12 vssa) nmos1 l=180n w=1u m=1
	mpb02 (net27 net51 net158 vdda) pmos1 l=180n w=1u m=1
	mppd1 (net158 xpd vdda vdda) pmos1 l=180n w=1u m=1
	mps11 (net31 net158 vdda vdda) pmos1 l=180n w=1u m=1
	mpd11 (net56 inn net31 net31) pmos1 l=180n w=1u m=1
	mp001 (out net158 vdda vdda) pmos1 l=180n w=1u m=1
	mpd12 (net13 inp net31 net31) pmos1 l=180n w=1u m=1
	mpb01 (net158 net158 vdda vdda) pmos1 l=180n w=1u m=1
ends OPAMP1_variant500

subckt OPAMP1_variant501 inn inp out pd xpd vdda vssa
	xd1 (vssa vdda) prim_nwd AREA=6.13907e-9 PJ=476.6e-6 m=1
	xi0 (vssa net69) prim_nd AREA=1e-12 PJ=4e-6 m=1
	xi3 (net51 vdda) prim_pd AREA=4.6e-09 PJ=4.6e-05 m=1
	xr0 (vssa vdda net51) prim_rdiffp l=2.1e-6 w=700e-9 m=1
	xr1 (vdda vdda net69) prim_rdiffp l=2.1e-6 w=700e-9 m=1
	xcc01 (net12 out) prim_cpoly c=1p m=1
	mnm12 (net13 net56 vssa vssa) nmos1 l=1.7e-07n w=8.6e-07u m=1
	mnm11 (net56 net56 vssa vssa) nmos1 l=180n w=1u m=1
	mnb02 (net27 net27 net21 vssa) nmos1 l=180n w=1u m=1
	mnpd1 (net21 xpd vssa vssa) nmos1 l=180n w=1u m=1
	mn001 (out net13 vssa vssa) nmos1 l=180n w=1u m=1
	mnpd2 (net13 pd vssa vssa) nmos1 l=180n w=1u m=1
	mnc01 (net13 net69 net12 vssa) nmos1 l=180n w=1u m=1
	mpb02 (net27 net51 net158 vdda) pmos1 l=2.2e-07n w=8.0e-07u m=1
	mppd1 (net158 xpd vdda vdda) pmos1 l=1.5e-07n w=9.5e-07u m=1
	mps11 (net31 net158 vdda vdda) pmos1 l=180n w=1u m=1
	mpd11 (net56 inn net31 net31) pmos1 l=180n w=1u m=1
	mp001 (out net158 vdda vdda) pmos1 l=180n w=1u m=1
	mpd12 (net13 inp net31 net31) pmos1 l=1.5e-07n w=9.2e-07u m=1
	mpb01 (net158 net158 vdda vdda) pmos1 l=180n w=1u m=1
ends OPAMP1_variant501

subckt OPAMP1_variant502 inn inp out pd xpd vdda vssa
	xd1 (vssa vdda) prim_nwd AREA=6.13907e-9 PJ=476.6e-6 m=1
	xi0 (vssa net69) prim_nd AREA=1e-12 PJ=4e-6 m=1
	xi3 (net51 vdda) prim_pd AREA=790e-15 PJ=3.3e-6 m=1
	xr0 (vssa vdda net51) prim_rdiffp l=2.1e-6 w=700e-9 m=1
	xr1 (vdda vdda net69) prim_rdiffp l=2.1e-6 w=700e-9 m=1
	xcc01 (net12 out) prim_cpoly c=1p m=1
	mnm12 (net13 net56 vssa vssa) nmos1 l=180n w=1u m=1
	mnm11 (net56 net56 vssa vssa) nmos1 l=180n w=1u m=1
	mnb02 (net27 net27 net21 vssa) nmos1 l=180n w=1u m=1
	mnpd1 (net21 xpd vssa vssa) nmos1 l=180n w=1u m=1
	mn001 (out net13 vssa vssa) nmos1 l=180n w=1u m=1
	mnpd2 (net13 pd vssa vssa) nmos1 l=180n w=1u m=1
	mnc01 (net13 net69 net12 vssa) nmos1 l=2.6e-07n w=1.8e-06u m=1
	mpb02 (net27 net51 net158 vdda) pmos1 l=180n w=1u m=1
	mppd1 (net158 xpd vdda vdda) pmos1 l=2.2e-07n w=5.9e-07u m=1
	mps11 (net31 net158 vdda vdda) pmos1 l=180n w=1u m=1
	mpd11 (net56 inn net31 net31) pmos1 l=180n w=1u m=1
	mp001 (out net158 vdda vdda) pmos1 l=180n w=1u m=1
	mpd12 (net13 inp net31 net31) pmos1 l=180n w=1u m=1
	mpb01 (net158 net158 vdda vdda) pmos1 l=1.4e-07n w=6.2e-07u m=1
ends OPAMP1_variant502

subckt OPAMP1_variant503 inn inp out pd xpd vdda vssa
	xd1 (vssa vdda) prim_nwd AREA=7.2e-09 PJ=2.6e-05 m=1
	xi0 (vssa net69) prim_nd AREA=2.8e-09 PJ=1.8e-05 m=1
	xi3 (net51 vdda) prim_pd AREA=790e-15 PJ=3.3e-6 m=1
	xr0 (vssa vdda net51) prim_rdiffp l=2.1e-6 w=700e-9 m=1
	xr1 (vdda vdda net69) prim_rdiffp l=2.1e-6 w=700e-9 m=1
	xcc01 (net12 out) prim_cpoly c=1p m=1
	mnm12 (net13 net56 vssa vssa) nmos1 l=180n w=1u m=1
	mnm11 (net56 net56 vssa vssa) nmos1 l=180n w=1u m=1
	mnb02 (net27 net27 net21 vssa) nmos1 l=180n w=1u m=1
	mnpd1 (net21 xpd vssa vssa) nmos1 l=180n w=1u m=1
	mn001 (out net13 vssa vssa) nmos1 l=180n w=1u m=1
	mnpd2 (net13 pd vssa vssa) nmos1 l=180n w=1u m=1
	mnc01 (net13 net69 net12 vssa) nmos1 l=2.2e-07n w=1.1e-06u m=1
	mpb02 (net27 net51 net158 vdda) pmos1 l=180n w=1u m=1
	mppd1 (net158 xpd vdda vdda) pmos1 l=2.5e-07n w=9.6e-07u m=1
	mps11 (net31 net158 vdda vdda) pmos1 l=180n w=1u m=1
	mpd11 (net56 inn net31 net31) pmos1 l=180n w=1u m=1
	mp001 (out net158 vdda vdda) pmos1 l=180n w=1u m=1
	mpd12 (net13 inp net31 net31) pmos1 l=180n w=1u m=1
	mpb01 (net158 net158 vdda vdda) pmos1 l=1.6e-07n w=1.8e-06u m=1
ends OPAMP1_variant503

subckt OPAMP1_variant504 inn inp out pd xpd vdda vssa
	xd1 (vssa vdda) prim_nwd AREA=6.13907e-9 PJ=476.6e-6 m=1
	xi0 (vssa net69) prim_nd AREA=1e-12 PJ=4e-6 m=1
	xi3 (net51 vdda) prim_pd AREA=790e-15 PJ=3.3e-6 m=1
	xr0 (vssa vdda net51) prim_rdiffp l=2.1e-6 w=700e-9 m=1
	xr1 (vdda vdda net69) prim_rdiffp l=2.1e-6 w=700e-9 m=1
	xcc01 (net12 out) prim_cpoly c=1p m=1
	mnm12 (net13 net56 vssa vssa) nmos1 l=180n w=1u m=1
	mnm11 (net56 net56 vssa vssa) nmos1 l=180n w=1u m=1
	mnb02 (net27 net27 net21 vssa) nmos1 l=180n w=1u m=1
	mnpd1 (net21 xpd vssa vssa) nmos1 l=180n w=1u m=1
	mn001 (out net13 vssa vssa) nmos1 l=180n w=1u m=1
	mnpd2 (net13 pd vssa vssa) nmos1 l=180n w=1u m=1
	mnc01 (net13 net69 net12 vssa) nmos1 l=180n w=1u m=1
	mpb02 (net27 net51 net158 vdda) pmos1 l=2.7e-07n w=9.8e-07u m=1
	mppd1 (net158 xpd vdda vdda) pmos1 l=180n w=1u m=1
	mps11 (net31 net158 vdda vdda) pmos1 l=180n w=1u m=1
	mpd11 (net56 inn net31 net31) pmos1 l=180n w=1u m=1
	mp001 (out net158 vdda vdda) pmos1 l=180n w=1u m=1
	mpd12 (net13 inp net31 net31) pmos1 l=1.3e-07n w=8.6e-07u m=1
	mpb01 (net158 net158 vdda vdda) pmos1 l=1.1e-07n w=1.6e-06u m=1
ends OPAMP1_variant504

subckt OPAMP1_variant505 inn inp out pd xpd vdda vssa
	xd1 (vssa vdda) prim_nwd AREA=6.13907e-9 PJ=476.6e-6 m=1
	xi0 (vssa net69) prim_nd AREA=1e-12 PJ=4e-6 m=1
	xi3 (net51 vdda) prim_pd AREA=790e-15 PJ=3.3e-6 m=1
	xr0 (vssa vdda net51) prim_rdiffp l=1.1e-07 w=1.8e-06 m=1
	xr1 (vdda vdda net69) prim_rdiffp l=2.1e-6 w=700e-9 m=1
	xcc01 (net12 out) prim_cpoly c=1p m=1
	mnm12 (net13 net56 vssa vssa) nmos1 l=180n w=1u m=1
	mnm11 (net56 net56 vssa vssa) nmos1 l=180n w=1u m=1
	mnb02 (net27 net27 net21 vssa) nmos1 l=180n w=1u m=1
	mnpd1 (net21 xpd vssa vssa) nmos1 l=180n w=1u m=1
	mn001 (out net13 vssa vssa) nmos1 l=180n w=1u m=1
	mnpd2 (net13 pd vssa vssa) nmos1 l=180n w=1u m=1
	mnc01 (net13 net69 net12 vssa) nmos1 l=180n w=1u m=1
	mpb02 (net27 net51 net158 vdda) pmos1 l=180n w=1u m=1
	mppd1 (net158 xpd vdda vdda) pmos1 l=180n w=1u m=1
	mps11 (net31 net158 vdda vdda) pmos1 l=2.5e-07n w=1.3e-06u m=1
	mpd11 (net56 inn net31 net31) pmos1 l=180n w=1u m=1
	mp001 (out net158 vdda vdda) pmos1 l=180n w=1u m=1
	mpd12 (net13 inp net31 net31) pmos1 l=180n w=1u m=1
	mpb01 (net158 net158 vdda vdda) pmos1 l=2.2e-07n w=6.4e-07u m=1
ends OPAMP1_variant505

subckt OPAMP1_variant506 inn inp out pd xpd vdda vssa
	xd1 (vssa vdda) prim_nwd AREA=6.13907e-9 PJ=476.6e-6 m=1
	xi0 (vssa net69) prim_nd AREA=1e-12 PJ=4e-6 m=1
	xi3 (net51 vdda) prim_pd AREA=790e-15 PJ=3.3e-6 m=1
	xr0 (vssa vdda net51) prim_rdiffp l=2.1e-6 w=700e-9 m=1
	xr1 (vdda vdda net69) prim_rdiffp l=2.1e-6 w=700e-9 m=1
	xcc01 (net12 out) prim_cpoly c=1p m=1
	mnm12 (net13 net56 vssa vssa) nmos1 l=2.9e-07n w=1.9e-06u m=1
	mnm11 (net56 net56 vssa vssa) nmos1 l=180n w=1u m=1
	mnb02 (net27 net27 net21 vssa) nmos1 l=180n w=1u m=1
	mnpd1 (net21 xpd vssa vssa) nmos1 l=180n w=1u m=1
	mn001 (out net13 vssa vssa) nmos1 l=2.3e-07n w=1.5e-06u m=1
	mnpd2 (net13 pd vssa vssa) nmos1 l=180n w=1u m=1
	mnc01 (net13 net69 net12 vssa) nmos1 l=180n w=1u m=1
	mpb02 (net27 net51 net158 vdda) pmos1 l=180n w=1u m=1
	mppd1 (net158 xpd vdda vdda) pmos1 l=180n w=1u m=1
	mps11 (net31 net158 vdda vdda) pmos1 l=180n w=1u m=1
	mpd11 (net56 inn net31 net31) pmos1 l=180n w=1u m=1
	mp001 (out net158 vdda vdda) pmos1 l=180n w=1u m=1
	mpd12 (net13 inp net31 net31) pmos1 l=180n w=1u m=1
	mpb01 (net158 net158 vdda vdda) pmos1 l=180n w=1u m=1
ends OPAMP1_variant506

subckt OPAMP1_variant507 inn inp out pd xpd vdda vssa
	xd1 (vssa vdda) prim_nwd AREA=6.13907e-9 PJ=476.6e-6 m=1
	xi0 (vssa net69) prim_nd AREA=1e-12 PJ=4e-6 m=1
	xi3 (net51 vdda) prim_pd AREA=790e-15 PJ=3.3e-6 m=1
	xr0 (vssa vdda net51) prim_rdiffp l=2.1e-6 w=700e-9 m=1
	xr1 (vdda vdda net69) prim_rdiffp l=2.5e-07 w=1.1e-06 m=1
	xcc01 (net12 out) prim_cpoly c=1p m=1
	mnm12 (net13 net56 vssa vssa) nmos1 l=180n w=1u m=1
	mnm11 (net56 net56 vssa vssa) nmos1 l=1.5e-07n w=2.0e-06u m=1
	mnb02 (net27 net27 net21 vssa) nmos1 l=180n w=1u m=1
	mnpd1 (net21 xpd vssa vssa) nmos1 l=180n w=1u m=1
	mn001 (out net13 vssa vssa) nmos1 l=180n w=1u m=1
	mnpd2 (net13 pd vssa vssa) nmos1 l=180n w=1u m=1
	mnc01 (net13 net69 net12 vssa) nmos1 l=1.4e-07n w=1.2e-06u m=1
	mpb02 (net27 net51 net158 vdda) pmos1 l=180n w=1u m=1
	mppd1 (net158 xpd vdda vdda) pmos1 l=1.1e-07n w=6.5e-07u m=1
	mps11 (net31 net158 vdda vdda) pmos1 l=180n w=1u m=1
	mpd11 (net56 inn net31 net31) pmos1 l=1.6e-07n w=8.3e-07u m=1
	mp001 (out net158 vdda vdda) pmos1 l=180n w=1u m=1
	mpd12 (net13 inp net31 net31) pmos1 l=180n w=1u m=1
	mpb01 (net158 net158 vdda vdda) pmos1 l=180n w=1u m=1
ends OPAMP1_variant507

subckt OPAMP1_variant508 inn inp out pd xpd vdda vssa
	xd1 (vssa vdda) prim_nwd AREA=6.13907e-9 PJ=476.6e-6 m=1
	xi0 (vssa net69) prim_nd AREA=1e-12 PJ=4e-6 m=1
	xi3 (net51 vdda) prim_pd AREA=790e-15 PJ=3.3e-6 m=1
	xr0 (vssa vdda net51) prim_rdiffp l=2.1e-6 w=700e-9 m=1
	xr1 (vdda vdda net69) prim_rdiffp l=2.1e-6 w=700e-9 m=1
	xcc01 (net12 out) prim_cpoly c=1p m=1
	mnm12 (net13 net56 vssa vssa) nmos1 l=180n w=1u m=1
	mnm11 (net56 net56 vssa vssa) nmos1 l=180n w=1u m=1
	mnb02 (net27 net27 net21 vssa) nmos1 l=180n w=1u m=1
	mnpd1 (net21 xpd vssa vssa) nmos1 l=180n w=1u m=1
	mn001 (out net13 vssa vssa) nmos1 l=180n w=1u m=1
	mnpd2 (net13 pd vssa vssa) nmos1 l=180n w=1u m=1
	mnc01 (net13 net69 net12 vssa) nmos1 l=1.8e-07n w=1.4e-06u m=1
	mpb02 (net27 net51 net158 vdda) pmos1 l=1.0e-07n w=2.0e-06u m=1
	mppd1 (net158 xpd vdda vdda) pmos1 l=180n w=1u m=1
	mps11 (net31 net158 vdda vdda) pmos1 l=180n w=1u m=1
	mpd11 (net56 inn net31 net31) pmos1 l=180n w=1u m=1
	mp001 (out net158 vdda vdda) pmos1 l=180n w=1u m=1
	mpd12 (net13 inp net31 net31) pmos1 l=180n w=1u m=1
	mpb01 (net158 net158 vdda vdda) pmos1 l=180n w=1u m=1
ends OPAMP1_variant508

subckt OPAMP1_variant509 inn inp out pd xpd vdda vssa
	xd1 (vssa vdda) prim_nwd AREA=6.13907e-9 PJ=476.6e-6 m=1
	xi0 (vssa net69) prim_nd AREA=1e-12 PJ=4e-6 m=1
	xi3 (net51 vdda) prim_pd AREA=2.9e-09 PJ=5.0e-06 m=1
	xr0 (vssa vdda net51) prim_rdiffp l=2.1e-6 w=700e-9 m=1
	xr1 (vdda vdda net69) prim_rdiffp l=2.1e-6 w=700e-9 m=1
	xcc01 (net12 out) prim_cpoly c=1p m=1
	mnm12 (net13 net56 vssa vssa) nmos1 l=180n w=1u m=1
	mnm11 (net56 net56 vssa vssa) nmos1 l=180n w=1u m=1
	mnb02 (net27 net27 net21 vssa) nmos1 l=180n w=1u m=1
	mnpd1 (net21 xpd vssa vssa) nmos1 l=180n w=1u m=1
	mn001 (out net13 vssa vssa) nmos1 l=180n w=1u m=1
	mnpd2 (net13 pd vssa vssa) nmos1 l=180n w=1u m=1
	mnc01 (net13 net69 net12 vssa) nmos1 l=180n w=1u m=1
	mpb02 (net27 net51 net158 vdda) pmos1 l=2.0e-07n w=1.8e-06u m=1
	mppd1 (net158 xpd vdda vdda) pmos1 l=180n w=1u m=1
	mps11 (net31 net158 vdda vdda) pmos1 l=180n w=1u m=1
	mpd11 (net56 inn net31 net31) pmos1 l=180n w=1u m=1
	mp001 (out net158 vdda vdda) pmos1 l=180n w=1u m=1
	mpd12 (net13 inp net31 net31) pmos1 l=1.3e-07n w=6.2e-07u m=1
	mpb01 (net158 net158 vdda vdda) pmos1 l=180n w=1u m=1
ends OPAMP1_variant509

subckt OPAMP1_variant510 inn inp out pd xpd vdda vssa
	xd1 (vssa vdda) prim_nwd AREA=6.13907e-9 PJ=476.6e-6 m=1
	xi0 (vssa net69) prim_nd AREA=1e-12 PJ=4e-6 m=1
	xi3 (net51 vdda) prim_pd AREA=790e-15 PJ=3.3e-6 m=1
	xr0 (vssa vdda net51) prim_rdiffp l=2.1e-6 w=700e-9 m=1
	xr1 (vdda vdda net69) prim_rdiffp l=2.1e-6 w=700e-9 m=1
	xcc01 (net12 out) prim_cpoly c=1p m=1
	mnm12 (net13 net56 vssa vssa) nmos1 l=180n w=1u m=1
	mnm11 (net56 net56 vssa vssa) nmos1 l=180n w=1u m=1
	mnb02 (net27 net27 net21 vssa) nmos1 l=180n w=1u m=1
	mnpd1 (net21 xpd vssa vssa) nmos1 l=1.7e-07n w=1.5e-06u m=1
	mn001 (out net13 vssa vssa) nmos1 l=180n w=1u m=1
	mnpd2 (net13 pd vssa vssa) nmos1 l=2.8e-07n w=1.3e-06u m=1
	mnc01 (net13 net69 net12 vssa) nmos1 l=180n w=1u m=1
	mpb02 (net27 net51 net158 vdda) pmos1 l=180n w=1u m=1
	mppd1 (net158 xpd vdda vdda) pmos1 l=180n w=1u m=1
	mps11 (net31 net158 vdda vdda) pmos1 l=180n w=1u m=1
	mpd11 (net56 inn net31 net31) pmos1 l=180n w=1u m=1
	mp001 (out net158 vdda vdda) pmos1 l=180n w=1u m=1
	mpd12 (net13 inp net31 net31) pmos1 l=180n w=1u m=1
	mpb01 (net158 net158 vdda vdda) pmos1 l=180n w=1u m=1
ends OPAMP1_variant510

subckt OPAMP1_variant511 inn inp out pd xpd vdda vssa
	xd1 (vssa vdda) prim_nwd AREA=6.13907e-9 PJ=476.6e-6 m=1
	xi0 (vssa net69) prim_nd AREA=1e-12 PJ=4e-6 m=1
	xi3 (net51 vdda) prim_pd AREA=790e-15 PJ=3.3e-6 m=1
	xr0 (vssa vdda net51) prim_rdiffp l=2.1e-6 w=700e-9 m=1
	xr1 (vdda vdda net69) prim_rdiffp l=2.1e-6 w=700e-9 m=1
	xcc01 (net12 out) prim_cpoly c=1.3e-12p m=1
	mnm12 (net13 net56 vssa vssa) nmos1 l=180n w=1u m=1
	mnm11 (net56 net56 vssa vssa) nmos1 l=180n w=1u m=1
	mnb02 (net27 net27 net21 vssa) nmos1 l=180n w=1u m=1
	mnpd1 (net21 xpd vssa vssa) nmos1 l=180n w=1u m=1
	mn001 (out net13 vssa vssa) nmos1 l=2.5e-07n w=1.5e-06u m=1
	mnpd2 (net13 pd vssa vssa) nmos1 l=180n w=1u m=1
	mnc01 (net13 net69 net12 vssa) nmos1 l=180n w=1u m=1
	mpb02 (net27 net51 net158 vdda) pmos1 l=180n w=1u m=1
	mppd1 (net158 xpd vdda vdda) pmos1 l=180n w=1u m=1
	mps11 (net31 net158 vdda vdda) pmos1 l=2.6e-07n w=8.2e-07u m=1
	mpd11 (net56 inn net31 net31) pmos1 l=180n w=1u m=1
	mp001 (out net158 vdda vdda) pmos1 l=180n w=1u m=1
	mpd12 (net13 inp net31 net31) pmos1 l=2.1e-07n w=1.7e-06u m=1
	mpb01 (net158 net158 vdda vdda) pmos1 l=180n w=1u m=1
ends OPAMP1_variant511

subckt OPAMP1_variant512 inn inp out pd xpd vdda vssa
	xd1 (vssa vdda) prim_nwd AREA=6.13907e-9 PJ=476.6e-6 m=1
	xi0 (vssa net69) prim_nd AREA=1e-12 PJ=4e-6 m=1
	xi3 (net51 vdda) prim_pd AREA=790e-15 PJ=3.3e-6 m=1
	xr0 (vssa vdda net51) prim_rdiffp l=2.1e-6 w=700e-9 m=1
	xr1 (vdda vdda net69) prim_rdiffp l=2.2e-07 w=1.8e-06 m=1
	xcc01 (net12 out) prim_cpoly c=1.8e-12p m=1
	mnm12 (net13 net56 vssa vssa) nmos1 l=180n w=1u m=1
	mnm11 (net56 net56 vssa vssa) nmos1 l=180n w=1u m=1
	mnb02 (net27 net27 net21 vssa) nmos1 l=180n w=1u m=1
	mnpd1 (net21 xpd vssa vssa) nmos1 l=180n w=1u m=1
	mn001 (out net13 vssa vssa) nmos1 l=180n w=1u m=1
	mnpd2 (net13 pd vssa vssa) nmos1 l=180n w=1u m=1
	mnc01 (net13 net69 net12 vssa) nmos1 l=180n w=1u m=1
	mpb02 (net27 net51 net158 vdda) pmos1 l=180n w=1u m=1
	mppd1 (net158 xpd vdda vdda) pmos1 l=180n w=1u m=1
	mps11 (net31 net158 vdda vdda) pmos1 l=2.5e-07n w=7.0e-07u m=1
	mpd11 (net56 inn net31 net31) pmos1 l=180n w=1u m=1
	mp001 (out net158 vdda vdda) pmos1 l=180n w=1u m=1
	mpd12 (net13 inp net31 net31) pmos1 l=180n w=1u m=1
	mpb01 (net158 net158 vdda vdda) pmos1 l=180n w=1u m=1
ends OPAMP1_variant512

subckt OPAMP1_variant513 inn inp out pd xpd vdda vssa
	xd1 (vssa vdda) prim_nwd AREA=6.13907e-9 PJ=476.6e-6 m=1
	xi0 (vssa net69) prim_nd AREA=1e-12 PJ=4e-6 m=1
	xi3 (net51 vdda) prim_pd AREA=790e-15 PJ=3.3e-6 m=1
	xr0 (vssa vdda net51) prim_rdiffp l=2.1e-6 w=700e-9 m=1
	xr1 (vdda vdda net69) prim_rdiffp l=1.5e-07 w=1.3e-06 m=1
	xcc01 (net12 out) prim_cpoly c=1p m=1
	mnm12 (net13 net56 vssa vssa) nmos1 l=2.3e-07n w=1.5e-06u m=1
	mnm11 (net56 net56 vssa vssa) nmos1 l=180n w=1u m=1
	mnb02 (net27 net27 net21 vssa) nmos1 l=1.2e-07n w=1.8e-06u m=1
	mnpd1 (net21 xpd vssa vssa) nmos1 l=180n w=1u m=1
	mn001 (out net13 vssa vssa) nmos1 l=1.7e-07n w=1.6e-06u m=1
	mnpd2 (net13 pd vssa vssa) nmos1 l=180n w=1u m=1
	mnc01 (net13 net69 net12 vssa) nmos1 l=180n w=1u m=1
	mpb02 (net27 net51 net158 vdda) pmos1 l=180n w=1u m=1
	mppd1 (net158 xpd vdda vdda) pmos1 l=180n w=1u m=1
	mps11 (net31 net158 vdda vdda) pmos1 l=180n w=1u m=1
	mpd11 (net56 inn net31 net31) pmos1 l=180n w=1u m=1
	mp001 (out net158 vdda vdda) pmos1 l=180n w=1u m=1
	mpd12 (net13 inp net31 net31) pmos1 l=180n w=1u m=1
	mpb01 (net158 net158 vdda vdda) pmos1 l=1.5e-07n w=1.5e-06u m=1
ends OPAMP1_variant513

subckt OPAMP1_variant514 inn inp out pd xpd vdda vssa
	xd1 (vssa vdda) prim_nwd AREA=6.13907e-9 PJ=476.6e-6 m=1
	xi0 (vssa net69) prim_nd AREA=8.5e-09 PJ=7.5e-05 m=1
	xi3 (net51 vdda) prim_pd AREA=790e-15 PJ=3.3e-6 m=1
	xr0 (vssa vdda net51) prim_rdiffp l=2.1e-6 w=700e-9 m=1
	xr1 (vdda vdda net69) prim_rdiffp l=2.1e-6 w=700e-9 m=1
	xcc01 (net12 out) prim_cpoly c=1p m=1
	mnm12 (net13 net56 vssa vssa) nmos1 l=1.7e-07n w=9.8e-07u m=1
	mnm11 (net56 net56 vssa vssa) nmos1 l=180n w=1u m=1
	mnb02 (net27 net27 net21 vssa) nmos1 l=180n w=1u m=1
	mnpd1 (net21 xpd vssa vssa) nmos1 l=1.8e-07n w=9.2e-07u m=1
	mn001 (out net13 vssa vssa) nmos1 l=180n w=1u m=1
	mnpd2 (net13 pd vssa vssa) nmos1 l=180n w=1u m=1
	mnc01 (net13 net69 net12 vssa) nmos1 l=180n w=1u m=1
	mpb02 (net27 net51 net158 vdda) pmos1 l=180n w=1u m=1
	mppd1 (net158 xpd vdda vdda) pmos1 l=180n w=1u m=1
	mps11 (net31 net158 vdda vdda) pmos1 l=180n w=1u m=1
	mpd11 (net56 inn net31 net31) pmos1 l=180n w=1u m=1
	mp001 (out net158 vdda vdda) pmos1 l=180n w=1u m=1
	mpd12 (net13 inp net31 net31) pmos1 l=180n w=1u m=1
	mpb01 (net158 net158 vdda vdda) pmos1 l=180n w=1u m=1
ends OPAMP1_variant514

subckt OPAMP1_variant515 inn inp out pd xpd vdda vssa
	xd1 (vssa vdda) prim_nwd AREA=6.13907e-9 PJ=476.6e-6 m=1
	xi0 (vssa net69) prim_nd AREA=6.1e-09 PJ=5.8e-05 m=1
	xi3 (net51 vdda) prim_pd AREA=790e-15 PJ=3.3e-6 m=1
	xr0 (vssa vdda net51) prim_rdiffp l=2.1e-6 w=700e-9 m=1
	xr1 (vdda vdda net69) prim_rdiffp l=2.4e-07 w=1.3e-06 m=1
	xcc01 (net12 out) prim_cpoly c=1p m=1
	mnm12 (net13 net56 vssa vssa) nmos1 l=180n w=1u m=1
	mnm11 (net56 net56 vssa vssa) nmos1 l=180n w=1u m=1
	mnb02 (net27 net27 net21 vssa) nmos1 l=180n w=1u m=1
	mnpd1 (net21 xpd vssa vssa) nmos1 l=180n w=1u m=1
	mn001 (out net13 vssa vssa) nmos1 l=180n w=1u m=1
	mnpd2 (net13 pd vssa vssa) nmos1 l=180n w=1u m=1
	mnc01 (net13 net69 net12 vssa) nmos1 l=2.8e-07n w=1.8e-06u m=1
	mpb02 (net27 net51 net158 vdda) pmos1 l=180n w=1u m=1
	mppd1 (net158 xpd vdda vdda) pmos1 l=180n w=1u m=1
	mps11 (net31 net158 vdda vdda) pmos1 l=180n w=1u m=1
	mpd11 (net56 inn net31 net31) pmos1 l=180n w=1u m=1
	mp001 (out net158 vdda vdda) pmos1 l=180n w=1u m=1
	mpd12 (net13 inp net31 net31) pmos1 l=1.8e-07n w=1.5e-06u m=1
	mpb01 (net158 net158 vdda vdda) pmos1 l=180n w=1u m=1
ends OPAMP1_variant515

subckt OPAMP1_variant516 inn inp out pd xpd vdda vssa
	xd1 (vssa vdda) prim_nwd AREA=6.13907e-9 PJ=476.6e-6 m=1
	xi0 (vssa net69) prim_nd AREA=1e-12 PJ=4e-6 m=1
	xi3 (net51 vdda) prim_pd AREA=790e-15 PJ=3.3e-6 m=1
	xr0 (vssa vdda net51) prim_rdiffp l=1.8e-07 w=1.0e-06 m=1
	xr1 (vdda vdda net69) prim_rdiffp l=2.1e-6 w=700e-9 m=1
	xcc01 (net12 out) prim_cpoly c=1p m=1
	mnm12 (net13 net56 vssa vssa) nmos1 l=180n w=1u m=1
	mnm11 (net56 net56 vssa vssa) nmos1 l=180n w=1u m=1
	mnb02 (net27 net27 net21 vssa) nmos1 l=180n w=1u m=1
	mnpd1 (net21 xpd vssa vssa) nmos1 l=180n w=1u m=1
	mn001 (out net13 vssa vssa) nmos1 l=180n w=1u m=1
	mnpd2 (net13 pd vssa vssa) nmos1 l=180n w=1u m=1
	mnc01 (net13 net69 net12 vssa) nmos1 l=1.1e-07n w=8.5e-07u m=1
	mpb02 (net27 net51 net158 vdda) pmos1 l=180n w=1u m=1
	mppd1 (net158 xpd vdda vdda) pmos1 l=180n w=1u m=1
	mps11 (net31 net158 vdda vdda) pmos1 l=180n w=1u m=1
	mpd11 (net56 inn net31 net31) pmos1 l=180n w=1u m=1
	mp001 (out net158 vdda vdda) pmos1 l=1.1e-07n w=1.7e-06u m=1
	mpd12 (net13 inp net31 net31) pmos1 l=180n w=1u m=1
	mpb01 (net158 net158 vdda vdda) pmos1 l=180n w=1u m=1
ends OPAMP1_variant516

subckt OPAMP1_variant517 inn inp out pd xpd vdda vssa
	xd1 (vssa vdda) prim_nwd AREA=6.13907e-9 PJ=476.6e-6 m=1
	xi0 (vssa net69) prim_nd AREA=1e-12 PJ=4e-6 m=1
	xi3 (net51 vdda) prim_pd AREA=790e-15 PJ=3.3e-6 m=1
	xr0 (vssa vdda net51) prim_rdiffp l=1.5e-07 w=1.1e-06 m=1
	xr1 (vdda vdda net69) prim_rdiffp l=2.1e-6 w=700e-9 m=1
	xcc01 (net12 out) prim_cpoly c=2.0e-12p m=1
	mnm12 (net13 net56 vssa vssa) nmos1 l=180n w=1u m=1
	mnm11 (net56 net56 vssa vssa) nmos1 l=180n w=1u m=1
	mnb02 (net27 net27 net21 vssa) nmos1 l=180n w=1u m=1
	mnpd1 (net21 xpd vssa vssa) nmos1 l=180n w=1u m=1
	mn001 (out net13 vssa vssa) nmos1 l=180n w=1u m=1
	mnpd2 (net13 pd vssa vssa) nmos1 l=180n w=1u m=1
	mnc01 (net13 net69 net12 vssa) nmos1 l=1.4e-07n w=7.9e-07u m=1
	mpb02 (net27 net51 net158 vdda) pmos1 l=180n w=1u m=1
	mppd1 (net158 xpd vdda vdda) pmos1 l=180n w=1u m=1
	mps11 (net31 net158 vdda vdda) pmos1 l=180n w=1u m=1
	mpd11 (net56 inn net31 net31) pmos1 l=180n w=1u m=1
	mp001 (out net158 vdda vdda) pmos1 l=180n w=1u m=1
	mpd12 (net13 inp net31 net31) pmos1 l=180n w=1u m=1
	mpb01 (net158 net158 vdda vdda) pmos1 l=180n w=1u m=1
ends OPAMP1_variant517

subckt OPAMP1_variant518 inn inp out pd xpd vdda vssa
	xd1 (vssa vdda) prim_nwd AREA=6.13907e-9 PJ=476.6e-6 m=1
	xi0 (vssa net69) prim_nd AREA=1e-12 PJ=4e-6 m=1
	xi3 (net51 vdda) prim_pd AREA=790e-15 PJ=3.3e-6 m=1
	xr0 (vssa vdda net51) prim_rdiffp l=2.1e-6 w=700e-9 m=1
	xr1 (vdda vdda net69) prim_rdiffp l=2.1e-6 w=700e-9 m=1
	xcc01 (net12 out) prim_cpoly c=1p m=1
	mnm12 (net13 net56 vssa vssa) nmos1 l=180n w=1u m=1
	mnm11 (net56 net56 vssa vssa) nmos1 l=180n w=1u m=1
	mnb02 (net27 net27 net21 vssa) nmos1 l=180n w=1u m=1
	mnpd1 (net21 xpd vssa vssa) nmos1 l=180n w=1u m=1
	mn001 (out net13 vssa vssa) nmos1 l=180n w=1u m=1
	mnpd2 (net13 pd vssa vssa) nmos1 l=2.8e-07n w=1.9e-06u m=1
	mnc01 (net13 net69 net12 vssa) nmos1 l=180n w=1u m=1
	mpb02 (net27 net51 net158 vdda) pmos1 l=180n w=1u m=1
	mppd1 (net158 xpd vdda vdda) pmos1 l=2.2e-07n w=9.5e-07u m=1
	mps11 (net31 net158 vdda vdda) pmos1 l=180n w=1u m=1
	mpd11 (net56 inn net31 net31) pmos1 l=180n w=1u m=1
	mp001 (out net158 vdda vdda) pmos1 l=180n w=1u m=1
	mpd12 (net13 inp net31 net31) pmos1 l=180n w=1u m=1
	mpb01 (net158 net158 vdda vdda) pmos1 l=180n w=1u m=1
ends OPAMP1_variant518

subckt OPAMP1_variant519 inn inp out pd xpd vdda vssa
	xd1 (vssa vdda) prim_nwd AREA=6.13907e-9 PJ=476.6e-6 m=1
	xi0 (vssa net69) prim_nd AREA=1e-12 PJ=4e-6 m=1
	xi3 (net51 vdda) prim_pd AREA=790e-15 PJ=3.3e-6 m=1
	xr0 (vssa vdda net51) prim_rdiffp l=2.1e-6 w=700e-9 m=1
	xr1 (vdda vdda net69) prim_rdiffp l=2.1e-6 w=700e-9 m=1
	xcc01 (net12 out) prim_cpoly c=1p m=1
	mnm12 (net13 net56 vssa vssa) nmos1 l=2.3e-07n w=1.8e-06u m=1
	mnm11 (net56 net56 vssa vssa) nmos1 l=180n w=1u m=1
	mnb02 (net27 net27 net21 vssa) nmos1 l=1.7e-07n w=1.0e-06u m=1
	mnpd1 (net21 xpd vssa vssa) nmos1 l=180n w=1u m=1
	mn001 (out net13 vssa vssa) nmos1 l=180n w=1u m=1
	mnpd2 (net13 pd vssa vssa) nmos1 l=180n w=1u m=1
	mnc01 (net13 net69 net12 vssa) nmos1 l=180n w=1u m=1
	mpb02 (net27 net51 net158 vdda) pmos1 l=1.1e-07n w=1.5e-06u m=1
	mppd1 (net158 xpd vdda vdda) pmos1 l=180n w=1u m=1
	mps11 (net31 net158 vdda vdda) pmos1 l=180n w=1u m=1
	mpd11 (net56 inn net31 net31) pmos1 l=180n w=1u m=1
	mp001 (out net158 vdda vdda) pmos1 l=180n w=1u m=1
	mpd12 (net13 inp net31 net31) pmos1 l=3.0e-07n w=1.7e-06u m=1
	mpb01 (net158 net158 vdda vdda) pmos1 l=180n w=1u m=1
ends OPAMP1_variant519

subckt OPAMP1_variant520 inn inp out pd xpd vdda vssa
	xd1 (vssa vdda) prim_nwd AREA=6.13907e-9 PJ=476.6e-6 m=1
	xi0 (vssa net69) prim_nd AREA=1e-12 PJ=4e-6 m=1
	xi3 (net51 vdda) prim_pd AREA=790e-15 PJ=3.3e-6 m=1
	xr0 (vssa vdda net51) prim_rdiffp l=2.1e-6 w=700e-9 m=1
	xr1 (vdda vdda net69) prim_rdiffp l=2.1e-6 w=700e-9 m=1
	xcc01 (net12 out) prim_cpoly c=1p m=1
	mnm12 (net13 net56 vssa vssa) nmos1 l=180n w=1u m=1
	mnm11 (net56 net56 vssa vssa) nmos1 l=2.7e-07n w=1.3e-06u m=1
	mnb02 (net27 net27 net21 vssa) nmos1 l=180n w=1u m=1
	mnpd1 (net21 xpd vssa vssa) nmos1 l=180n w=1u m=1
	mn001 (out net13 vssa vssa) nmos1 l=180n w=1u m=1
	mnpd2 (net13 pd vssa vssa) nmos1 l=180n w=1u m=1
	mnc01 (net13 net69 net12 vssa) nmos1 l=3.0e-07n w=1.4e-06u m=1
	mpb02 (net27 net51 net158 vdda) pmos1 l=180n w=1u m=1
	mppd1 (net158 xpd vdda vdda) pmos1 l=180n w=1u m=1
	mps11 (net31 net158 vdda vdda) pmos1 l=180n w=1u m=1
	mpd11 (net56 inn net31 net31) pmos1 l=180n w=1u m=1
	mp001 (out net158 vdda vdda) pmos1 l=180n w=1u m=1
	mpd12 (net13 inp net31 net31) pmos1 l=180n w=1u m=1
	mpb01 (net158 net158 vdda vdda) pmos1 l=180n w=1u m=1
ends OPAMP1_variant520

subckt OPAMP1_variant521 inn inp out pd xpd vdda vssa
	xd1 (vssa vdda) prim_nwd AREA=6.13907e-9 PJ=476.6e-6 m=1
	xi0 (vssa net69) prim_nd AREA=1e-12 PJ=4e-6 m=1
	xi3 (net51 vdda) prim_pd AREA=790e-15 PJ=3.3e-6 m=1
	xr0 (vssa vdda net51) prim_rdiffp l=2.1e-6 w=700e-9 m=1
	xr1 (vdda vdda net69) prim_rdiffp l=2.1e-6 w=700e-9 m=1
	xcc01 (net12 out) prim_cpoly c=6.7e-13p m=1
	mnm12 (net13 net56 vssa vssa) nmos1 l=1.4e-07n w=1.4e-06u m=1
	mnm11 (net56 net56 vssa vssa) nmos1 l=180n w=1u m=1
	mnb02 (net27 net27 net21 vssa) nmos1 l=180n w=1u m=1
	mnpd1 (net21 xpd vssa vssa) nmos1 l=180n w=1u m=1
	mn001 (out net13 vssa vssa) nmos1 l=180n w=1u m=1
	mnpd2 (net13 pd vssa vssa) nmos1 l=180n w=1u m=1
	mnc01 (net13 net69 net12 vssa) nmos1 l=180n w=1u m=1
	mpb02 (net27 net51 net158 vdda) pmos1 l=180n w=1u m=1
	mppd1 (net158 xpd vdda vdda) pmos1 l=180n w=1u m=1
	mps11 (net31 net158 vdda vdda) pmos1 l=180n w=1u m=1
	mpd11 (net56 inn net31 net31) pmos1 l=180n w=1u m=1
	mp001 (out net158 vdda vdda) pmos1 l=180n w=1u m=1
	mpd12 (net13 inp net31 net31) pmos1 l=180n w=1u m=1
	mpb01 (net158 net158 vdda vdda) pmos1 l=1.5e-07n w=9.1e-07u m=1
ends OPAMP1_variant521

subckt OPAMP1_variant522 inn inp out pd xpd vdda vssa
	xd1 (vssa vdda) prim_nwd AREA=6.13907e-9 PJ=476.6e-6 m=1
	xi0 (vssa net69) prim_nd AREA=1e-12 PJ=4e-6 m=1
	xi3 (net51 vdda) prim_pd AREA=790e-15 PJ=3.3e-6 m=1
	xr0 (vssa vdda net51) prim_rdiffp l=2.1e-6 w=700e-9 m=1
	xr1 (vdda vdda net69) prim_rdiffp l=1.1e-07 w=1.3e-06 m=1
	xcc01 (net12 out) prim_cpoly c=1.3e-12p m=1
	mnm12 (net13 net56 vssa vssa) nmos1 l=180n w=1u m=1
	mnm11 (net56 net56 vssa vssa) nmos1 l=180n w=1u m=1
	mnb02 (net27 net27 net21 vssa) nmos1 l=180n w=1u m=1
	mnpd1 (net21 xpd vssa vssa) nmos1 l=180n w=1u m=1
	mn001 (out net13 vssa vssa) nmos1 l=180n w=1u m=1
	mnpd2 (net13 pd vssa vssa) nmos1 l=180n w=1u m=1
	mnc01 (net13 net69 net12 vssa) nmos1 l=180n w=1u m=1
	mpb02 (net27 net51 net158 vdda) pmos1 l=180n w=1u m=1
	mppd1 (net158 xpd vdda vdda) pmos1 l=180n w=1u m=1
	mps11 (net31 net158 vdda vdda) pmos1 l=180n w=1u m=1
	mpd11 (net56 inn net31 net31) pmos1 l=180n w=1u m=1
	mp001 (out net158 vdda vdda) pmos1 l=180n w=1u m=1
	mpd12 (net13 inp net31 net31) pmos1 l=1.1e-07n w=7.5e-07u m=1
	mpb01 (net158 net158 vdda vdda) pmos1 l=180n w=1u m=1
ends OPAMP1_variant522

subckt OPAMP1_variant523 inn inp out pd xpd vdda vssa
	xd1 (vssa vdda) prim_nwd AREA=6.13907e-9 PJ=476.6e-6 m=1
	xi0 (vssa net69) prim_nd AREA=1e-12 PJ=4e-6 m=1
	xi3 (net51 vdda) prim_pd AREA=7.0e-09 PJ=5.1e-05 m=1
	xr0 (vssa vdda net51) prim_rdiffp l=2.1e-6 w=700e-9 m=1
	xr1 (vdda vdda net69) prim_rdiffp l=2.1e-6 w=700e-9 m=1
	xcc01 (net12 out) prim_cpoly c=1p m=1
	mnm12 (net13 net56 vssa vssa) nmos1 l=180n w=1u m=1
	mnm11 (net56 net56 vssa vssa) nmos1 l=2.5e-07n w=7.2e-07u m=1
	mnb02 (net27 net27 net21 vssa) nmos1 l=180n w=1u m=1
	mnpd1 (net21 xpd vssa vssa) nmos1 l=180n w=1u m=1
	mn001 (out net13 vssa vssa) nmos1 l=180n w=1u m=1
	mnpd2 (net13 pd vssa vssa) nmos1 l=180n w=1u m=1
	mnc01 (net13 net69 net12 vssa) nmos1 l=1.7e-07n w=1.2e-06u m=1
	mpb02 (net27 net51 net158 vdda) pmos1 l=180n w=1u m=1
	mppd1 (net158 xpd vdda vdda) pmos1 l=180n w=1u m=1
	mps11 (net31 net158 vdda vdda) pmos1 l=180n w=1u m=1
	mpd11 (net56 inn net31 net31) pmos1 l=180n w=1u m=1
	mp001 (out net158 vdda vdda) pmos1 l=180n w=1u m=1
	mpd12 (net13 inp net31 net31) pmos1 l=180n w=1u m=1
	mpb01 (net158 net158 vdda vdda) pmos1 l=180n w=1u m=1
ends OPAMP1_variant523

subckt OPAMP1_variant524 inn inp out pd xpd vdda vssa
	xd1 (vssa vdda) prim_nwd AREA=6.13907e-9 PJ=476.6e-6 m=1
	xi0 (vssa net69) prim_nd AREA=1e-12 PJ=4e-6 m=1
	xi3 (net51 vdda) prim_pd AREA=790e-15 PJ=3.3e-6 m=1
	xr0 (vssa vdda net51) prim_rdiffp l=2.1e-6 w=700e-9 m=1
	xr1 (vdda vdda net69) prim_rdiffp l=2.1e-6 w=700e-9 m=1
	xcc01 (net12 out) prim_cpoly c=1p m=1
	mnm12 (net13 net56 vssa vssa) nmos1 l=180n w=1u m=1
	mnm11 (net56 net56 vssa vssa) nmos1 l=2.3e-07n w=9.1e-07u m=1
	mnb02 (net27 net27 net21 vssa) nmos1 l=1.5e-07n w=1.0e-06u m=1
	mnpd1 (net21 xpd vssa vssa) nmos1 l=180n w=1u m=1
	mn001 (out net13 vssa vssa) nmos1 l=180n w=1u m=1
	mnpd2 (net13 pd vssa vssa) nmos1 l=180n w=1u m=1
	mnc01 (net13 net69 net12 vssa) nmos1 l=180n w=1u m=1
	mpb02 (net27 net51 net158 vdda) pmos1 l=1.2e-07n w=1.6e-06u m=1
	mppd1 (net158 xpd vdda vdda) pmos1 l=180n w=1u m=1
	mps11 (net31 net158 vdda vdda) pmos1 l=2.9e-07n w=1.8e-06u m=1
	mpd11 (net56 inn net31 net31) pmos1 l=2.3e-07n w=1.9e-06u m=1
	mp001 (out net158 vdda vdda) pmos1 l=180n w=1u m=1
	mpd12 (net13 inp net31 net31) pmos1 l=180n w=1u m=1
	mpb01 (net158 net158 vdda vdda) pmos1 l=180n w=1u m=1
ends OPAMP1_variant524

subckt OPAMP1_variant525 inn inp out pd xpd vdda vssa
	xd1 (vssa vdda) prim_nwd AREA=6.13907e-9 PJ=476.6e-6 m=1
	xi0 (vssa net69) prim_nd AREA=1e-12 PJ=4e-6 m=1
	xi3 (net51 vdda) prim_pd AREA=790e-15 PJ=3.3e-6 m=1
	xr0 (vssa vdda net51) prim_rdiffp l=2.1e-6 w=700e-9 m=1
	xr1 (vdda vdda net69) prim_rdiffp l=2.1e-6 w=700e-9 m=1
	xcc01 (net12 out) prim_cpoly c=1p m=1
	mnm12 (net13 net56 vssa vssa) nmos1 l=180n w=1u m=1
	mnm11 (net56 net56 vssa vssa) nmos1 l=1.6e-07n w=9.7e-07u m=1
	mnb02 (net27 net27 net21 vssa) nmos1 l=180n w=1u m=1
	mnpd1 (net21 xpd vssa vssa) nmos1 l=1.9e-07n w=7.8e-07u m=1
	mn001 (out net13 vssa vssa) nmos1 l=180n w=1u m=1
	mnpd2 (net13 pd vssa vssa) nmos1 l=180n w=1u m=1
	mnc01 (net13 net69 net12 vssa) nmos1 l=180n w=1u m=1
	mpb02 (net27 net51 net158 vdda) pmos1 l=2.8e-07n w=1.6e-06u m=1
	mppd1 (net158 xpd vdda vdda) pmos1 l=180n w=1u m=1
	mps11 (net31 net158 vdda vdda) pmos1 l=180n w=1u m=1
	mpd11 (net56 inn net31 net31) pmos1 l=180n w=1u m=1
	mp001 (out net158 vdda vdda) pmos1 l=2.9e-07n w=1.2e-06u m=1
	mpd12 (net13 inp net31 net31) pmos1 l=1.7e-07n w=7.1e-07u m=1
	mpb01 (net158 net158 vdda vdda) pmos1 l=180n w=1u m=1
ends OPAMP1_variant525

subckt OPAMP1_variant526 inn inp out pd xpd vdda vssa
	xd1 (vssa vdda) prim_nwd AREA=6.13907e-9 PJ=476.6e-6 m=1
	xi0 (vssa net69) prim_nd AREA=1e-12 PJ=4e-6 m=1
	xi3 (net51 vdda) prim_pd AREA=790e-15 PJ=3.3e-6 m=1
	xr0 (vssa vdda net51) prim_rdiffp l=2.1e-6 w=700e-9 m=1
	xr1 (vdda vdda net69) prim_rdiffp l=2.1e-6 w=700e-9 m=1
	xcc01 (net12 out) prim_cpoly c=1.6e-12p m=1
	mnm12 (net13 net56 vssa vssa) nmos1 l=180n w=1u m=1
	mnm11 (net56 net56 vssa vssa) nmos1 l=180n w=1u m=1
	mnb02 (net27 net27 net21 vssa) nmos1 l=2.4e-07n w=1.8e-06u m=1
	mnpd1 (net21 xpd vssa vssa) nmos1 l=2.7e-07n w=1.6e-06u m=1
	mn001 (out net13 vssa vssa) nmos1 l=180n w=1u m=1
	mnpd2 (net13 pd vssa vssa) nmos1 l=180n w=1u m=1
	mnc01 (net13 net69 net12 vssa) nmos1 l=180n w=1u m=1
	mpb02 (net27 net51 net158 vdda) pmos1 l=180n w=1u m=1
	mppd1 (net158 xpd vdda vdda) pmos1 l=180n w=1u m=1
	mps11 (net31 net158 vdda vdda) pmos1 l=180n w=1u m=1
	mpd11 (net56 inn net31 net31) pmos1 l=1.0e-07n w=1.3e-06u m=1
	mp001 (out net158 vdda vdda) pmos1 l=180n w=1u m=1
	mpd12 (net13 inp net31 net31) pmos1 l=180n w=1u m=1
	mpb01 (net158 net158 vdda vdda) pmos1 l=180n w=1u m=1
ends OPAMP1_variant526

subckt OPAMP1_variant527 inn inp out pd xpd vdda vssa
	xd1 (vssa vdda) prim_nwd AREA=6.13907e-9 PJ=476.6e-6 m=1
	xi0 (vssa net69) prim_nd AREA=1e-12 PJ=4e-6 m=1
	xi3 (net51 vdda) prim_pd AREA=790e-15 PJ=3.3e-6 m=1
	xr0 (vssa vdda net51) prim_rdiffp l=2.1e-6 w=700e-9 m=1
	xr1 (vdda vdda net69) prim_rdiffp l=2.1e-6 w=700e-9 m=1
	xcc01 (net12 out) prim_cpoly c=1p m=1
	mnm12 (net13 net56 vssa vssa) nmos1 l=180n w=1u m=1
	mnm11 (net56 net56 vssa vssa) nmos1 l=180n w=1u m=1
	mnb02 (net27 net27 net21 vssa) nmos1 l=180n w=1u m=1
	mnpd1 (net21 xpd vssa vssa) nmos1 l=180n w=1u m=1
	mn001 (out net13 vssa vssa) nmos1 l=180n w=1u m=1
	mnpd2 (net13 pd vssa vssa) nmos1 l=180n w=1u m=1
	mnc01 (net13 net69 net12 vssa) nmos1 l=180n w=1u m=1
	mpb02 (net27 net51 net158 vdda) pmos1 l=2.1e-07n w=1.2e-06u m=1
	mppd1 (net158 xpd vdda vdda) pmos1 l=1.1e-07n w=1.6e-06u m=1
	mps11 (net31 net158 vdda vdda) pmos1 l=180n w=1u m=1
	mpd11 (net56 inn net31 net31) pmos1 l=180n w=1u m=1
	mp001 (out net158 vdda vdda) pmos1 l=1.7e-07n w=1.8e-06u m=1
	mpd12 (net13 inp net31 net31) pmos1 l=180n w=1u m=1
	mpb01 (net158 net158 vdda vdda) pmos1 l=2.9e-07n w=8.8e-07u m=1
ends OPAMP1_variant527

subckt OPAMP1_variant528 inn inp out pd xpd vdda vssa
	xd1 (vssa vdda) prim_nwd AREA=6.13907e-9 PJ=476.6e-6 m=1
	xi0 (vssa net69) prim_nd AREA=1e-12 PJ=4e-6 m=1
	xi3 (net51 vdda) prim_pd AREA=790e-15 PJ=3.3e-6 m=1
	xr0 (vssa vdda net51) prim_rdiffp l=2.1e-6 w=700e-9 m=1
	xr1 (vdda vdda net69) prim_rdiffp l=2.1e-6 w=700e-9 m=1
	xcc01 (net12 out) prim_cpoly c=1p m=1
	mnm12 (net13 net56 vssa vssa) nmos1 l=180n w=1u m=1
	mnm11 (net56 net56 vssa vssa) nmos1 l=180n w=1u m=1
	mnb02 (net27 net27 net21 vssa) nmos1 l=180n w=1u m=1
	mnpd1 (net21 xpd vssa vssa) nmos1 l=180n w=1u m=1
	mn001 (out net13 vssa vssa) nmos1 l=180n w=1u m=1
	mnpd2 (net13 pd vssa vssa) nmos1 l=2.0e-07n w=1.3e-06u m=1
	mnc01 (net13 net69 net12 vssa) nmos1 l=180n w=1u m=1
	mpb02 (net27 net51 net158 vdda) pmos1 l=3.0e-07n w=5.3e-07u m=1
	mppd1 (net158 xpd vdda vdda) pmos1 l=180n w=1u m=1
	mps11 (net31 net158 vdda vdda) pmos1 l=180n w=1u m=1
	mpd11 (net56 inn net31 net31) pmos1 l=180n w=1u m=1
	mp001 (out net158 vdda vdda) pmos1 l=2.1e-07n w=8.7e-07u m=1
	mpd12 (net13 inp net31 net31) pmos1 l=180n w=1u m=1
	mpb01 (net158 net158 vdda vdda) pmos1 l=1.7e-07n w=1.2e-06u m=1
ends OPAMP1_variant528

subckt OPAMP1_variant529 inn inp out pd xpd vdda vssa
	xd1 (vssa vdda) prim_nwd AREA=1.1e-09 PJ=7.0e-05 m=1
	xi0 (vssa net69) prim_nd AREA=1e-12 PJ=4e-6 m=1
	xi3 (net51 vdda) prim_pd AREA=790e-15 PJ=3.3e-6 m=1
	xr0 (vssa vdda net51) prim_rdiffp l=2.1e-6 w=700e-9 m=1
	xr1 (vdda vdda net69) prim_rdiffp l=2.1e-6 w=700e-9 m=1
	xcc01 (net12 out) prim_cpoly c=1p m=1
	mnm12 (net13 net56 vssa vssa) nmos1 l=1.5e-07n w=1.6e-06u m=1
	mnm11 (net56 net56 vssa vssa) nmos1 l=180n w=1u m=1
	mnb02 (net27 net27 net21 vssa) nmos1 l=180n w=1u m=1
	mnpd1 (net21 xpd vssa vssa) nmos1 l=180n w=1u m=1
	mn001 (out net13 vssa vssa) nmos1 l=2.7e-07n w=1.6e-06u m=1
	mnpd2 (net13 pd vssa vssa) nmos1 l=180n w=1u m=1
	mnc01 (net13 net69 net12 vssa) nmos1 l=2.3e-07n w=5.2e-07u m=1
	mpb02 (net27 net51 net158 vdda) pmos1 l=180n w=1u m=1
	mppd1 (net158 xpd vdda vdda) pmos1 l=180n w=1u m=1
	mps11 (net31 net158 vdda vdda) pmos1 l=1.4e-07n w=1.4e-06u m=1
	mpd11 (net56 inn net31 net31) pmos1 l=180n w=1u m=1
	mp001 (out net158 vdda vdda) pmos1 l=180n w=1u m=1
	mpd12 (net13 inp net31 net31) pmos1 l=180n w=1u m=1
	mpb01 (net158 net158 vdda vdda) pmos1 l=180n w=1u m=1
ends OPAMP1_variant529

subckt OPAMP1_variant530 inn inp out pd xpd vdda vssa
	xd1 (vssa vdda) prim_nwd AREA=6.13907e-9 PJ=476.6e-6 m=1
	xi0 (vssa net69) prim_nd AREA=1e-12 PJ=4e-6 m=1
	xi3 (net51 vdda) prim_pd AREA=1.6e-09 PJ=8.5e-05 m=1
	xr0 (vssa vdda net51) prim_rdiffp l=2.8e-07 w=1.4e-06 m=1
	xr1 (vdda vdda net69) prim_rdiffp l=2.1e-6 w=700e-9 m=1
	xcc01 (net12 out) prim_cpoly c=1p m=1
	mnm12 (net13 net56 vssa vssa) nmos1 l=180n w=1u m=1
	mnm11 (net56 net56 vssa vssa) nmos1 l=180n w=1u m=1
	mnb02 (net27 net27 net21 vssa) nmos1 l=180n w=1u m=1
	mnpd1 (net21 xpd vssa vssa) nmos1 l=180n w=1u m=1
	mn001 (out net13 vssa vssa) nmos1 l=180n w=1u m=1
	mnpd2 (net13 pd vssa vssa) nmos1 l=180n w=1u m=1
	mnc01 (net13 net69 net12 vssa) nmos1 l=180n w=1u m=1
	mpb02 (net27 net51 net158 vdda) pmos1 l=2.7e-07n w=1.1e-06u m=1
	mppd1 (net158 xpd vdda vdda) pmos1 l=2.6e-07n w=7.5e-07u m=1
	mps11 (net31 net158 vdda vdda) pmos1 l=180n w=1u m=1
	mpd11 (net56 inn net31 net31) pmos1 l=180n w=1u m=1
	mp001 (out net158 vdda vdda) pmos1 l=180n w=1u m=1
	mpd12 (net13 inp net31 net31) pmos1 l=1.4e-07n w=1.9e-06u m=1
	mpb01 (net158 net158 vdda vdda) pmos1 l=180n w=1u m=1
ends OPAMP1_variant530

subckt OPAMP1_variant531 inn inp out pd xpd vdda vssa
	xd1 (vssa vdda) prim_nwd AREA=6.13907e-9 PJ=476.6e-6 m=1
	xi0 (vssa net69) prim_nd AREA=1e-12 PJ=4e-6 m=1
	xi3 (net51 vdda) prim_pd AREA=790e-15 PJ=3.3e-6 m=1
	xr0 (vssa vdda net51) prim_rdiffp l=2.1e-6 w=700e-9 m=1
	xr1 (vdda vdda net69) prim_rdiffp l=2.1e-6 w=700e-9 m=1
	xcc01 (net12 out) prim_cpoly c=1.5e-12p m=1
	mnm12 (net13 net56 vssa vssa) nmos1 l=1.9e-07n w=1.9e-06u m=1
	mnm11 (net56 net56 vssa vssa) nmos1 l=180n w=1u m=1
	mnb02 (net27 net27 net21 vssa) nmos1 l=1.6e-07n w=1.2e-06u m=1
	mnpd1 (net21 xpd vssa vssa) nmos1 l=180n w=1u m=1
	mn001 (out net13 vssa vssa) nmos1 l=180n w=1u m=1
	mnpd2 (net13 pd vssa vssa) nmos1 l=180n w=1u m=1
	mnc01 (net13 net69 net12 vssa) nmos1 l=180n w=1u m=1
	mpb02 (net27 net51 net158 vdda) pmos1 l=1.5e-07n w=6.9e-07u m=1
	mppd1 (net158 xpd vdda vdda) pmos1 l=180n w=1u m=1
	mps11 (net31 net158 vdda vdda) pmos1 l=180n w=1u m=1
	mpd11 (net56 inn net31 net31) pmos1 l=2.0e-07n w=1.1e-06u m=1
	mp001 (out net158 vdda vdda) pmos1 l=180n w=1u m=1
	mpd12 (net13 inp net31 net31) pmos1 l=180n w=1u m=1
	mpb01 (net158 net158 vdda vdda) pmos1 l=180n w=1u m=1
ends OPAMP1_variant531

subckt OPAMP1_variant532 inn inp out pd xpd vdda vssa
	xd1 (vssa vdda) prim_nwd AREA=3.2e-09 PJ=7.2e-06 m=1
	xi0 (vssa net69) prim_nd AREA=1e-12 PJ=4e-6 m=1
	xi3 (net51 vdda) prim_pd AREA=3.7e-09 PJ=6.4e-05 m=1
	xr0 (vssa vdda net51) prim_rdiffp l=2.1e-6 w=700e-9 m=1
	xr1 (vdda vdda net69) prim_rdiffp l=2.1e-6 w=700e-9 m=1
	xcc01 (net12 out) prim_cpoly c=1p m=1
	mnm12 (net13 net56 vssa vssa) nmos1 l=180n w=1u m=1
	mnm11 (net56 net56 vssa vssa) nmos1 l=180n w=1u m=1
	mnb02 (net27 net27 net21 vssa) nmos1 l=180n w=1u m=1
	mnpd1 (net21 xpd vssa vssa) nmos1 l=180n w=1u m=1
	mn001 (out net13 vssa vssa) nmos1 l=180n w=1u m=1
	mnpd2 (net13 pd vssa vssa) nmos1 l=180n w=1u m=1
	mnc01 (net13 net69 net12 vssa) nmos1 l=180n w=1u m=1
	mpb02 (net27 net51 net158 vdda) pmos1 l=180n w=1u m=1
	mppd1 (net158 xpd vdda vdda) pmos1 l=180n w=1u m=1
	mps11 (net31 net158 vdda vdda) pmos1 l=180n w=1u m=1
	mpd11 (net56 inn net31 net31) pmos1 l=180n w=1u m=1
	mp001 (out net158 vdda vdda) pmos1 l=180n w=1u m=1
	mpd12 (net13 inp net31 net31) pmos1 l=180n w=1u m=1
	mpb01 (net158 net158 vdda vdda) pmos1 l=1.6e-07n w=8.8e-07u m=1
ends OPAMP1_variant532

subckt OPAMP1_variant533 inn inp out pd xpd vdda vssa
	xd1 (vssa vdda) prim_nwd AREA=6.13907e-9 PJ=476.6e-6 m=1
	xi0 (vssa net69) prim_nd AREA=8.6e-09 PJ=6.2e-05 m=1
	xi3 (net51 vdda) prim_pd AREA=3.7e-09 PJ=2.2e-05 m=1
	xr0 (vssa vdda net51) prim_rdiffp l=2.1e-6 w=700e-9 m=1
	xr1 (vdda vdda net69) prim_rdiffp l=2.1e-6 w=700e-9 m=1
	xcc01 (net12 out) prim_cpoly c=1p m=1
	mnm12 (net13 net56 vssa vssa) nmos1 l=180n w=1u m=1
	mnm11 (net56 net56 vssa vssa) nmos1 l=180n w=1u m=1
	mnb02 (net27 net27 net21 vssa) nmos1 l=180n w=1u m=1
	mnpd1 (net21 xpd vssa vssa) nmos1 l=180n w=1u m=1
	mn001 (out net13 vssa vssa) nmos1 l=180n w=1u m=1
	mnpd2 (net13 pd vssa vssa) nmos1 l=180n w=1u m=1
	mnc01 (net13 net69 net12 vssa) nmos1 l=180n w=1u m=1
	mpb02 (net27 net51 net158 vdda) pmos1 l=180n w=1u m=1
	mppd1 (net158 xpd vdda vdda) pmos1 l=180n w=1u m=1
	mps11 (net31 net158 vdda vdda) pmos1 l=180n w=1u m=1
	mpd11 (net56 inn net31 net31) pmos1 l=2.5e-07n w=1.0e-06u m=1
	mp001 (out net158 vdda vdda) pmos1 l=180n w=1u m=1
	mpd12 (net13 inp net31 net31) pmos1 l=2.2e-07n w=1.7e-06u m=1
	mpb01 (net158 net158 vdda vdda) pmos1 l=1.8e-07n w=1.5e-06u m=1
ends OPAMP1_variant533

subckt OPAMP1_variant534 inn inp out pd xpd vdda vssa
	xd1 (vssa vdda) prim_nwd AREA=6.13907e-9 PJ=476.6e-6 m=1
	xi0 (vssa net69) prim_nd AREA=7.8e-09 PJ=6.9e-06 m=1
	xi3 (net51 vdda) prim_pd AREA=790e-15 PJ=3.3e-6 m=1
	xr0 (vssa vdda net51) prim_rdiffp l=2.1e-6 w=700e-9 m=1
	xr1 (vdda vdda net69) prim_rdiffp l=2.1e-6 w=700e-9 m=1
	xcc01 (net12 out) prim_cpoly c=1p m=1
	mnm12 (net13 net56 vssa vssa) nmos1 l=180n w=1u m=1
	mnm11 (net56 net56 vssa vssa) nmos1 l=180n w=1u m=1
	mnb02 (net27 net27 net21 vssa) nmos1 l=180n w=1u m=1
	mnpd1 (net21 xpd vssa vssa) nmos1 l=2.6e-07n w=1.6e-06u m=1
	mn001 (out net13 vssa vssa) nmos1 l=1.6e-07n w=5.1e-07u m=1
	mnpd2 (net13 pd vssa vssa) nmos1 l=2.8e-07n w=1.4e-06u m=1
	mnc01 (net13 net69 net12 vssa) nmos1 l=180n w=1u m=1
	mpb02 (net27 net51 net158 vdda) pmos1 l=180n w=1u m=1
	mppd1 (net158 xpd vdda vdda) pmos1 l=180n w=1u m=1
	mps11 (net31 net158 vdda vdda) pmos1 l=1.5e-07n w=1.8e-06u m=1
	mpd11 (net56 inn net31 net31) pmos1 l=180n w=1u m=1
	mp001 (out net158 vdda vdda) pmos1 l=180n w=1u m=1
	mpd12 (net13 inp net31 net31) pmos1 l=180n w=1u m=1
	mpb01 (net158 net158 vdda vdda) pmos1 l=180n w=1u m=1
ends OPAMP1_variant534

subckt OPAMP1_variant535 inn inp out pd xpd vdda vssa
	xd1 (vssa vdda) prim_nwd AREA=6.13907e-9 PJ=476.6e-6 m=1
	xi0 (vssa net69) prim_nd AREA=1e-12 PJ=4e-6 m=1
	xi3 (net51 vdda) prim_pd AREA=790e-15 PJ=3.3e-6 m=1
	xr0 (vssa vdda net51) prim_rdiffp l=2.1e-6 w=700e-9 m=1
	xr1 (vdda vdda net69) prim_rdiffp l=2.1e-6 w=700e-9 m=1
	xcc01 (net12 out) prim_cpoly c=1p m=1
	mnm12 (net13 net56 vssa vssa) nmos1 l=180n w=1u m=1
	mnm11 (net56 net56 vssa vssa) nmos1 l=180n w=1u m=1
	mnb02 (net27 net27 net21 vssa) nmos1 l=180n w=1u m=1
	mnpd1 (net21 xpd vssa vssa) nmos1 l=2.5e-07n w=8.3e-07u m=1
	mn001 (out net13 vssa vssa) nmos1 l=1.7e-07n w=1.6e-06u m=1
	mnpd2 (net13 pd vssa vssa) nmos1 l=180n w=1u m=1
	mnc01 (net13 net69 net12 vssa) nmos1 l=180n w=1u m=1
	mpb02 (net27 net51 net158 vdda) pmos1 l=180n w=1u m=1
	mppd1 (net158 xpd vdda vdda) pmos1 l=180n w=1u m=1
	mps11 (net31 net158 vdda vdda) pmos1 l=180n w=1u m=1
	mpd11 (net56 inn net31 net31) pmos1 l=2.3e-07n w=1.8e-06u m=1
	mp001 (out net158 vdda vdda) pmos1 l=180n w=1u m=1
	mpd12 (net13 inp net31 net31) pmos1 l=180n w=1u m=1
	mpb01 (net158 net158 vdda vdda) pmos1 l=180n w=1u m=1
ends OPAMP1_variant535

subckt OPAMP1_variant536 inn inp out pd xpd vdda vssa
	xd1 (vssa vdda) prim_nwd AREA=6.13907e-9 PJ=476.6e-6 m=1
	xi0 (vssa net69) prim_nd AREA=1e-12 PJ=4e-6 m=1
	xi3 (net51 vdda) prim_pd AREA=790e-15 PJ=3.3e-6 m=1
	xr0 (vssa vdda net51) prim_rdiffp l=2.1e-6 w=700e-9 m=1
	xr1 (vdda vdda net69) prim_rdiffp l=2.1e-6 w=700e-9 m=1
	xcc01 (net12 out) prim_cpoly c=1p m=1
	mnm12 (net13 net56 vssa vssa) nmos1 l=2.3e-07n w=5.6e-07u m=1
	mnm11 (net56 net56 vssa vssa) nmos1 l=1.4e-07n w=1.3e-06u m=1
	mnb02 (net27 net27 net21 vssa) nmos1 l=2.7e-07n w=7.7e-07u m=1
	mnpd1 (net21 xpd vssa vssa) nmos1 l=180n w=1u m=1
	mn001 (out net13 vssa vssa) nmos1 l=180n w=1u m=1
	mnpd2 (net13 pd vssa vssa) nmos1 l=180n w=1u m=1
	mnc01 (net13 net69 net12 vssa) nmos1 l=1.7e-07n w=1.3e-06u m=1
	mpb02 (net27 net51 net158 vdda) pmos1 l=180n w=1u m=1
	mppd1 (net158 xpd vdda vdda) pmos1 l=180n w=1u m=1
	mps11 (net31 net158 vdda vdda) pmos1 l=180n w=1u m=1
	mpd11 (net56 inn net31 net31) pmos1 l=180n w=1u m=1
	mp001 (out net158 vdda vdda) pmos1 l=180n w=1u m=1
	mpd12 (net13 inp net31 net31) pmos1 l=180n w=1u m=1
	mpb01 (net158 net158 vdda vdda) pmos1 l=180n w=1u m=1
ends OPAMP1_variant536

subckt OPAMP1_variant537 inn inp out pd xpd vdda vssa
	xd1 (vssa vdda) prim_nwd AREA=6.13907e-9 PJ=476.6e-6 m=1
	xi0 (vssa net69) prim_nd AREA=1e-12 PJ=4e-6 m=1
	xi3 (net51 vdda) prim_pd AREA=790e-15 PJ=3.3e-6 m=1
	xr0 (vssa vdda net51) prim_rdiffp l=2.1e-6 w=700e-9 m=1
	xr1 (vdda vdda net69) prim_rdiffp l=2.1e-6 w=700e-9 m=1
	xcc01 (net12 out) prim_cpoly c=1.5e-12p m=1
	mnm12 (net13 net56 vssa vssa) nmos1 l=180n w=1u m=1
	mnm11 (net56 net56 vssa vssa) nmos1 l=180n w=1u m=1
	mnb02 (net27 net27 net21 vssa) nmos1 l=180n w=1u m=1
	mnpd1 (net21 xpd vssa vssa) nmos1 l=2.3e-07n w=1.4e-06u m=1
	mn001 (out net13 vssa vssa) nmos1 l=180n w=1u m=1
	mnpd2 (net13 pd vssa vssa) nmos1 l=180n w=1u m=1
	mnc01 (net13 net69 net12 vssa) nmos1 l=1.3e-07n w=1.7e-06u m=1
	mpb02 (net27 net51 net158 vdda) pmos1 l=180n w=1u m=1
	mppd1 (net158 xpd vdda vdda) pmos1 l=180n w=1u m=1
	mps11 (net31 net158 vdda vdda) pmos1 l=180n w=1u m=1
	mpd11 (net56 inn net31 net31) pmos1 l=180n w=1u m=1
	mp001 (out net158 vdda vdda) pmos1 l=180n w=1u m=1
	mpd12 (net13 inp net31 net31) pmos1 l=1.9e-07n w=1.7e-06u m=1
	mpb01 (net158 net158 vdda vdda) pmos1 l=180n w=1u m=1
ends OPAMP1_variant537

subckt OPAMP1_variant538 inn inp out pd xpd vdda vssa
	xd1 (vssa vdda) prim_nwd AREA=6.13907e-9 PJ=476.6e-6 m=1
	xi0 (vssa net69) prim_nd AREA=1e-12 PJ=4e-6 m=1
	xi3 (net51 vdda) prim_pd AREA=790e-15 PJ=3.3e-6 m=1
	xr0 (vssa vdda net51) prim_rdiffp l=2.1e-6 w=700e-9 m=1
	xr1 (vdda vdda net69) prim_rdiffp l=2.1e-6 w=700e-9 m=1
	xcc01 (net12 out) prim_cpoly c=1p m=1
	mnm12 (net13 net56 vssa vssa) nmos1 l=180n w=1u m=1
	mnm11 (net56 net56 vssa vssa) nmos1 l=180n w=1u m=1
	mnb02 (net27 net27 net21 vssa) nmos1 l=180n w=1u m=1
	mnpd1 (net21 xpd vssa vssa) nmos1 l=2.4e-07n w=1.9e-06u m=1
	mn001 (out net13 vssa vssa) nmos1 l=180n w=1u m=1
	mnpd2 (net13 pd vssa vssa) nmos1 l=180n w=1u m=1
	mnc01 (net13 net69 net12 vssa) nmos1 l=180n w=1u m=1
	mpb02 (net27 net51 net158 vdda) pmos1 l=2.0e-07n w=1.4e-06u m=1
	mppd1 (net158 xpd vdda vdda) pmos1 l=180n w=1u m=1
	mps11 (net31 net158 vdda vdda) pmos1 l=180n w=1u m=1
	mpd11 (net56 inn net31 net31) pmos1 l=180n w=1u m=1
	mp001 (out net158 vdda vdda) pmos1 l=180n w=1u m=1
	mpd12 (net13 inp net31 net31) pmos1 l=180n w=1u m=1
	mpb01 (net158 net158 vdda vdda) pmos1 l=180n w=1u m=1
ends OPAMP1_variant538

subckt OPAMP1_variant539 inn inp out pd xpd vdda vssa
	xd1 (vssa vdda) prim_nwd AREA=6.13907e-9 PJ=476.6e-6 m=1
	xi0 (vssa net69) prim_nd AREA=4.3e-09 PJ=5.9e-05 m=1
	xi3 (net51 vdda) prim_pd AREA=790e-15 PJ=3.3e-6 m=1
	xr0 (vssa vdda net51) prim_rdiffp l=2.1e-6 w=700e-9 m=1
	xr1 (vdda vdda net69) prim_rdiffp l=2.1e-6 w=700e-9 m=1
	xcc01 (net12 out) prim_cpoly c=1p m=1
	mnm12 (net13 net56 vssa vssa) nmos1 l=180n w=1u m=1
	mnm11 (net56 net56 vssa vssa) nmos1 l=180n w=1u m=1
	mnb02 (net27 net27 net21 vssa) nmos1 l=2.6e-07n w=1.3e-06u m=1
	mnpd1 (net21 xpd vssa vssa) nmos1 l=180n w=1u m=1
	mn001 (out net13 vssa vssa) nmos1 l=180n w=1u m=1
	mnpd2 (net13 pd vssa vssa) nmos1 l=2.4e-07n w=7.9e-07u m=1
	mnc01 (net13 net69 net12 vssa) nmos1 l=180n w=1u m=1
	mpb02 (net27 net51 net158 vdda) pmos1 l=180n w=1u m=1
	mppd1 (net158 xpd vdda vdda) pmos1 l=2.0e-07n w=1.9e-06u m=1
	mps11 (net31 net158 vdda vdda) pmos1 l=180n w=1u m=1
	mpd11 (net56 inn net31 net31) pmos1 l=180n w=1u m=1
	mp001 (out net158 vdda vdda) pmos1 l=180n w=1u m=1
	mpd12 (net13 inp net31 net31) pmos1 l=180n w=1u m=1
	mpb01 (net158 net158 vdda vdda) pmos1 l=180n w=1u m=1
ends OPAMP1_variant539

subckt OPAMP1_variant540 inn inp out pd xpd vdda vssa
	xd1 (vssa vdda) prim_nwd AREA=6.13907e-9 PJ=476.6e-6 m=1
	xi0 (vssa net69) prim_nd AREA=1e-12 PJ=4e-6 m=1
	xi3 (net51 vdda) prim_pd AREA=790e-15 PJ=3.3e-6 m=1
	xr0 (vssa vdda net51) prim_rdiffp l=2.7e-07 w=1.2e-06 m=1
	xr1 (vdda vdda net69) prim_rdiffp l=1.4e-07 w=1.1e-06 m=1
	xcc01 (net12 out) prim_cpoly c=1p m=1
	mnm12 (net13 net56 vssa vssa) nmos1 l=180n w=1u m=1
	mnm11 (net56 net56 vssa vssa) nmos1 l=1.3e-07n w=1.3e-06u m=1
	mnb02 (net27 net27 net21 vssa) nmos1 l=180n w=1u m=1
	mnpd1 (net21 xpd vssa vssa) nmos1 l=180n w=1u m=1
	mn001 (out net13 vssa vssa) nmos1 l=180n w=1u m=1
	mnpd2 (net13 pd vssa vssa) nmos1 l=180n w=1u m=1
	mnc01 (net13 net69 net12 vssa) nmos1 l=180n w=1u m=1
	mpb02 (net27 net51 net158 vdda) pmos1 l=180n w=1u m=1
	mppd1 (net158 xpd vdda vdda) pmos1 l=180n w=1u m=1
	mps11 (net31 net158 vdda vdda) pmos1 l=2.4e-07n w=6.9e-07u m=1
	mpd11 (net56 inn net31 net31) pmos1 l=180n w=1u m=1
	mp001 (out net158 vdda vdda) pmos1 l=180n w=1u m=1
	mpd12 (net13 inp net31 net31) pmos1 l=180n w=1u m=1
	mpb01 (net158 net158 vdda vdda) pmos1 l=180n w=1u m=1
ends OPAMP1_variant540

subckt OPAMP1_variant541 inn inp out pd xpd vdda vssa
	xd1 (vssa vdda) prim_nwd AREA=6.13907e-9 PJ=476.6e-6 m=1
	xi0 (vssa net69) prim_nd AREA=1e-12 PJ=4e-6 m=1
	xi3 (net51 vdda) prim_pd AREA=790e-15 PJ=3.3e-6 m=1
	xr0 (vssa vdda net51) prim_rdiffp l=2.1e-6 w=700e-9 m=1
	xr1 (vdda vdda net69) prim_rdiffp l=2.1e-6 w=700e-9 m=1
	xcc01 (net12 out) prim_cpoly c=1p m=1
	mnm12 (net13 net56 vssa vssa) nmos1 l=180n w=1u m=1
	mnm11 (net56 net56 vssa vssa) nmos1 l=180n w=1u m=1
	mnb02 (net27 net27 net21 vssa) nmos1 l=180n w=1u m=1
	mnpd1 (net21 xpd vssa vssa) nmos1 l=1.6e-07n w=1.9e-06u m=1
	mn001 (out net13 vssa vssa) nmos1 l=180n w=1u m=1
	mnpd2 (net13 pd vssa vssa) nmos1 l=1.2e-07n w=1.4e-06u m=1
	mnc01 (net13 net69 net12 vssa) nmos1 l=180n w=1u m=1
	mpb02 (net27 net51 net158 vdda) pmos1 l=3.0e-07n w=7.1e-07u m=1
	mppd1 (net158 xpd vdda vdda) pmos1 l=180n w=1u m=1
	mps11 (net31 net158 vdda vdda) pmos1 l=2.8e-07n w=6.1e-07u m=1
	mpd11 (net56 inn net31 net31) pmos1 l=180n w=1u m=1
	mp001 (out net158 vdda vdda) pmos1 l=180n w=1u m=1
	mpd12 (net13 inp net31 net31) pmos1 l=180n w=1u m=1
	mpb01 (net158 net158 vdda vdda) pmos1 l=2.9e-07n w=1.8e-06u m=1
ends OPAMP1_variant541

subckt OPAMP1_variant542 inn inp out pd xpd vdda vssa
	xd1 (vssa vdda) prim_nwd AREA=6.13907e-9 PJ=476.6e-6 m=1
	xi0 (vssa net69) prim_nd AREA=1e-12 PJ=4e-6 m=1
	xi3 (net51 vdda) prim_pd AREA=790e-15 PJ=3.3e-6 m=1
	xr0 (vssa vdda net51) prim_rdiffp l=3.0e-07 w=1.8e-06 m=1
	xr1 (vdda vdda net69) prim_rdiffp l=2.1e-6 w=700e-9 m=1
	xcc01 (net12 out) prim_cpoly c=1p m=1
	mnm12 (net13 net56 vssa vssa) nmos1 l=180n w=1u m=1
	mnm11 (net56 net56 vssa vssa) nmos1 l=180n w=1u m=1
	mnb02 (net27 net27 net21 vssa) nmos1 l=180n w=1u m=1
	mnpd1 (net21 xpd vssa vssa) nmos1 l=180n w=1u m=1
	mn001 (out net13 vssa vssa) nmos1 l=180n w=1u m=1
	mnpd2 (net13 pd vssa vssa) nmos1 l=180n w=1u m=1
	mnc01 (net13 net69 net12 vssa) nmos1 l=180n w=1u m=1
	mpb02 (net27 net51 net158 vdda) pmos1 l=180n w=1u m=1
	mppd1 (net158 xpd vdda vdda) pmos1 l=2.4e-07n w=1.1e-06u m=1
	mps11 (net31 net158 vdda vdda) pmos1 l=180n w=1u m=1
	mpd11 (net56 inn net31 net31) pmos1 l=1.8e-07n w=1.3e-06u m=1
	mp001 (out net158 vdda vdda) pmos1 l=180n w=1u m=1
	mpd12 (net13 inp net31 net31) pmos1 l=180n w=1u m=1
	mpb01 (net158 net158 vdda vdda) pmos1 l=180n w=1u m=1
ends OPAMP1_variant542

subckt OPAMP1_variant543 inn inp out pd xpd vdda vssa
	xd1 (vssa vdda) prim_nwd AREA=6.13907e-9 PJ=476.6e-6 m=1
	xi0 (vssa net69) prim_nd AREA=1e-12 PJ=4e-6 m=1
	xi3 (net51 vdda) prim_pd AREA=790e-15 PJ=3.3e-6 m=1
	xr0 (vssa vdda net51) prim_rdiffp l=2.1e-6 w=700e-9 m=1
	xr1 (vdda vdda net69) prim_rdiffp l=1.5e-07 w=1.8e-06 m=1
	xcc01 (net12 out) prim_cpoly c=1p m=1
	mnm12 (net13 net56 vssa vssa) nmos1 l=180n w=1u m=1
	mnm11 (net56 net56 vssa vssa) nmos1 l=1.7e-07n w=1.1e-06u m=1
	mnb02 (net27 net27 net21 vssa) nmos1 l=180n w=1u m=1
	mnpd1 (net21 xpd vssa vssa) nmos1 l=180n w=1u m=1
	mn001 (out net13 vssa vssa) nmos1 l=180n w=1u m=1
	mnpd2 (net13 pd vssa vssa) nmos1 l=180n w=1u m=1
	mnc01 (net13 net69 net12 vssa) nmos1 l=180n w=1u m=1
	mpb02 (net27 net51 net158 vdda) pmos1 l=180n w=1u m=1
	mppd1 (net158 xpd vdda vdda) pmos1 l=180n w=1u m=1
	mps11 (net31 net158 vdda vdda) pmos1 l=180n w=1u m=1
	mpd11 (net56 inn net31 net31) pmos1 l=180n w=1u m=1
	mp001 (out net158 vdda vdda) pmos1 l=180n w=1u m=1
	mpd12 (net13 inp net31 net31) pmos1 l=180n w=1u m=1
	mpb01 (net158 net158 vdda vdda) pmos1 l=180n w=1u m=1
ends OPAMP1_variant543

subckt OPAMP1_variant544 inn inp out pd xpd vdda vssa
	xd1 (vssa vdda) prim_nwd AREA=5.8e-09 PJ=4.2e-05 m=1
	xi0 (vssa net69) prim_nd AREA=1e-12 PJ=4e-6 m=1
	xi3 (net51 vdda) prim_pd AREA=790e-15 PJ=3.3e-6 m=1
	xr0 (vssa vdda net51) prim_rdiffp l=2.1e-6 w=700e-9 m=1
	xr1 (vdda vdda net69) prim_rdiffp l=2.1e-6 w=700e-9 m=1
	xcc01 (net12 out) prim_cpoly c=1p m=1
	mnm12 (net13 net56 vssa vssa) nmos1 l=180n w=1u m=1
	mnm11 (net56 net56 vssa vssa) nmos1 l=180n w=1u m=1
	mnb02 (net27 net27 net21 vssa) nmos1 l=180n w=1u m=1
	mnpd1 (net21 xpd vssa vssa) nmos1 l=2.9e-07n w=1.9e-06u m=1
	mn001 (out net13 vssa vssa) nmos1 l=180n w=1u m=1
	mnpd2 (net13 pd vssa vssa) nmos1 l=180n w=1u m=1
	mnc01 (net13 net69 net12 vssa) nmos1 l=2.4e-07n w=1.4e-06u m=1
	mpb02 (net27 net51 net158 vdda) pmos1 l=180n w=1u m=1
	mppd1 (net158 xpd vdda vdda) pmos1 l=2.9e-07n w=1.4e-06u m=1
	mps11 (net31 net158 vdda vdda) pmos1 l=180n w=1u m=1
	mpd11 (net56 inn net31 net31) pmos1 l=180n w=1u m=1
	mp001 (out net158 vdda vdda) pmos1 l=180n w=1u m=1
	mpd12 (net13 inp net31 net31) pmos1 l=180n w=1u m=1
	mpb01 (net158 net158 vdda vdda) pmos1 l=180n w=1u m=1
ends OPAMP1_variant544

subckt OPAMP1_variant545 inn inp out pd xpd vdda vssa
	xd1 (vssa vdda) prim_nwd AREA=6.13907e-9 PJ=476.6e-6 m=1
	xi0 (vssa net69) prim_nd AREA=1e-12 PJ=4e-6 m=1
	xi3 (net51 vdda) prim_pd AREA=5.9e-10 PJ=7.0e-05 m=1
	xr0 (vssa vdda net51) prim_rdiffp l=2.1e-6 w=700e-9 m=1
	xr1 (vdda vdda net69) prim_rdiffp l=2.1e-6 w=700e-9 m=1
	xcc01 (net12 out) prim_cpoly c=1p m=1
	mnm12 (net13 net56 vssa vssa) nmos1 l=180n w=1u m=1
	mnm11 (net56 net56 vssa vssa) nmos1 l=180n w=1u m=1
	mnb02 (net27 net27 net21 vssa) nmos1 l=180n w=1u m=1
	mnpd1 (net21 xpd vssa vssa) nmos1 l=2.4e-07n w=1.0e-06u m=1
	mn001 (out net13 vssa vssa) nmos1 l=180n w=1u m=1
	mnpd2 (net13 pd vssa vssa) nmos1 l=180n w=1u m=1
	mnc01 (net13 net69 net12 vssa) nmos1 l=180n w=1u m=1
	mpb02 (net27 net51 net158 vdda) pmos1 l=180n w=1u m=1
	mppd1 (net158 xpd vdda vdda) pmos1 l=180n w=1u m=1
	mps11 (net31 net158 vdda vdda) pmos1 l=180n w=1u m=1
	mpd11 (net56 inn net31 net31) pmos1 l=180n w=1u m=1
	mp001 (out net158 vdda vdda) pmos1 l=180n w=1u m=1
	mpd12 (net13 inp net31 net31) pmos1 l=180n w=1u m=1
	mpb01 (net158 net158 vdda vdda) pmos1 l=180n w=1u m=1
ends OPAMP1_variant545

subckt OPAMP1_variant546 inn inp out pd xpd vdda vssa
	xd1 (vssa vdda) prim_nwd AREA=1.5e-09 PJ=3.9e-05 m=1
	xi0 (vssa net69) prim_nd AREA=1e-12 PJ=4e-6 m=1
	xi3 (net51 vdda) prim_pd AREA=6.4e-09 PJ=5.0e-05 m=1
	xr0 (vssa vdda net51) prim_rdiffp l=2.1e-6 w=700e-9 m=1
	xr1 (vdda vdda net69) prim_rdiffp l=2.1e-6 w=700e-9 m=1
	xcc01 (net12 out) prim_cpoly c=1p m=1
	mnm12 (net13 net56 vssa vssa) nmos1 l=180n w=1u m=1
	mnm11 (net56 net56 vssa vssa) nmos1 l=3.0e-07n w=1.4e-06u m=1
	mnb02 (net27 net27 net21 vssa) nmos1 l=180n w=1u m=1
	mnpd1 (net21 xpd vssa vssa) nmos1 l=180n w=1u m=1
	mn001 (out net13 vssa vssa) nmos1 l=180n w=1u m=1
	mnpd2 (net13 pd vssa vssa) nmos1 l=180n w=1u m=1
	mnc01 (net13 net69 net12 vssa) nmos1 l=180n w=1u m=1
	mpb02 (net27 net51 net158 vdda) pmos1 l=180n w=1u m=1
	mppd1 (net158 xpd vdda vdda) pmos1 l=180n w=1u m=1
	mps11 (net31 net158 vdda vdda) pmos1 l=180n w=1u m=1
	mpd11 (net56 inn net31 net31) pmos1 l=1.9e-07n w=1.7e-06u m=1
	mp001 (out net158 vdda vdda) pmos1 l=180n w=1u m=1
	mpd12 (net13 inp net31 net31) pmos1 l=2.7e-07n w=1.6e-06u m=1
	mpb01 (net158 net158 vdda vdda) pmos1 l=180n w=1u m=1
ends OPAMP1_variant546

subckt OPAMP1_variant547 inn inp out pd xpd vdda vssa
	xd1 (vssa vdda) prim_nwd AREA=6.13907e-9 PJ=476.6e-6 m=1
	xi0 (vssa net69) prim_nd AREA=1e-12 PJ=4e-6 m=1
	xi3 (net51 vdda) prim_pd AREA=790e-15 PJ=3.3e-6 m=1
	xr0 (vssa vdda net51) prim_rdiffp l=2.1e-6 w=700e-9 m=1
	xr1 (vdda vdda net69) prim_rdiffp l=2.1e-6 w=700e-9 m=1
	xcc01 (net12 out) prim_cpoly c=1.8e-12p m=1
	mnm12 (net13 net56 vssa vssa) nmos1 l=180n w=1u m=1
	mnm11 (net56 net56 vssa vssa) nmos1 l=180n w=1u m=1
	mnb02 (net27 net27 net21 vssa) nmos1 l=180n w=1u m=1
	mnpd1 (net21 xpd vssa vssa) nmos1 l=180n w=1u m=1
	mn001 (out net13 vssa vssa) nmos1 l=2.3e-07n w=1.1e-06u m=1
	mnpd2 (net13 pd vssa vssa) nmos1 l=2.5e-07n w=1.2e-06u m=1
	mnc01 (net13 net69 net12 vssa) nmos1 l=180n w=1u m=1
	mpb02 (net27 net51 net158 vdda) pmos1 l=3.0e-07n w=1.8e-06u m=1
	mppd1 (net158 xpd vdda vdda) pmos1 l=180n w=1u m=1
	mps11 (net31 net158 vdda vdda) pmos1 l=180n w=1u m=1
	mpd11 (net56 inn net31 net31) pmos1 l=180n w=1u m=1
	mp001 (out net158 vdda vdda) pmos1 l=180n w=1u m=1
	mpd12 (net13 inp net31 net31) pmos1 l=180n w=1u m=1
	mpb01 (net158 net158 vdda vdda) pmos1 l=180n w=1u m=1
ends OPAMP1_variant547

subckt OPAMP1_variant548 inn inp out pd xpd vdda vssa
	xd1 (vssa vdda) prim_nwd AREA=4.5e-09 PJ=8.3e-05 m=1
	xi0 (vssa net69) prim_nd AREA=1e-12 PJ=4e-6 m=1
	xi3 (net51 vdda) prim_pd AREA=1.4e-09 PJ=4.8e-05 m=1
	xr0 (vssa vdda net51) prim_rdiffp l=2.1e-6 w=700e-9 m=1
	xr1 (vdda vdda net69) prim_rdiffp l=2.1e-6 w=700e-9 m=1
	xcc01 (net12 out) prim_cpoly c=1p m=1
	mnm12 (net13 net56 vssa vssa) nmos1 l=180n w=1u m=1
	mnm11 (net56 net56 vssa vssa) nmos1 l=180n w=1u m=1
	mnb02 (net27 net27 net21 vssa) nmos1 l=180n w=1u m=1
	mnpd1 (net21 xpd vssa vssa) nmos1 l=180n w=1u m=1
	mn001 (out net13 vssa vssa) nmos1 l=180n w=1u m=1
	mnpd2 (net13 pd vssa vssa) nmos1 l=180n w=1u m=1
	mnc01 (net13 net69 net12 vssa) nmos1 l=1.3e-07n w=1.6e-06u m=1
	mpb02 (net27 net51 net158 vdda) pmos1 l=2.2e-07n w=2.0e-06u m=1
	mppd1 (net158 xpd vdda vdda) pmos1 l=180n w=1u m=1
	mps11 (net31 net158 vdda vdda) pmos1 l=180n w=1u m=1
	mpd11 (net56 inn net31 net31) pmos1 l=180n w=1u m=1
	mp001 (out net158 vdda vdda) pmos1 l=180n w=1u m=1
	mpd12 (net13 inp net31 net31) pmos1 l=180n w=1u m=1
	mpb01 (net158 net158 vdda vdda) pmos1 l=180n w=1u m=1
ends OPAMP1_variant548

subckt OPAMP1_variant549 inn inp out pd xpd vdda vssa
	xd1 (vssa vdda) prim_nwd AREA=6.13907e-9 PJ=476.6e-6 m=1
	xi0 (vssa net69) prim_nd AREA=1e-12 PJ=4e-6 m=1
	xi3 (net51 vdda) prim_pd AREA=790e-15 PJ=3.3e-6 m=1
	xr0 (vssa vdda net51) prim_rdiffp l=1.4e-07 w=1.1e-06 m=1
	xr1 (vdda vdda net69) prim_rdiffp l=2.1e-6 w=700e-9 m=1
	xcc01 (net12 out) prim_cpoly c=1p m=1
	mnm12 (net13 net56 vssa vssa) nmos1 l=1.8e-07n w=7.8e-07u m=1
	mnm11 (net56 net56 vssa vssa) nmos1 l=180n w=1u m=1
	mnb02 (net27 net27 net21 vssa) nmos1 l=180n w=1u m=1
	mnpd1 (net21 xpd vssa vssa) nmos1 l=180n w=1u m=1
	mn001 (out net13 vssa vssa) nmos1 l=180n w=1u m=1
	mnpd2 (net13 pd vssa vssa) nmos1 l=1.9e-07n w=1.5e-06u m=1
	mnc01 (net13 net69 net12 vssa) nmos1 l=180n w=1u m=1
	mpb02 (net27 net51 net158 vdda) pmos1 l=1.7e-07n w=1.7e-06u m=1
	mppd1 (net158 xpd vdda vdda) pmos1 l=180n w=1u m=1
	mps11 (net31 net158 vdda vdda) pmos1 l=1.8e-07n w=1.3e-06u m=1
	mpd11 (net56 inn net31 net31) pmos1 l=180n w=1u m=1
	mp001 (out net158 vdda vdda) pmos1 l=180n w=1u m=1
	mpd12 (net13 inp net31 net31) pmos1 l=180n w=1u m=1
	mpb01 (net158 net158 vdda vdda) pmos1 l=180n w=1u m=1
ends OPAMP1_variant549

subckt OPAMP1_variant550 inn inp out pd xpd vdda vssa
	xd1 (vssa vdda) prim_nwd AREA=6.13907e-9 PJ=476.6e-6 m=1
	xi0 (vssa net69) prim_nd AREA=7.0e-11 PJ=3.5e-05 m=1
	xi3 (net51 vdda) prim_pd AREA=790e-15 PJ=3.3e-6 m=1
	xr0 (vssa vdda net51) prim_rdiffp l=2.1e-6 w=700e-9 m=1
	xr1 (vdda vdda net69) prim_rdiffp l=2.1e-6 w=700e-9 m=1
	xcc01 (net12 out) prim_cpoly c=1p m=1
	mnm12 (net13 net56 vssa vssa) nmos1 l=180n w=1u m=1
	mnm11 (net56 net56 vssa vssa) nmos1 l=180n w=1u m=1
	mnb02 (net27 net27 net21 vssa) nmos1 l=180n w=1u m=1
	mnpd1 (net21 xpd vssa vssa) nmos1 l=180n w=1u m=1
	mn001 (out net13 vssa vssa) nmos1 l=180n w=1u m=1
	mnpd2 (net13 pd vssa vssa) nmos1 l=180n w=1u m=1
	mnc01 (net13 net69 net12 vssa) nmos1 l=2.6e-07n w=1.0e-06u m=1
	mpb02 (net27 net51 net158 vdda) pmos1 l=180n w=1u m=1
	mppd1 (net158 xpd vdda vdda) pmos1 l=2.7e-07n w=1.9e-06u m=1
	mps11 (net31 net158 vdda vdda) pmos1 l=2.1e-07n w=9.2e-07u m=1
	mpd11 (net56 inn net31 net31) pmos1 l=180n w=1u m=1
	mp001 (out net158 vdda vdda) pmos1 l=1.8e-07n w=1.9e-06u m=1
	mpd12 (net13 inp net31 net31) pmos1 l=180n w=1u m=1
	mpb01 (net158 net158 vdda vdda) pmos1 l=180n w=1u m=1
ends OPAMP1_variant550

subckt OPAMP1_variant551 inn inp out pd xpd vdda vssa
	xd1 (vssa vdda) prim_nwd AREA=2.5e-09 PJ=1.3e-05 m=1
	xi0 (vssa net69) prim_nd AREA=4.5e-09 PJ=8.4e-05 m=1
	xi3 (net51 vdda) prim_pd AREA=790e-15 PJ=3.3e-6 m=1
	xr0 (vssa vdda net51) prim_rdiffp l=2.1e-6 w=700e-9 m=1
	xr1 (vdda vdda net69) prim_rdiffp l=2.1e-6 w=700e-9 m=1
	xcc01 (net12 out) prim_cpoly c=1p m=1
	mnm12 (net13 net56 vssa vssa) nmos1 l=180n w=1u m=1
	mnm11 (net56 net56 vssa vssa) nmos1 l=1.5e-07n w=1.6e-06u m=1
	mnb02 (net27 net27 net21 vssa) nmos1 l=180n w=1u m=1
	mnpd1 (net21 xpd vssa vssa) nmos1 l=180n w=1u m=1
	mn001 (out net13 vssa vssa) nmos1 l=180n w=1u m=1
	mnpd2 (net13 pd vssa vssa) nmos1 l=180n w=1u m=1
	mnc01 (net13 net69 net12 vssa) nmos1 l=180n w=1u m=1
	mpb02 (net27 net51 net158 vdda) pmos1 l=180n w=1u m=1
	mppd1 (net158 xpd vdda vdda) pmos1 l=180n w=1u m=1
	mps11 (net31 net158 vdda vdda) pmos1 l=180n w=1u m=1
	mpd11 (net56 inn net31 net31) pmos1 l=180n w=1u m=1
	mp001 (out net158 vdda vdda) pmos1 l=180n w=1u m=1
	mpd12 (net13 inp net31 net31) pmos1 l=2.8e-07n w=7.2e-07u m=1
	mpb01 (net158 net158 vdda vdda) pmos1 l=2.1e-07n w=9.3e-07u m=1
ends OPAMP1_variant551

subckt OPAMP1_variant552 inn inp out pd xpd vdda vssa
	xd1 (vssa vdda) prim_nwd AREA=6.13907e-9 PJ=476.6e-6 m=1
	xi0 (vssa net69) prim_nd AREA=1e-12 PJ=4e-6 m=1
	xi3 (net51 vdda) prim_pd AREA=790e-15 PJ=3.3e-6 m=1
	xr0 (vssa vdda net51) prim_rdiffp l=2.1e-6 w=700e-9 m=1
	xr1 (vdda vdda net69) prim_rdiffp l=2.1e-6 w=700e-9 m=1
	xcc01 (net12 out) prim_cpoly c=1p m=1
	mnm12 (net13 net56 vssa vssa) nmos1 l=180n w=1u m=1
	mnm11 (net56 net56 vssa vssa) nmos1 l=180n w=1u m=1
	mnb02 (net27 net27 net21 vssa) nmos1 l=2.3e-07n w=1.7e-06u m=1
	mnpd1 (net21 xpd vssa vssa) nmos1 l=2.4e-07n w=1.4e-06u m=1
	mn001 (out net13 vssa vssa) nmos1 l=180n w=1u m=1
	mnpd2 (net13 pd vssa vssa) nmos1 l=180n w=1u m=1
	mnc01 (net13 net69 net12 vssa) nmos1 l=180n w=1u m=1
	mpb02 (net27 net51 net158 vdda) pmos1 l=1.1e-07n w=8.2e-07u m=1
	mppd1 (net158 xpd vdda vdda) pmos1 l=180n w=1u m=1
	mps11 (net31 net158 vdda vdda) pmos1 l=180n w=1u m=1
	mpd11 (net56 inn net31 net31) pmos1 l=180n w=1u m=1
	mp001 (out net158 vdda vdda) pmos1 l=1.3e-07n w=9.3e-07u m=1
	mpd12 (net13 inp net31 net31) pmos1 l=1.5e-07n w=1.4e-06u m=1
	mpb01 (net158 net158 vdda vdda) pmos1 l=180n w=1u m=1
ends OPAMP1_variant552

subckt OPAMP1_variant553 inn inp out pd xpd vdda vssa
	xd1 (vssa vdda) prim_nwd AREA=6.13907e-9 PJ=476.6e-6 m=1
	xi0 (vssa net69) prim_nd AREA=1e-12 PJ=4e-6 m=1
	xi3 (net51 vdda) prim_pd AREA=9.9e-09 PJ=3.5e-05 m=1
	xr0 (vssa vdda net51) prim_rdiffp l=2.1e-6 w=700e-9 m=1
	xr1 (vdda vdda net69) prim_rdiffp l=2.1e-6 w=700e-9 m=1
	xcc01 (net12 out) prim_cpoly c=1p m=1
	mnm12 (net13 net56 vssa vssa) nmos1 l=180n w=1u m=1
	mnm11 (net56 net56 vssa vssa) nmos1 l=180n w=1u m=1
	mnb02 (net27 net27 net21 vssa) nmos1 l=180n w=1u m=1
	mnpd1 (net21 xpd vssa vssa) nmos1 l=1.4e-07n w=8.3e-07u m=1
	mn001 (out net13 vssa vssa) nmos1 l=180n w=1u m=1
	mnpd2 (net13 pd vssa vssa) nmos1 l=180n w=1u m=1
	mnc01 (net13 net69 net12 vssa) nmos1 l=180n w=1u m=1
	mpb02 (net27 net51 net158 vdda) pmos1 l=2.8e-07n w=5.6e-07u m=1
	mppd1 (net158 xpd vdda vdda) pmos1 l=1.7e-07n w=1.2e-06u m=1
	mps11 (net31 net158 vdda vdda) pmos1 l=180n w=1u m=1
	mpd11 (net56 inn net31 net31) pmos1 l=180n w=1u m=1
	mp001 (out net158 vdda vdda) pmos1 l=1.4e-07n w=5.3e-07u m=1
	mpd12 (net13 inp net31 net31) pmos1 l=180n w=1u m=1
	mpb01 (net158 net158 vdda vdda) pmos1 l=180n w=1u m=1
ends OPAMP1_variant553

subckt OPAMP1_variant554 inn inp out pd xpd vdda vssa
	xd1 (vssa vdda) prim_nwd AREA=6.13907e-9 PJ=476.6e-6 m=1
	xi0 (vssa net69) prim_nd AREA=1e-12 PJ=4e-6 m=1
	xi3 (net51 vdda) prim_pd AREA=790e-15 PJ=3.3e-6 m=1
	xr0 (vssa vdda net51) prim_rdiffp l=2.1e-6 w=700e-9 m=1
	xr1 (vdda vdda net69) prim_rdiffp l=2.1e-6 w=700e-9 m=1
	xcc01 (net12 out) prim_cpoly c=1.1e-12p m=1
	mnm12 (net13 net56 vssa vssa) nmos1 l=180n w=1u m=1
	mnm11 (net56 net56 vssa vssa) nmos1 l=180n w=1u m=1
	mnb02 (net27 net27 net21 vssa) nmos1 l=180n w=1u m=1
	mnpd1 (net21 xpd vssa vssa) nmos1 l=180n w=1u m=1
	mn001 (out net13 vssa vssa) nmos1 l=180n w=1u m=1
	mnpd2 (net13 pd vssa vssa) nmos1 l=180n w=1u m=1
	mnc01 (net13 net69 net12 vssa) nmos1 l=2.8e-07n w=1.8e-06u m=1
	mpb02 (net27 net51 net158 vdda) pmos1 l=180n w=1u m=1
	mppd1 (net158 xpd vdda vdda) pmos1 l=180n w=1u m=1
	mps11 (net31 net158 vdda vdda) pmos1 l=180n w=1u m=1
	mpd11 (net56 inn net31 net31) pmos1 l=180n w=1u m=1
	mp001 (out net158 vdda vdda) pmos1 l=180n w=1u m=1
	mpd12 (net13 inp net31 net31) pmos1 l=180n w=1u m=1
	mpb01 (net158 net158 vdda vdda) pmos1 l=180n w=1u m=1
ends OPAMP1_variant554

subckt OPAMP1_variant555 inn inp out pd xpd vdda vssa
	xd1 (vssa vdda) prim_nwd AREA=9.9e-09 PJ=3.1e-05 m=1
	xi0 (vssa net69) prim_nd AREA=1e-12 PJ=4e-6 m=1
	xi3 (net51 vdda) prim_pd AREA=790e-15 PJ=3.3e-6 m=1
	xr0 (vssa vdda net51) prim_rdiffp l=2.5e-07 w=1.7e-06 m=1
	xr1 (vdda vdda net69) prim_rdiffp l=2.1e-6 w=700e-9 m=1
	xcc01 (net12 out) prim_cpoly c=1p m=1
	mnm12 (net13 net56 vssa vssa) nmos1 l=180n w=1u m=1
	mnm11 (net56 net56 vssa vssa) nmos1 l=180n w=1u m=1
	mnb02 (net27 net27 net21 vssa) nmos1 l=180n w=1u m=1
	mnpd1 (net21 xpd vssa vssa) nmos1 l=180n w=1u m=1
	mn001 (out net13 vssa vssa) nmos1 l=180n w=1u m=1
	mnpd2 (net13 pd vssa vssa) nmos1 l=180n w=1u m=1
	mnc01 (net13 net69 net12 vssa) nmos1 l=180n w=1u m=1
	mpb02 (net27 net51 net158 vdda) pmos1 l=180n w=1u m=1
	mppd1 (net158 xpd vdda vdda) pmos1 l=180n w=1u m=1
	mps11 (net31 net158 vdda vdda) pmos1 l=180n w=1u m=1
	mpd11 (net56 inn net31 net31) pmos1 l=1.9e-07n w=1.3e-06u m=1
	mp001 (out net158 vdda vdda) pmos1 l=180n w=1u m=1
	mpd12 (net13 inp net31 net31) pmos1 l=180n w=1u m=1
	mpb01 (net158 net158 vdda vdda) pmos1 l=180n w=1u m=1
ends OPAMP1_variant555

subckt OPAMP1_variant556 inn inp out pd xpd vdda vssa
	xd1 (vssa vdda) prim_nwd AREA=6.13907e-9 PJ=476.6e-6 m=1
	xi0 (vssa net69) prim_nd AREA=1e-12 PJ=4e-6 m=1
	xi3 (net51 vdda) prim_pd AREA=790e-15 PJ=3.3e-6 m=1
	xr0 (vssa vdda net51) prim_rdiffp l=2.1e-6 w=700e-9 m=1
	xr1 (vdda vdda net69) prim_rdiffp l=2.1e-6 w=700e-9 m=1
	xcc01 (net12 out) prim_cpoly c=1p m=1
	mnm12 (net13 net56 vssa vssa) nmos1 l=180n w=1u m=1
	mnm11 (net56 net56 vssa vssa) nmos1 l=180n w=1u m=1
	mnb02 (net27 net27 net21 vssa) nmos1 l=180n w=1u m=1
	mnpd1 (net21 xpd vssa vssa) nmos1 l=180n w=1u m=1
	mn001 (out net13 vssa vssa) nmos1 l=2.5e-07n w=5.9e-07u m=1
	mnpd2 (net13 pd vssa vssa) nmos1 l=2.7e-07n w=8.0e-07u m=1
	mnc01 (net13 net69 net12 vssa) nmos1 l=1.7e-07n w=1.5e-06u m=1
	mpb02 (net27 net51 net158 vdda) pmos1 l=1.1e-07n w=1.8e-06u m=1
	mppd1 (net158 xpd vdda vdda) pmos1 l=180n w=1u m=1
	mps11 (net31 net158 vdda vdda) pmos1 l=1.6e-07n w=1.4e-06u m=1
	mpd11 (net56 inn net31 net31) pmos1 l=180n w=1u m=1
	mp001 (out net158 vdda vdda) pmos1 l=180n w=1u m=1
	mpd12 (net13 inp net31 net31) pmos1 l=180n w=1u m=1
	mpb01 (net158 net158 vdda vdda) pmos1 l=180n w=1u m=1
ends OPAMP1_variant556

subckt OPAMP1_variant557 inn inp out pd xpd vdda vssa
	xd1 (vssa vdda) prim_nwd AREA=6.13907e-9 PJ=476.6e-6 m=1
	xi0 (vssa net69) prim_nd AREA=1e-12 PJ=4e-6 m=1
	xi3 (net51 vdda) prim_pd AREA=790e-15 PJ=3.3e-6 m=1
	xr0 (vssa vdda net51) prim_rdiffp l=2.1e-6 w=700e-9 m=1
	xr1 (vdda vdda net69) prim_rdiffp l=2.1e-6 w=700e-9 m=1
	xcc01 (net12 out) prim_cpoly c=1p m=1
	mnm12 (net13 net56 vssa vssa) nmos1 l=180n w=1u m=1
	mnm11 (net56 net56 vssa vssa) nmos1 l=180n w=1u m=1
	mnb02 (net27 net27 net21 vssa) nmos1 l=2.6e-07n w=1.7e-06u m=1
	mnpd1 (net21 xpd vssa vssa) nmos1 l=180n w=1u m=1
	mn001 (out net13 vssa vssa) nmos1 l=180n w=1u m=1
	mnpd2 (net13 pd vssa vssa) nmos1 l=180n w=1u m=1
	mnc01 (net13 net69 net12 vssa) nmos1 l=180n w=1u m=1
	mpb02 (net27 net51 net158 vdda) pmos1 l=180n w=1u m=1
	mppd1 (net158 xpd vdda vdda) pmos1 l=180n w=1u m=1
	mps11 (net31 net158 vdda vdda) pmos1 l=180n w=1u m=1
	mpd11 (net56 inn net31 net31) pmos1 l=180n w=1u m=1
	mp001 (out net158 vdda vdda) pmos1 l=1.4e-07n w=9.9e-07u m=1
	mpd12 (net13 inp net31 net31) pmos1 l=180n w=1u m=1
	mpb01 (net158 net158 vdda vdda) pmos1 l=180n w=1u m=1
ends OPAMP1_variant557

subckt OPAMP1_variant558 inn inp out pd xpd vdda vssa
	xd1 (vssa vdda) prim_nwd AREA=6.13907e-9 PJ=476.6e-6 m=1
	xi0 (vssa net69) prim_nd AREA=2.2e-09 PJ=8.5e-05 m=1
	xi3 (net51 vdda) prim_pd AREA=790e-15 PJ=3.3e-6 m=1
	xr0 (vssa vdda net51) prim_rdiffp l=2.1e-6 w=700e-9 m=1
	xr1 (vdda vdda net69) prim_rdiffp l=2.1e-6 w=700e-9 m=1
	xcc01 (net12 out) prim_cpoly c=1p m=1
	mnm12 (net13 net56 vssa vssa) nmos1 l=180n w=1u m=1
	mnm11 (net56 net56 vssa vssa) nmos1 l=180n w=1u m=1
	mnb02 (net27 net27 net21 vssa) nmos1 l=180n w=1u m=1
	mnpd1 (net21 xpd vssa vssa) nmos1 l=180n w=1u m=1
	mn001 (out net13 vssa vssa) nmos1 l=180n w=1u m=1
	mnpd2 (net13 pd vssa vssa) nmos1 l=2.0e-07n w=1.5e-06u m=1
	mnc01 (net13 net69 net12 vssa) nmos1 l=1.1e-07n w=1.3e-06u m=1
	mpb02 (net27 net51 net158 vdda) pmos1 l=180n w=1u m=1
	mppd1 (net158 xpd vdda vdda) pmos1 l=180n w=1u m=1
	mps11 (net31 net158 vdda vdda) pmos1 l=180n w=1u m=1
	mpd11 (net56 inn net31 net31) pmos1 l=180n w=1u m=1
	mp001 (out net158 vdda vdda) pmos1 l=180n w=1u m=1
	mpd12 (net13 inp net31 net31) pmos1 l=180n w=1u m=1
	mpb01 (net158 net158 vdda vdda) pmos1 l=180n w=1u m=1
ends OPAMP1_variant558

subckt OPAMP1_variant559 inn inp out pd xpd vdda vssa
	xd1 (vssa vdda) prim_nwd AREA=6.13907e-9 PJ=476.6e-6 m=1
	xi0 (vssa net69) prim_nd AREA=1e-12 PJ=4e-6 m=1
	xi3 (net51 vdda) prim_pd AREA=790e-15 PJ=3.3e-6 m=1
	xr0 (vssa vdda net51) prim_rdiffp l=2.6e-07 w=1.0e-06 m=1
	xr1 (vdda vdda net69) prim_rdiffp l=2.7e-07 w=1.9e-06 m=1
	xcc01 (net12 out) prim_cpoly c=1p m=1
	mnm12 (net13 net56 vssa vssa) nmos1 l=180n w=1u m=1
	mnm11 (net56 net56 vssa vssa) nmos1 l=180n w=1u m=1
	mnb02 (net27 net27 net21 vssa) nmos1 l=180n w=1u m=1
	mnpd1 (net21 xpd vssa vssa) nmos1 l=1.4e-07n w=8.0e-07u m=1
	mn001 (out net13 vssa vssa) nmos1 l=180n w=1u m=1
	mnpd2 (net13 pd vssa vssa) nmos1 l=180n w=1u m=1
	mnc01 (net13 net69 net12 vssa) nmos1 l=180n w=1u m=1
	mpb02 (net27 net51 net158 vdda) pmos1 l=2.3e-07n w=6.9e-07u m=1
	mppd1 (net158 xpd vdda vdda) pmos1 l=180n w=1u m=1
	mps11 (net31 net158 vdda vdda) pmos1 l=1.9e-07n w=2.0e-06u m=1
	mpd11 (net56 inn net31 net31) pmos1 l=180n w=1u m=1
	mp001 (out net158 vdda vdda) pmos1 l=180n w=1u m=1
	mpd12 (net13 inp net31 net31) pmos1 l=180n w=1u m=1
	mpb01 (net158 net158 vdda vdda) pmos1 l=180n w=1u m=1
ends OPAMP1_variant559

subckt OPAMP1_variant560 inn inp out pd xpd vdda vssa
	xd1 (vssa vdda) prim_nwd AREA=6.13907e-9 PJ=476.6e-6 m=1
	xi0 (vssa net69) prim_nd AREA=1e-12 PJ=4e-6 m=1
	xi3 (net51 vdda) prim_pd AREA=790e-15 PJ=3.3e-6 m=1
	xr0 (vssa vdda net51) prim_rdiffp l=2.1e-6 w=700e-9 m=1
	xr1 (vdda vdda net69) prim_rdiffp l=2.1e-6 w=700e-9 m=1
	xcc01 (net12 out) prim_cpoly c=1p m=1
	mnm12 (net13 net56 vssa vssa) nmos1 l=180n w=1u m=1
	mnm11 (net56 net56 vssa vssa) nmos1 l=180n w=1u m=1
	mnb02 (net27 net27 net21 vssa) nmos1 l=1.9e-07n w=1.4e-06u m=1
	mnpd1 (net21 xpd vssa vssa) nmos1 l=180n w=1u m=1
	mn001 (out net13 vssa vssa) nmos1 l=180n w=1u m=1
	mnpd2 (net13 pd vssa vssa) nmos1 l=180n w=1u m=1
	mnc01 (net13 net69 net12 vssa) nmos1 l=2.6e-07n w=1.0e-06u m=1
	mpb02 (net27 net51 net158 vdda) pmos1 l=2.1e-07n w=1.8e-06u m=1
	mppd1 (net158 xpd vdda vdda) pmos1 l=180n w=1u m=1
	mps11 (net31 net158 vdda vdda) pmos1 l=2.1e-07n w=2.0e-06u m=1
	mpd11 (net56 inn net31 net31) pmos1 l=180n w=1u m=1
	mp001 (out net158 vdda vdda) pmos1 l=180n w=1u m=1
	mpd12 (net13 inp net31 net31) pmos1 l=180n w=1u m=1
	mpb01 (net158 net158 vdda vdda) pmos1 l=180n w=1u m=1
ends OPAMP1_variant560

subckt OPAMP1_variant561 inn inp out pd xpd vdda vssa
	xd1 (vssa vdda) prim_nwd AREA=6.13907e-9 PJ=476.6e-6 m=1
	xi0 (vssa net69) prim_nd AREA=1e-12 PJ=4e-6 m=1
	xi3 (net51 vdda) prim_pd AREA=790e-15 PJ=3.3e-6 m=1
	xr0 (vssa vdda net51) prim_rdiffp l=2.1e-6 w=700e-9 m=1
	xr1 (vdda vdda net69) prim_rdiffp l=2.1e-6 w=700e-9 m=1
	xcc01 (net12 out) prim_cpoly c=1p m=1
	mnm12 (net13 net56 vssa vssa) nmos1 l=180n w=1u m=1
	mnm11 (net56 net56 vssa vssa) nmos1 l=180n w=1u m=1
	mnb02 (net27 net27 net21 vssa) nmos1 l=180n w=1u m=1
	mnpd1 (net21 xpd vssa vssa) nmos1 l=180n w=1u m=1
	mn001 (out net13 vssa vssa) nmos1 l=180n w=1u m=1
	mnpd2 (net13 pd vssa vssa) nmos1 l=1.9e-07n w=6.3e-07u m=1
	mnc01 (net13 net69 net12 vssa) nmos1 l=180n w=1u m=1
	mpb02 (net27 net51 net158 vdda) pmos1 l=180n w=1u m=1
	mppd1 (net158 xpd vdda vdda) pmos1 l=180n w=1u m=1
	mps11 (net31 net158 vdda vdda) pmos1 l=180n w=1u m=1
	mpd11 (net56 inn net31 net31) pmos1 l=180n w=1u m=1
	mp001 (out net158 vdda vdda) pmos1 l=1.4e-07n w=1.9e-06u m=1
	mpd12 (net13 inp net31 net31) pmos1 l=180n w=1u m=1
	mpb01 (net158 net158 vdda vdda) pmos1 l=180n w=1u m=1
ends OPAMP1_variant561

subckt OPAMP1_variant562 inn inp out pd xpd vdda vssa
	xd1 (vssa vdda) prim_nwd AREA=6.13907e-9 PJ=476.6e-6 m=1
	xi0 (vssa net69) prim_nd AREA=1e-12 PJ=4e-6 m=1
	xi3 (net51 vdda) prim_pd AREA=790e-15 PJ=3.3e-6 m=1
	xr0 (vssa vdda net51) prim_rdiffp l=2.1e-6 w=700e-9 m=1
	xr1 (vdda vdda net69) prim_rdiffp l=2.1e-6 w=700e-9 m=1
	xcc01 (net12 out) prim_cpoly c=1p m=1
	mnm12 (net13 net56 vssa vssa) nmos1 l=1.9e-07n w=1.6e-06u m=1
	mnm11 (net56 net56 vssa vssa) nmos1 l=180n w=1u m=1
	mnb02 (net27 net27 net21 vssa) nmos1 l=180n w=1u m=1
	mnpd1 (net21 xpd vssa vssa) nmos1 l=180n w=1u m=1
	mn001 (out net13 vssa vssa) nmos1 l=180n w=1u m=1
	mnpd2 (net13 pd vssa vssa) nmos1 l=1.6e-07n w=1.6e-06u m=1
	mnc01 (net13 net69 net12 vssa) nmos1 l=180n w=1u m=1
	mpb02 (net27 net51 net158 vdda) pmos1 l=180n w=1u m=1
	mppd1 (net158 xpd vdda vdda) pmos1 l=2.4e-07n w=1.7e-06u m=1
	mps11 (net31 net158 vdda vdda) pmos1 l=180n w=1u m=1
	mpd11 (net56 inn net31 net31) pmos1 l=180n w=1u m=1
	mp001 (out net158 vdda vdda) pmos1 l=1.1e-07n w=1.8e-06u m=1
	mpd12 (net13 inp net31 net31) pmos1 l=180n w=1u m=1
	mpb01 (net158 net158 vdda vdda) pmos1 l=1.5e-07n w=6.3e-07u m=1
ends OPAMP1_variant562

subckt OPAMP1_variant563 inn inp out pd xpd vdda vssa
	xd1 (vssa vdda) prim_nwd AREA=6.13907e-9 PJ=476.6e-6 m=1
	xi0 (vssa net69) prim_nd AREA=1e-12 PJ=4e-6 m=1
	xi3 (net51 vdda) prim_pd AREA=5.0e-09 PJ=5.7e-05 m=1
	xr0 (vssa vdda net51) prim_rdiffp l=2.1e-6 w=700e-9 m=1
	xr1 (vdda vdda net69) prim_rdiffp l=2.1e-6 w=700e-9 m=1
	xcc01 (net12 out) prim_cpoly c=1p m=1
	mnm12 (net13 net56 vssa vssa) nmos1 l=180n w=1u m=1
	mnm11 (net56 net56 vssa vssa) nmos1 l=180n w=1u m=1
	mnb02 (net27 net27 net21 vssa) nmos1 l=180n w=1u m=1
	mnpd1 (net21 xpd vssa vssa) nmos1 l=1.4e-07n w=1.1e-06u m=1
	mn001 (out net13 vssa vssa) nmos1 l=180n w=1u m=1
	mnpd2 (net13 pd vssa vssa) nmos1 l=180n w=1u m=1
	mnc01 (net13 net69 net12 vssa) nmos1 l=2.7e-07n w=1.1e-06u m=1
	mpb02 (net27 net51 net158 vdda) pmos1 l=180n w=1u m=1
	mppd1 (net158 xpd vdda vdda) pmos1 l=180n w=1u m=1
	mps11 (net31 net158 vdda vdda) pmos1 l=180n w=1u m=1
	mpd11 (net56 inn net31 net31) pmos1 l=180n w=1u m=1
	mp001 (out net158 vdda vdda) pmos1 l=180n w=1u m=1
	mpd12 (net13 inp net31 net31) pmos1 l=1.8e-07n w=1.3e-06u m=1
	mpb01 (net158 net158 vdda vdda) pmos1 l=1.7e-07n w=2.0e-06u m=1
ends OPAMP1_variant563

subckt OPAMP1_variant564 inn inp out pd xpd vdda vssa
	xd1 (vssa vdda) prim_nwd AREA=6.13907e-9 PJ=476.6e-6 m=1
	xi0 (vssa net69) prim_nd AREA=1e-12 PJ=4e-6 m=1
	xi3 (net51 vdda) prim_pd AREA=790e-15 PJ=3.3e-6 m=1
	xr0 (vssa vdda net51) prim_rdiffp l=2.1e-6 w=700e-9 m=1
	xr1 (vdda vdda net69) prim_rdiffp l=2.1e-6 w=700e-9 m=1
	xcc01 (net12 out) prim_cpoly c=1p m=1
	mnm12 (net13 net56 vssa vssa) nmos1 l=180n w=1u m=1
	mnm11 (net56 net56 vssa vssa) nmos1 l=180n w=1u m=1
	mnb02 (net27 net27 net21 vssa) nmos1 l=180n w=1u m=1
	mnpd1 (net21 xpd vssa vssa) nmos1 l=180n w=1u m=1
	mn001 (out net13 vssa vssa) nmos1 l=2.2e-07n w=1.6e-06u m=1
	mnpd2 (net13 pd vssa vssa) nmos1 l=180n w=1u m=1
	mnc01 (net13 net69 net12 vssa) nmos1 l=180n w=1u m=1
	mpb02 (net27 net51 net158 vdda) pmos1 l=180n w=1u m=1
	mppd1 (net158 xpd vdda vdda) pmos1 l=1.5e-07n w=1.5e-06u m=1
	mps11 (net31 net158 vdda vdda) pmos1 l=180n w=1u m=1
	mpd11 (net56 inn net31 net31) pmos1 l=180n w=1u m=1
	mp001 (out net158 vdda vdda) pmos1 l=2.2e-07n w=1.6e-06u m=1
	mpd12 (net13 inp net31 net31) pmos1 l=180n w=1u m=1
	mpb01 (net158 net158 vdda vdda) pmos1 l=1.7e-07n w=1.6e-06u m=1
ends OPAMP1_variant564

subckt OPAMP1_variant565 inn inp out pd xpd vdda vssa
	xd1 (vssa vdda) prim_nwd AREA=6.13907e-9 PJ=476.6e-6 m=1
	xi0 (vssa net69) prim_nd AREA=1e-12 PJ=4e-6 m=1
	xi3 (net51 vdda) prim_pd AREA=790e-15 PJ=3.3e-6 m=1
	xr0 (vssa vdda net51) prim_rdiffp l=2.1e-6 w=700e-9 m=1
	xr1 (vdda vdda net69) prim_rdiffp l=2.1e-6 w=700e-9 m=1
	xcc01 (net12 out) prim_cpoly c=1p m=1
	mnm12 (net13 net56 vssa vssa) nmos1 l=180n w=1u m=1
	mnm11 (net56 net56 vssa vssa) nmos1 l=180n w=1u m=1
	mnb02 (net27 net27 net21 vssa) nmos1 l=180n w=1u m=1
	mnpd1 (net21 xpd vssa vssa) nmos1 l=180n w=1u m=1
	mn001 (out net13 vssa vssa) nmos1 l=2.7e-07n w=1.4e-06u m=1
	mnpd2 (net13 pd vssa vssa) nmos1 l=180n w=1u m=1
	mnc01 (net13 net69 net12 vssa) nmos1 l=180n w=1u m=1
	mpb02 (net27 net51 net158 vdda) pmos1 l=1.8e-07n w=1.1e-06u m=1
	mppd1 (net158 xpd vdda vdda) pmos1 l=180n w=1u m=1
	mps11 (net31 net158 vdda vdda) pmos1 l=180n w=1u m=1
	mpd11 (net56 inn net31 net31) pmos1 l=180n w=1u m=1
	mp001 (out net158 vdda vdda) pmos1 l=180n w=1u m=1
	mpd12 (net13 inp net31 net31) pmos1 l=180n w=1u m=1
	mpb01 (net158 net158 vdda vdda) pmos1 l=180n w=1u m=1
ends OPAMP1_variant565

subckt OPAMP1_variant566 inn inp out pd xpd vdda vssa
	xd1 (vssa vdda) prim_nwd AREA=9.4e-09 PJ=6.1e-05 m=1
	xi0 (vssa net69) prim_nd AREA=5.0e-09 PJ=9.5e-05 m=1
	xi3 (net51 vdda) prim_pd AREA=3.6e-09 PJ=9.5e-05 m=1
	xr0 (vssa vdda net51) prim_rdiffp l=2.6e-07 w=5.2e-07 m=1
	xr1 (vdda vdda net69) prim_rdiffp l=2.1e-6 w=700e-9 m=1
	xcc01 (net12 out) prim_cpoly c=1p m=1
	mnm12 (net13 net56 vssa vssa) nmos1 l=180n w=1u m=1
	mnm11 (net56 net56 vssa vssa) nmos1 l=180n w=1u m=1
	mnb02 (net27 net27 net21 vssa) nmos1 l=180n w=1u m=1
	mnpd1 (net21 xpd vssa vssa) nmos1 l=180n w=1u m=1
	mn001 (out net13 vssa vssa) nmos1 l=180n w=1u m=1
	mnpd2 (net13 pd vssa vssa) nmos1 l=180n w=1u m=1
	mnc01 (net13 net69 net12 vssa) nmos1 l=180n w=1u m=1
	mpb02 (net27 net51 net158 vdda) pmos1 l=180n w=1u m=1
	mppd1 (net158 xpd vdda vdda) pmos1 l=180n w=1u m=1
	mps11 (net31 net158 vdda vdda) pmos1 l=180n w=1u m=1
	mpd11 (net56 inn net31 net31) pmos1 l=180n w=1u m=1
	mp001 (out net158 vdda vdda) pmos1 l=180n w=1u m=1
	mpd12 (net13 inp net31 net31) pmos1 l=180n w=1u m=1
	mpb01 (net158 net158 vdda vdda) pmos1 l=180n w=1u m=1
ends OPAMP1_variant566

subckt OPAMP1_variant567 inn inp out pd xpd vdda vssa
	xd1 (vssa vdda) prim_nwd AREA=3.7e-09 PJ=6.5e-05 m=1
	xi0 (vssa net69) prim_nd AREA=1e-12 PJ=4e-6 m=1
	xi3 (net51 vdda) prim_pd AREA=790e-15 PJ=3.3e-6 m=1
	xr0 (vssa vdda net51) prim_rdiffp l=2.7e-07 w=1.7e-06 m=1
	xr1 (vdda vdda net69) prim_rdiffp l=2.1e-6 w=700e-9 m=1
	xcc01 (net12 out) prim_cpoly c=1p m=1
	mnm12 (net13 net56 vssa vssa) nmos1 l=180n w=1u m=1
	mnm11 (net56 net56 vssa vssa) nmos1 l=180n w=1u m=1
	mnb02 (net27 net27 net21 vssa) nmos1 l=180n w=1u m=1
	mnpd1 (net21 xpd vssa vssa) nmos1 l=180n w=1u m=1
	mn001 (out net13 vssa vssa) nmos1 l=180n w=1u m=1
	mnpd2 (net13 pd vssa vssa) nmos1 l=180n w=1u m=1
	mnc01 (net13 net69 net12 vssa) nmos1 l=180n w=1u m=1
	mpb02 (net27 net51 net158 vdda) pmos1 l=180n w=1u m=1
	mppd1 (net158 xpd vdda vdda) pmos1 l=180n w=1u m=1
	mps11 (net31 net158 vdda vdda) pmos1 l=180n w=1u m=1
	mpd11 (net56 inn net31 net31) pmos1 l=180n w=1u m=1
	mp001 (out net158 vdda vdda) pmos1 l=180n w=1u m=1
	mpd12 (net13 inp net31 net31) pmos1 l=2.7e-07n w=1.4e-06u m=1
	mpb01 (net158 net158 vdda vdda) pmos1 l=180n w=1u m=1
ends OPAMP1_variant567

subckt OPAMP1_variant568 inn inp out pd xpd vdda vssa
	xd1 (vssa vdda) prim_nwd AREA=6.13907e-9 PJ=476.6e-6 m=1
	xi0 (vssa net69) prim_nd AREA=1e-12 PJ=4e-6 m=1
	xi3 (net51 vdda) prim_pd AREA=790e-15 PJ=3.3e-6 m=1
	xr0 (vssa vdda net51) prim_rdiffp l=2.1e-07 w=1.1e-06 m=1
	xr1 (vdda vdda net69) prim_rdiffp l=2.1e-6 w=700e-9 m=1
	xcc01 (net12 out) prim_cpoly c=1p m=1
	mnm12 (net13 net56 vssa vssa) nmos1 l=180n w=1u m=1
	mnm11 (net56 net56 vssa vssa) nmos1 l=180n w=1u m=1
	mnb02 (net27 net27 net21 vssa) nmos1 l=180n w=1u m=1
	mnpd1 (net21 xpd vssa vssa) nmos1 l=180n w=1u m=1
	mn001 (out net13 vssa vssa) nmos1 l=180n w=1u m=1
	mnpd2 (net13 pd vssa vssa) nmos1 l=180n w=1u m=1
	mnc01 (net13 net69 net12 vssa) nmos1 l=180n w=1u m=1
	mpb02 (net27 net51 net158 vdda) pmos1 l=180n w=1u m=1
	mppd1 (net158 xpd vdda vdda) pmos1 l=180n w=1u m=1
	mps11 (net31 net158 vdda vdda) pmos1 l=180n w=1u m=1
	mpd11 (net56 inn net31 net31) pmos1 l=2.5e-07n w=1.6e-06u m=1
	mp001 (out net158 vdda vdda) pmos1 l=180n w=1u m=1
	mpd12 (net13 inp net31 net31) pmos1 l=2.7e-07n w=1.1e-06u m=1
	mpb01 (net158 net158 vdda vdda) pmos1 l=1.4e-07n w=1.0e-06u m=1
ends OPAMP1_variant568

subckt OPAMP1_variant569 inn inp out pd xpd vdda vssa
	xd1 (vssa vdda) prim_nwd AREA=6.13907e-9 PJ=476.6e-6 m=1
	xi0 (vssa net69) prim_nd AREA=1e-12 PJ=4e-6 m=1
	xi3 (net51 vdda) prim_pd AREA=1.4e-09 PJ=5.5e-05 m=1
	xr0 (vssa vdda net51) prim_rdiffp l=2.1e-6 w=700e-9 m=1
	xr1 (vdda vdda net69) prim_rdiffp l=2.1e-6 w=700e-9 m=1
	xcc01 (net12 out) prim_cpoly c=1p m=1
	mnm12 (net13 net56 vssa vssa) nmos1 l=180n w=1u m=1
	mnm11 (net56 net56 vssa vssa) nmos1 l=180n w=1u m=1
	mnb02 (net27 net27 net21 vssa) nmos1 l=180n w=1u m=1
	mnpd1 (net21 xpd vssa vssa) nmos1 l=180n w=1u m=1
	mn001 (out net13 vssa vssa) nmos1 l=180n w=1u m=1
	mnpd2 (net13 pd vssa vssa) nmos1 l=180n w=1u m=1
	mnc01 (net13 net69 net12 vssa) nmos1 l=180n w=1u m=1
	mpb02 (net27 net51 net158 vdda) pmos1 l=1.6e-07n w=1.5e-06u m=1
	mppd1 (net158 xpd vdda vdda) pmos1 l=180n w=1u m=1
	mps11 (net31 net158 vdda vdda) pmos1 l=180n w=1u m=1
	mpd11 (net56 inn net31 net31) pmos1 l=180n w=1u m=1
	mp001 (out net158 vdda vdda) pmos1 l=180n w=1u m=1
	mpd12 (net13 inp net31 net31) pmos1 l=180n w=1u m=1
	mpb01 (net158 net158 vdda vdda) pmos1 l=180n w=1u m=1
ends OPAMP1_variant569

subckt OPAMP1_variant570 inn inp out pd xpd vdda vssa
	xd1 (vssa vdda) prim_nwd AREA=6.13907e-9 PJ=476.6e-6 m=1
	xi0 (vssa net69) prim_nd AREA=1e-12 PJ=4e-6 m=1
	xi3 (net51 vdda) prim_pd AREA=790e-15 PJ=3.3e-6 m=1
	xr0 (vssa vdda net51) prim_rdiffp l=2.1e-6 w=700e-9 m=1
	xr1 (vdda vdda net69) prim_rdiffp l=2.1e-6 w=700e-9 m=1
	xcc01 (net12 out) prim_cpoly c=1p m=1
	mnm12 (net13 net56 vssa vssa) nmos1 l=180n w=1u m=1
	mnm11 (net56 net56 vssa vssa) nmos1 l=180n w=1u m=1
	mnb02 (net27 net27 net21 vssa) nmos1 l=180n w=1u m=1
	mnpd1 (net21 xpd vssa vssa) nmos1 l=1.6e-07n w=1.4e-06u m=1
	mn001 (out net13 vssa vssa) nmos1 l=180n w=1u m=1
	mnpd2 (net13 pd vssa vssa) nmos1 l=180n w=1u m=1
	mnc01 (net13 net69 net12 vssa) nmos1 l=180n w=1u m=1
	mpb02 (net27 net51 net158 vdda) pmos1 l=2.0e-07n w=8.2e-07u m=1
	mppd1 (net158 xpd vdda vdda) pmos1 l=180n w=1u m=1
	mps11 (net31 net158 vdda vdda) pmos1 l=180n w=1u m=1
	mpd11 (net56 inn net31 net31) pmos1 l=180n w=1u m=1
	mp001 (out net158 vdda vdda) pmos1 l=180n w=1u m=1
	mpd12 (net13 inp net31 net31) pmos1 l=180n w=1u m=1
	mpb01 (net158 net158 vdda vdda) pmos1 l=180n w=1u m=1
ends OPAMP1_variant570

subckt OPAMP1_variant571 inn inp out pd xpd vdda vssa
	xd1 (vssa vdda) prim_nwd AREA=8.2e-09 PJ=1.8e-05 m=1
	xi0 (vssa net69) prim_nd AREA=1e-12 PJ=4e-6 m=1
	xi3 (net51 vdda) prim_pd AREA=790e-15 PJ=3.3e-6 m=1
	xr0 (vssa vdda net51) prim_rdiffp l=2.1e-6 w=700e-9 m=1
	xr1 (vdda vdda net69) prim_rdiffp l=2.1e-6 w=700e-9 m=1
	xcc01 (net12 out) prim_cpoly c=1p m=1
	mnm12 (net13 net56 vssa vssa) nmos1 l=180n w=1u m=1
	mnm11 (net56 net56 vssa vssa) nmos1 l=180n w=1u m=1
	mnb02 (net27 net27 net21 vssa) nmos1 l=180n w=1u m=1
	mnpd1 (net21 xpd vssa vssa) nmos1 l=180n w=1u m=1
	mn001 (out net13 vssa vssa) nmos1 l=1.2e-07n w=8.0e-07u m=1
	mnpd2 (net13 pd vssa vssa) nmos1 l=180n w=1u m=1
	mnc01 (net13 net69 net12 vssa) nmos1 l=180n w=1u m=1
	mpb02 (net27 net51 net158 vdda) pmos1 l=180n w=1u m=1
	mppd1 (net158 xpd vdda vdda) pmos1 l=180n w=1u m=1
	mps11 (net31 net158 vdda vdda) pmos1 l=180n w=1u m=1
	mpd11 (net56 inn net31 net31) pmos1 l=180n w=1u m=1
	mp001 (out net158 vdda vdda) pmos1 l=180n w=1u m=1
	mpd12 (net13 inp net31 net31) pmos1 l=180n w=1u m=1
	mpb01 (net158 net158 vdda vdda) pmos1 l=180n w=1u m=1
ends OPAMP1_variant571

subckt OPAMP1_variant572 inn inp out pd xpd vdda vssa
	xd1 (vssa vdda) prim_nwd AREA=6.13907e-9 PJ=476.6e-6 m=1
	xi0 (vssa net69) prim_nd AREA=1e-12 PJ=4e-6 m=1
	xi3 (net51 vdda) prim_pd AREA=790e-15 PJ=3.3e-6 m=1
	xr0 (vssa vdda net51) prim_rdiffp l=2.1e-6 w=700e-9 m=1
	xr1 (vdda vdda net69) prim_rdiffp l=2.1e-6 w=700e-9 m=1
	xcc01 (net12 out) prim_cpoly c=1p m=1
	mnm12 (net13 net56 vssa vssa) nmos1 l=180n w=1u m=1
	mnm11 (net56 net56 vssa vssa) nmos1 l=180n w=1u m=1
	mnb02 (net27 net27 net21 vssa) nmos1 l=180n w=1u m=1
	mnpd1 (net21 xpd vssa vssa) nmos1 l=180n w=1u m=1
	mn001 (out net13 vssa vssa) nmos1 l=2.6e-07n w=5.9e-07u m=1
	mnpd2 (net13 pd vssa vssa) nmos1 l=180n w=1u m=1
	mnc01 (net13 net69 net12 vssa) nmos1 l=2.8e-07n w=1.3e-06u m=1
	mpb02 (net27 net51 net158 vdda) pmos1 l=180n w=1u m=1
	mppd1 (net158 xpd vdda vdda) pmos1 l=180n w=1u m=1
	mps11 (net31 net158 vdda vdda) pmos1 l=1.7e-07n w=1.8e-06u m=1
	mpd11 (net56 inn net31 net31) pmos1 l=180n w=1u m=1
	mp001 (out net158 vdda vdda) pmos1 l=180n w=1u m=1
	mpd12 (net13 inp net31 net31) pmos1 l=180n w=1u m=1
	mpb01 (net158 net158 vdda vdda) pmos1 l=180n w=1u m=1
ends OPAMP1_variant572

subckt OPAMP1_variant573 inn inp out pd xpd vdda vssa
	xd1 (vssa vdda) prim_nwd AREA=6.13907e-9 PJ=476.6e-6 m=1
	xi0 (vssa net69) prim_nd AREA=7.4e-09 PJ=9.2e-05 m=1
	xi3 (net51 vdda) prim_pd AREA=9.2e-09 PJ=6.5e-05 m=1
	xr0 (vssa vdda net51) prim_rdiffp l=2.1e-6 w=700e-9 m=1
	xr1 (vdda vdda net69) prim_rdiffp l=2.6e-07 w=1.8e-06 m=1
	xcc01 (net12 out) prim_cpoly c=1p m=1
	mnm12 (net13 net56 vssa vssa) nmos1 l=180n w=1u m=1
	mnm11 (net56 net56 vssa vssa) nmos1 l=180n w=1u m=1
	mnb02 (net27 net27 net21 vssa) nmos1 l=1.4e-07n w=1.2e-06u m=1
	mnpd1 (net21 xpd vssa vssa) nmos1 l=2.2e-07n w=1.9e-06u m=1
	mn001 (out net13 vssa vssa) nmos1 l=180n w=1u m=1
	mnpd2 (net13 pd vssa vssa) nmos1 l=180n w=1u m=1
	mnc01 (net13 net69 net12 vssa) nmos1 l=180n w=1u m=1
	mpb02 (net27 net51 net158 vdda) pmos1 l=180n w=1u m=1
	mppd1 (net158 xpd vdda vdda) pmos1 l=180n w=1u m=1
	mps11 (net31 net158 vdda vdda) pmos1 l=180n w=1u m=1
	mpd11 (net56 inn net31 net31) pmos1 l=180n w=1u m=1
	mp001 (out net158 vdda vdda) pmos1 l=180n w=1u m=1
	mpd12 (net13 inp net31 net31) pmos1 l=180n w=1u m=1
	mpb01 (net158 net158 vdda vdda) pmos1 l=180n w=1u m=1
ends OPAMP1_variant573

subckt OPAMP1_variant574 inn inp out pd xpd vdda vssa
	xd1 (vssa vdda) prim_nwd AREA=6.13907e-9 PJ=476.6e-6 m=1
	xi0 (vssa net69) prim_nd AREA=6.1e-09 PJ=7.3e-05 m=1
	xi3 (net51 vdda) prim_pd AREA=790e-15 PJ=3.3e-6 m=1
	xr0 (vssa vdda net51) prim_rdiffp l=2.1e-6 w=700e-9 m=1
	xr1 (vdda vdda net69) prim_rdiffp l=2.1e-6 w=700e-9 m=1
	xcc01 (net12 out) prim_cpoly c=1p m=1
	mnm12 (net13 net56 vssa vssa) nmos1 l=180n w=1u m=1
	mnm11 (net56 net56 vssa vssa) nmos1 l=180n w=1u m=1
	mnb02 (net27 net27 net21 vssa) nmos1 l=180n w=1u m=1
	mnpd1 (net21 xpd vssa vssa) nmos1 l=1.7e-07n w=9.8e-07u m=1
	mn001 (out net13 vssa vssa) nmos1 l=180n w=1u m=1
	mnpd2 (net13 pd vssa vssa) nmos1 l=180n w=1u m=1
	mnc01 (net13 net69 net12 vssa) nmos1 l=180n w=1u m=1
	mpb02 (net27 net51 net158 vdda) pmos1 l=180n w=1u m=1
	mppd1 (net158 xpd vdda vdda) pmos1 l=180n w=1u m=1
	mps11 (net31 net158 vdda vdda) pmos1 l=1.7e-07n w=1.6e-06u m=1
	mpd11 (net56 inn net31 net31) pmos1 l=180n w=1u m=1
	mp001 (out net158 vdda vdda) pmos1 l=180n w=1u m=1
	mpd12 (net13 inp net31 net31) pmos1 l=180n w=1u m=1
	mpb01 (net158 net158 vdda vdda) pmos1 l=180n w=1u m=1
ends OPAMP1_variant574

subckt OPAMP1_variant575 inn inp out pd xpd vdda vssa
	xd1 (vssa vdda) prim_nwd AREA=6.13907e-9 PJ=476.6e-6 m=1
	xi0 (vssa net69) prim_nd AREA=1e-12 PJ=4e-6 m=1
	xi3 (net51 vdda) prim_pd AREA=790e-15 PJ=3.3e-6 m=1
	xr0 (vssa vdda net51) prim_rdiffp l=2.1e-6 w=700e-9 m=1
	xr1 (vdda vdda net69) prim_rdiffp l=2.1e-6 w=700e-9 m=1
	xcc01 (net12 out) prim_cpoly c=1p m=1
	mnm12 (net13 net56 vssa vssa) nmos1 l=180n w=1u m=1
	mnm11 (net56 net56 vssa vssa) nmos1 l=180n w=1u m=1
	mnb02 (net27 net27 net21 vssa) nmos1 l=180n w=1u m=1
	mnpd1 (net21 xpd vssa vssa) nmos1 l=1.9e-07n w=6.1e-07u m=1
	mn001 (out net13 vssa vssa) nmos1 l=180n w=1u m=1
	mnpd2 (net13 pd vssa vssa) nmos1 l=180n w=1u m=1
	mnc01 (net13 net69 net12 vssa) nmos1 l=180n w=1u m=1
	mpb02 (net27 net51 net158 vdda) pmos1 l=180n w=1u m=1
	mppd1 (net158 xpd vdda vdda) pmos1 l=2.9e-07n w=5.6e-07u m=1
	mps11 (net31 net158 vdda vdda) pmos1 l=180n w=1u m=1
	mpd11 (net56 inn net31 net31) pmos1 l=180n w=1u m=1
	mp001 (out net158 vdda vdda) pmos1 l=180n w=1u m=1
	mpd12 (net13 inp net31 net31) pmos1 l=180n w=1u m=1
	mpb01 (net158 net158 vdda vdda) pmos1 l=180n w=1u m=1
ends OPAMP1_variant575

subckt OPAMP1_variant576 inn inp out pd xpd vdda vssa
	xd1 (vssa vdda) prim_nwd AREA=6.13907e-9 PJ=476.6e-6 m=1
	xi0 (vssa net69) prim_nd AREA=1e-12 PJ=4e-6 m=1
	xi3 (net51 vdda) prim_pd AREA=790e-15 PJ=3.3e-6 m=1
	xr0 (vssa vdda net51) prim_rdiffp l=2.1e-6 w=700e-9 m=1
	xr1 (vdda vdda net69) prim_rdiffp l=2.1e-6 w=700e-9 m=1
	xcc01 (net12 out) prim_cpoly c=1p m=1
	mnm12 (net13 net56 vssa vssa) nmos1 l=180n w=1u m=1
	mnm11 (net56 net56 vssa vssa) nmos1 l=180n w=1u m=1
	mnb02 (net27 net27 net21 vssa) nmos1 l=1.0e-07n w=1.5e-06u m=1
	mnpd1 (net21 xpd vssa vssa) nmos1 l=2.3e-07n w=1.9e-06u m=1
	mn001 (out net13 vssa vssa) nmos1 l=180n w=1u m=1
	mnpd2 (net13 pd vssa vssa) nmos1 l=180n w=1u m=1
	mnc01 (net13 net69 net12 vssa) nmos1 l=2.6e-07n w=1.5e-06u m=1
	mpb02 (net27 net51 net158 vdda) pmos1 l=180n w=1u m=1
	mppd1 (net158 xpd vdda vdda) pmos1 l=180n w=1u m=1
	mps11 (net31 net158 vdda vdda) pmos1 l=180n w=1u m=1
	mpd11 (net56 inn net31 net31) pmos1 l=180n w=1u m=1
	mp001 (out net158 vdda vdda) pmos1 l=1.1e-07n w=1.4e-06u m=1
	mpd12 (net13 inp net31 net31) pmos1 l=180n w=1u m=1
	mpb01 (net158 net158 vdda vdda) pmos1 l=180n w=1u m=1
ends OPAMP1_variant576

subckt OPAMP1_variant577 inn inp out pd xpd vdda vssa
	xd1 (vssa vdda) prim_nwd AREA=6.13907e-9 PJ=476.6e-6 m=1
	xi0 (vssa net69) prim_nd AREA=1e-12 PJ=4e-6 m=1
	xi3 (net51 vdda) prim_pd AREA=790e-15 PJ=3.3e-6 m=1
	xr0 (vssa vdda net51) prim_rdiffp l=2.1e-6 w=700e-9 m=1
	xr1 (vdda vdda net69) prim_rdiffp l=2.1e-6 w=700e-9 m=1
	xcc01 (net12 out) prim_cpoly c=1p m=1
	mnm12 (net13 net56 vssa vssa) nmos1 l=180n w=1u m=1
	mnm11 (net56 net56 vssa vssa) nmos1 l=2.2e-07n w=1.6e-06u m=1
	mnb02 (net27 net27 net21 vssa) nmos1 l=180n w=1u m=1
	mnpd1 (net21 xpd vssa vssa) nmos1 l=180n w=1u m=1
	mn001 (out net13 vssa vssa) nmos1 l=180n w=1u m=1
	mnpd2 (net13 pd vssa vssa) nmos1 l=180n w=1u m=1
	mnc01 (net13 net69 net12 vssa) nmos1 l=2.1e-07n w=6.6e-07u m=1
	mpb02 (net27 net51 net158 vdda) pmos1 l=180n w=1u m=1
	mppd1 (net158 xpd vdda vdda) pmos1 l=180n w=1u m=1
	mps11 (net31 net158 vdda vdda) pmos1 l=180n w=1u m=1
	mpd11 (net56 inn net31 net31) pmos1 l=180n w=1u m=1
	mp001 (out net158 vdda vdda) pmos1 l=180n w=1u m=1
	mpd12 (net13 inp net31 net31) pmos1 l=180n w=1u m=1
	mpb01 (net158 net158 vdda vdda) pmos1 l=180n w=1u m=1
ends OPAMP1_variant577

subckt OPAMP1_variant578 inn inp out pd xpd vdda vssa
	xd1 (vssa vdda) prim_nwd AREA=6.13907e-9 PJ=476.6e-6 m=1
	xi0 (vssa net69) prim_nd AREA=1.5e-09 PJ=9.8e-05 m=1
	xi3 (net51 vdda) prim_pd AREA=3.3e-10 PJ=1.1e-05 m=1
	xr0 (vssa vdda net51) prim_rdiffp l=2.1e-6 w=700e-9 m=1
	xr1 (vdda vdda net69) prim_rdiffp l=2.1e-6 w=700e-9 m=1
	xcc01 (net12 out) prim_cpoly c=1p m=1
	mnm12 (net13 net56 vssa vssa) nmos1 l=180n w=1u m=1
	mnm11 (net56 net56 vssa vssa) nmos1 l=180n w=1u m=1
	mnb02 (net27 net27 net21 vssa) nmos1 l=180n w=1u m=1
	mnpd1 (net21 xpd vssa vssa) nmos1 l=180n w=1u m=1
	mn001 (out net13 vssa vssa) nmos1 l=180n w=1u m=1
	mnpd2 (net13 pd vssa vssa) nmos1 l=180n w=1u m=1
	mnc01 (net13 net69 net12 vssa) nmos1 l=180n w=1u m=1
	mpb02 (net27 net51 net158 vdda) pmos1 l=180n w=1u m=1
	mppd1 (net158 xpd vdda vdda) pmos1 l=1.2e-07n w=1.8e-06u m=1
	mps11 (net31 net158 vdda vdda) pmos1 l=1.6e-07n w=1.6e-06u m=1
	mpd11 (net56 inn net31 net31) pmos1 l=180n w=1u m=1
	mp001 (out net158 vdda vdda) pmos1 l=180n w=1u m=1
	mpd12 (net13 inp net31 net31) pmos1 l=2.0e-07n w=8.7e-07u m=1
	mpb01 (net158 net158 vdda vdda) pmos1 l=180n w=1u m=1
ends OPAMP1_variant578

subckt OPAMP1_variant579 inn inp out pd xpd vdda vssa
	xd1 (vssa vdda) prim_nwd AREA=6.13907e-9 PJ=476.6e-6 m=1
	xi0 (vssa net69) prim_nd AREA=1e-12 PJ=4e-6 m=1
	xi3 (net51 vdda) prim_pd AREA=790e-15 PJ=3.3e-6 m=1
	xr0 (vssa vdda net51) prim_rdiffp l=2.6e-07 w=1.0e-06 m=1
	xr1 (vdda vdda net69) prim_rdiffp l=2.1e-6 w=700e-9 m=1
	xcc01 (net12 out) prim_cpoly c=1p m=1
	mnm12 (net13 net56 vssa vssa) nmos1 l=180n w=1u m=1
	mnm11 (net56 net56 vssa vssa) nmos1 l=180n w=1u m=1
	mnb02 (net27 net27 net21 vssa) nmos1 l=180n w=1u m=1
	mnpd1 (net21 xpd vssa vssa) nmos1 l=2.2e-07n w=7.2e-07u m=1
	mn001 (out net13 vssa vssa) nmos1 l=180n w=1u m=1
	mnpd2 (net13 pd vssa vssa) nmos1 l=180n w=1u m=1
	mnc01 (net13 net69 net12 vssa) nmos1 l=180n w=1u m=1
	mpb02 (net27 net51 net158 vdda) pmos1 l=180n w=1u m=1
	mppd1 (net158 xpd vdda vdda) pmos1 l=180n w=1u m=1
	mps11 (net31 net158 vdda vdda) pmos1 l=180n w=1u m=1
	mpd11 (net56 inn net31 net31) pmos1 l=180n w=1u m=1
	mp001 (out net158 vdda vdda) pmos1 l=1.2e-07n w=9.8e-07u m=1
	mpd12 (net13 inp net31 net31) pmos1 l=180n w=1u m=1
	mpb01 (net158 net158 vdda vdda) pmos1 l=180n w=1u m=1
ends OPAMP1_variant579

subckt OPAMP1_variant580 inn inp out pd xpd vdda vssa
	xd1 (vssa vdda) prim_nwd AREA=6.13907e-9 PJ=476.6e-6 m=1
	xi0 (vssa net69) prim_nd AREA=1e-12 PJ=4e-6 m=1
	xi3 (net51 vdda) prim_pd AREA=790e-15 PJ=3.3e-6 m=1
	xr0 (vssa vdda net51) prim_rdiffp l=2.1e-6 w=700e-9 m=1
	xr1 (vdda vdda net69) prim_rdiffp l=1.4e-07 w=1.3e-06 m=1
	xcc01 (net12 out) prim_cpoly c=1p m=1
	mnm12 (net13 net56 vssa vssa) nmos1 l=180n w=1u m=1
	mnm11 (net56 net56 vssa vssa) nmos1 l=180n w=1u m=1
	mnb02 (net27 net27 net21 vssa) nmos1 l=180n w=1u m=1
	mnpd1 (net21 xpd vssa vssa) nmos1 l=180n w=1u m=1
	mn001 (out net13 vssa vssa) nmos1 l=180n w=1u m=1
	mnpd2 (net13 pd vssa vssa) nmos1 l=180n w=1u m=1
	mnc01 (net13 net69 net12 vssa) nmos1 l=180n w=1u m=1
	mpb02 (net27 net51 net158 vdda) pmos1 l=1.1e-07n w=1.1e-06u m=1
	mppd1 (net158 xpd vdda vdda) pmos1 l=180n w=1u m=1
	mps11 (net31 net158 vdda vdda) pmos1 l=180n w=1u m=1
	mpd11 (net56 inn net31 net31) pmos1 l=180n w=1u m=1
	mp001 (out net158 vdda vdda) pmos1 l=180n w=1u m=1
	mpd12 (net13 inp net31 net31) pmos1 l=180n w=1u m=1
	mpb01 (net158 net158 vdda vdda) pmos1 l=180n w=1u m=1
ends OPAMP1_variant580

subckt OPAMP1_variant581 inn inp out pd xpd vdda vssa
	xd1 (vssa vdda) prim_nwd AREA=6.13907e-9 PJ=476.6e-6 m=1
	xi0 (vssa net69) prim_nd AREA=1e-12 PJ=4e-6 m=1
	xi3 (net51 vdda) prim_pd AREA=790e-15 PJ=3.3e-6 m=1
	xr0 (vssa vdda net51) prim_rdiffp l=2.4e-07 w=9.5e-07 m=1
	xr1 (vdda vdda net69) prim_rdiffp l=2.1e-6 w=700e-9 m=1
	xcc01 (net12 out) prim_cpoly c=1p m=1
	mnm12 (net13 net56 vssa vssa) nmos1 l=180n w=1u m=1
	mnm11 (net56 net56 vssa vssa) nmos1 l=180n w=1u m=1
	mnb02 (net27 net27 net21 vssa) nmos1 l=180n w=1u m=1
	mnpd1 (net21 xpd vssa vssa) nmos1 l=180n w=1u m=1
	mn001 (out net13 vssa vssa) nmos1 l=3.0e-07n w=1.1e-06u m=1
	mnpd2 (net13 pd vssa vssa) nmos1 l=180n w=1u m=1
	mnc01 (net13 net69 net12 vssa) nmos1 l=180n w=1u m=1
	mpb02 (net27 net51 net158 vdda) pmos1 l=180n w=1u m=1
	mppd1 (net158 xpd vdda vdda) pmos1 l=180n w=1u m=1
	mps11 (net31 net158 vdda vdda) pmos1 l=2.0e-07n w=2.0e-06u m=1
	mpd11 (net56 inn net31 net31) pmos1 l=180n w=1u m=1
	mp001 (out net158 vdda vdda) pmos1 l=180n w=1u m=1
	mpd12 (net13 inp net31 net31) pmos1 l=180n w=1u m=1
	mpb01 (net158 net158 vdda vdda) pmos1 l=180n w=1u m=1
ends OPAMP1_variant581

subckt OPAMP1_variant582 inn inp out pd xpd vdda vssa
	xd1 (vssa vdda) prim_nwd AREA=6.13907e-9 PJ=476.6e-6 m=1
	xi0 (vssa net69) prim_nd AREA=1e-12 PJ=4e-6 m=1
	xi3 (net51 vdda) prim_pd AREA=790e-15 PJ=3.3e-6 m=1
	xr0 (vssa vdda net51) prim_rdiffp l=2.1e-6 w=700e-9 m=1
	xr1 (vdda vdda net69) prim_rdiffp l=2.1e-6 w=700e-9 m=1
	xcc01 (net12 out) prim_cpoly c=1p m=1
	mnm12 (net13 net56 vssa vssa) nmos1 l=180n w=1u m=1
	mnm11 (net56 net56 vssa vssa) nmos1 l=180n w=1u m=1
	mnb02 (net27 net27 net21 vssa) nmos1 l=180n w=1u m=1
	mnpd1 (net21 xpd vssa vssa) nmos1 l=180n w=1u m=1
	mn001 (out net13 vssa vssa) nmos1 l=180n w=1u m=1
	mnpd2 (net13 pd vssa vssa) nmos1 l=180n w=1u m=1
	mnc01 (net13 net69 net12 vssa) nmos1 l=180n w=1u m=1
	mpb02 (net27 net51 net158 vdda) pmos1 l=2.5e-07n w=1.6e-06u m=1
	mppd1 (net158 xpd vdda vdda) pmos1 l=180n w=1u m=1
	mps11 (net31 net158 vdda vdda) pmos1 l=1.3e-07n w=1.2e-06u m=1
	mpd11 (net56 inn net31 net31) pmos1 l=180n w=1u m=1
	mp001 (out net158 vdda vdda) pmos1 l=180n w=1u m=1
	mpd12 (net13 inp net31 net31) pmos1 l=180n w=1u m=1
	mpb01 (net158 net158 vdda vdda) pmos1 l=180n w=1u m=1
ends OPAMP1_variant582

subckt OPAMP1_variant583 inn inp out pd xpd vdda vssa
	xd1 (vssa vdda) prim_nwd AREA=6.13907e-9 PJ=476.6e-6 m=1
	xi0 (vssa net69) prim_nd AREA=1e-12 PJ=4e-6 m=1
	xi3 (net51 vdda) prim_pd AREA=790e-15 PJ=3.3e-6 m=1
	xr0 (vssa vdda net51) prim_rdiffp l=2.1e-6 w=700e-9 m=1
	xr1 (vdda vdda net69) prim_rdiffp l=2.1e-6 w=700e-9 m=1
	xcc01 (net12 out) prim_cpoly c=1p m=1
	mnm12 (net13 net56 vssa vssa) nmos1 l=180n w=1u m=1
	mnm11 (net56 net56 vssa vssa) nmos1 l=180n w=1u m=1
	mnb02 (net27 net27 net21 vssa) nmos1 l=180n w=1u m=1
	mnpd1 (net21 xpd vssa vssa) nmos1 l=180n w=1u m=1
	mn001 (out net13 vssa vssa) nmos1 l=1.4e-07n w=6.7e-07u m=1
	mnpd2 (net13 pd vssa vssa) nmos1 l=180n w=1u m=1
	mnc01 (net13 net69 net12 vssa) nmos1 l=180n w=1u m=1
	mpb02 (net27 net51 net158 vdda) pmos1 l=180n w=1u m=1
	mppd1 (net158 xpd vdda vdda) pmos1 l=1.4e-07n w=5.1e-07u m=1
	mps11 (net31 net158 vdda vdda) pmos1 l=180n w=1u m=1
	mpd11 (net56 inn net31 net31) pmos1 l=180n w=1u m=1
	mp001 (out net158 vdda vdda) pmos1 l=180n w=1u m=1
	mpd12 (net13 inp net31 net31) pmos1 l=180n w=1u m=1
	mpb01 (net158 net158 vdda vdda) pmos1 l=180n w=1u m=1
ends OPAMP1_variant583

subckt OPAMP1_variant584 inn inp out pd xpd vdda vssa
	xd1 (vssa vdda) prim_nwd AREA=6.13907e-9 PJ=476.6e-6 m=1
	xi0 (vssa net69) prim_nd AREA=1e-12 PJ=4e-6 m=1
	xi3 (net51 vdda) prim_pd AREA=790e-15 PJ=3.3e-6 m=1
	xr0 (vssa vdda net51) prim_rdiffp l=2.1e-6 w=700e-9 m=1
	xr1 (vdda vdda net69) prim_rdiffp l=2.1e-6 w=700e-9 m=1
	xcc01 (net12 out) prim_cpoly c=9.1e-13p m=1
	mnm12 (net13 net56 vssa vssa) nmos1 l=180n w=1u m=1
	mnm11 (net56 net56 vssa vssa) nmos1 l=180n w=1u m=1
	mnb02 (net27 net27 net21 vssa) nmos1 l=180n w=1u m=1
	mnpd1 (net21 xpd vssa vssa) nmos1 l=180n w=1u m=1
	mn001 (out net13 vssa vssa) nmos1 l=180n w=1u m=1
	mnpd2 (net13 pd vssa vssa) nmos1 l=180n w=1u m=1
	mnc01 (net13 net69 net12 vssa) nmos1 l=180n w=1u m=1
	mpb02 (net27 net51 net158 vdda) pmos1 l=180n w=1u m=1
	mppd1 (net158 xpd vdda vdda) pmos1 l=180n w=1u m=1
	mps11 (net31 net158 vdda vdda) pmos1 l=180n w=1u m=1
	mpd11 (net56 inn net31 net31) pmos1 l=180n w=1u m=1
	mp001 (out net158 vdda vdda) pmos1 l=1.7e-07n w=7.6e-07u m=1
	mpd12 (net13 inp net31 net31) pmos1 l=180n w=1u m=1
	mpb01 (net158 net158 vdda vdda) pmos1 l=180n w=1u m=1
ends OPAMP1_variant584

subckt OPAMP1_variant585 inn inp out pd xpd vdda vssa
	xd1 (vssa vdda) prim_nwd AREA=6.13907e-9 PJ=476.6e-6 m=1
	xi0 (vssa net69) prim_nd AREA=1e-12 PJ=4e-6 m=1
	xi3 (net51 vdda) prim_pd AREA=790e-15 PJ=3.3e-6 m=1
	xr0 (vssa vdda net51) prim_rdiffp l=2.9e-07 w=1.3e-06 m=1
	xr1 (vdda vdda net69) prim_rdiffp l=2.1e-6 w=700e-9 m=1
	xcc01 (net12 out) prim_cpoly c=1.3e-12p m=1
	mnm12 (net13 net56 vssa vssa) nmos1 l=180n w=1u m=1
	mnm11 (net56 net56 vssa vssa) nmos1 l=180n w=1u m=1
	mnb02 (net27 net27 net21 vssa) nmos1 l=180n w=1u m=1
	mnpd1 (net21 xpd vssa vssa) nmos1 l=180n w=1u m=1
	mn001 (out net13 vssa vssa) nmos1 l=180n w=1u m=1
	mnpd2 (net13 pd vssa vssa) nmos1 l=180n w=1u m=1
	mnc01 (net13 net69 net12 vssa) nmos1 l=180n w=1u m=1
	mpb02 (net27 net51 net158 vdda) pmos1 l=180n w=1u m=1
	mppd1 (net158 xpd vdda vdda) pmos1 l=180n w=1u m=1
	mps11 (net31 net158 vdda vdda) pmos1 l=180n w=1u m=1
	mpd11 (net56 inn net31 net31) pmos1 l=180n w=1u m=1
	mp001 (out net158 vdda vdda) pmos1 l=180n w=1u m=1
	mpd12 (net13 inp net31 net31) pmos1 l=180n w=1u m=1
	mpb01 (net158 net158 vdda vdda) pmos1 l=180n w=1u m=1
ends OPAMP1_variant585

subckt OPAMP1_variant586 inn inp out pd xpd vdda vssa
	xd1 (vssa vdda) prim_nwd AREA=6.13907e-9 PJ=476.6e-6 m=1
	xi0 (vssa net69) prim_nd AREA=1e-12 PJ=4e-6 m=1
	xi3 (net51 vdda) prim_pd AREA=3.0e-09 PJ=5.4e-05 m=1
	xr0 (vssa vdda net51) prim_rdiffp l=2.1e-6 w=700e-9 m=1
	xr1 (vdda vdda net69) prim_rdiffp l=2.1e-6 w=700e-9 m=1
	xcc01 (net12 out) prim_cpoly c=6.6e-13p m=1
	mnm12 (net13 net56 vssa vssa) nmos1 l=180n w=1u m=1
	mnm11 (net56 net56 vssa vssa) nmos1 l=3.0e-07n w=6.3e-07u m=1
	mnb02 (net27 net27 net21 vssa) nmos1 l=180n w=1u m=1
	mnpd1 (net21 xpd vssa vssa) nmos1 l=180n w=1u m=1
	mn001 (out net13 vssa vssa) nmos1 l=2.0e-07n w=1.1e-06u m=1
	mnpd2 (net13 pd vssa vssa) nmos1 l=180n w=1u m=1
	mnc01 (net13 net69 net12 vssa) nmos1 l=180n w=1u m=1
	mpb02 (net27 net51 net158 vdda) pmos1 l=2.8e-07n w=1.5e-06u m=1
	mppd1 (net158 xpd vdda vdda) pmos1 l=180n w=1u m=1
	mps11 (net31 net158 vdda vdda) pmos1 l=180n w=1u m=1
	mpd11 (net56 inn net31 net31) pmos1 l=180n w=1u m=1
	mp001 (out net158 vdda vdda) pmos1 l=180n w=1u m=1
	mpd12 (net13 inp net31 net31) pmos1 l=180n w=1u m=1
	mpb01 (net158 net158 vdda vdda) pmos1 l=180n w=1u m=1
ends OPAMP1_variant586

subckt OPAMP1_variant587 inn inp out pd xpd vdda vssa
	xd1 (vssa vdda) prim_nwd AREA=6.13907e-9 PJ=476.6e-6 m=1
	xi0 (vssa net69) prim_nd AREA=1e-12 PJ=4e-6 m=1
	xi3 (net51 vdda) prim_pd AREA=790e-15 PJ=3.3e-6 m=1
	xr0 (vssa vdda net51) prim_rdiffp l=2.1e-6 w=700e-9 m=1
	xr1 (vdda vdda net69) prim_rdiffp l=2.1e-6 w=700e-9 m=1
	xcc01 (net12 out) prim_cpoly c=1.4e-12p m=1
	mnm12 (net13 net56 vssa vssa) nmos1 l=2.9e-07n w=1.6e-06u m=1
	mnm11 (net56 net56 vssa vssa) nmos1 l=180n w=1u m=1
	mnb02 (net27 net27 net21 vssa) nmos1 l=180n w=1u m=1
	mnpd1 (net21 xpd vssa vssa) nmos1 l=180n w=1u m=1
	mn001 (out net13 vssa vssa) nmos1 l=180n w=1u m=1
	mnpd2 (net13 pd vssa vssa) nmos1 l=180n w=1u m=1
	mnc01 (net13 net69 net12 vssa) nmos1 l=180n w=1u m=1
	mpb02 (net27 net51 net158 vdda) pmos1 l=180n w=1u m=1
	mppd1 (net158 xpd vdda vdda) pmos1 l=180n w=1u m=1
	mps11 (net31 net158 vdda vdda) pmos1 l=180n w=1u m=1
	mpd11 (net56 inn net31 net31) pmos1 l=180n w=1u m=1
	mp001 (out net158 vdda vdda) pmos1 l=180n w=1u m=1
	mpd12 (net13 inp net31 net31) pmos1 l=1.7e-07n w=7.0e-07u m=1
	mpb01 (net158 net158 vdda vdda) pmos1 l=180n w=1u m=1
ends OPAMP1_variant587

subckt OPAMP1_variant588 inn inp out pd xpd vdda vssa
	xd1 (vssa vdda) prim_nwd AREA=6.13907e-9 PJ=476.6e-6 m=1
	xi0 (vssa net69) prim_nd AREA=1e-12 PJ=4e-6 m=1
	xi3 (net51 vdda) prim_pd AREA=790e-15 PJ=3.3e-6 m=1
	xr0 (vssa vdda net51) prim_rdiffp l=2.8e-07 w=1.1e-06 m=1
	xr1 (vdda vdda net69) prim_rdiffp l=2.1e-6 w=700e-9 m=1
	xcc01 (net12 out) prim_cpoly c=1p m=1
	mnm12 (net13 net56 vssa vssa) nmos1 l=180n w=1u m=1
	mnm11 (net56 net56 vssa vssa) nmos1 l=180n w=1u m=1
	mnb02 (net27 net27 net21 vssa) nmos1 l=180n w=1u m=1
	mnpd1 (net21 xpd vssa vssa) nmos1 l=180n w=1u m=1
	mn001 (out net13 vssa vssa) nmos1 l=180n w=1u m=1
	mnpd2 (net13 pd vssa vssa) nmos1 l=180n w=1u m=1
	mnc01 (net13 net69 net12 vssa) nmos1 l=180n w=1u m=1
	mpb02 (net27 net51 net158 vdda) pmos1 l=180n w=1u m=1
	mppd1 (net158 xpd vdda vdda) pmos1 l=180n w=1u m=1
	mps11 (net31 net158 vdda vdda) pmos1 l=1.9e-07n w=1.7e-06u m=1
	mpd11 (net56 inn net31 net31) pmos1 l=2.7e-07n w=1.2e-06u m=1
	mp001 (out net158 vdda vdda) pmos1 l=180n w=1u m=1
	mpd12 (net13 inp net31 net31) pmos1 l=180n w=1u m=1
	mpb01 (net158 net158 vdda vdda) pmos1 l=180n w=1u m=1
ends OPAMP1_variant588

subckt OPAMP1_variant589 inn inp out pd xpd vdda vssa
	xd1 (vssa vdda) prim_nwd AREA=6.13907e-9 PJ=476.6e-6 m=1
	xi0 (vssa net69) prim_nd AREA=1e-12 PJ=4e-6 m=1
	xi3 (net51 vdda) prim_pd AREA=7.8e-09 PJ=1.8e-05 m=1
	xr0 (vssa vdda net51) prim_rdiffp l=2.1e-6 w=700e-9 m=1
	xr1 (vdda vdda net69) prim_rdiffp l=2.1e-6 w=700e-9 m=1
	xcc01 (net12 out) prim_cpoly c=1p m=1
	mnm12 (net13 net56 vssa vssa) nmos1 l=180n w=1u m=1
	mnm11 (net56 net56 vssa vssa) nmos1 l=180n w=1u m=1
	mnb02 (net27 net27 net21 vssa) nmos1 l=180n w=1u m=1
	mnpd1 (net21 xpd vssa vssa) nmos1 l=180n w=1u m=1
	mn001 (out net13 vssa vssa) nmos1 l=180n w=1u m=1
	mnpd2 (net13 pd vssa vssa) nmos1 l=180n w=1u m=1
	mnc01 (net13 net69 net12 vssa) nmos1 l=180n w=1u m=1
	mpb02 (net27 net51 net158 vdda) pmos1 l=180n w=1u m=1
	mppd1 (net158 xpd vdda vdda) pmos1 l=180n w=1u m=1
	mps11 (net31 net158 vdda vdda) pmos1 l=180n w=1u m=1
	mpd11 (net56 inn net31 net31) pmos1 l=2.2e-07n w=1.2e-06u m=1
	mp001 (out net158 vdda vdda) pmos1 l=180n w=1u m=1
	mpd12 (net13 inp net31 net31) pmos1 l=180n w=1u m=1
	mpb01 (net158 net158 vdda vdda) pmos1 l=180n w=1u m=1
ends OPAMP1_variant589

subckt OPAMP1_variant590 inn inp out pd xpd vdda vssa
	xd1 (vssa vdda) prim_nwd AREA=6.13907e-9 PJ=476.6e-6 m=1
	xi0 (vssa net69) prim_nd AREA=1e-12 PJ=4e-6 m=1
	xi3 (net51 vdda) prim_pd AREA=790e-15 PJ=3.3e-6 m=1
	xr0 (vssa vdda net51) prim_rdiffp l=2.1e-6 w=700e-9 m=1
	xr1 (vdda vdda net69) prim_rdiffp l=2.1e-6 w=700e-9 m=1
	xcc01 (net12 out) prim_cpoly c=1p m=1
	mnm12 (net13 net56 vssa vssa) nmos1 l=180n w=1u m=1
	mnm11 (net56 net56 vssa vssa) nmos1 l=180n w=1u m=1
	mnb02 (net27 net27 net21 vssa) nmos1 l=180n w=1u m=1
	mnpd1 (net21 xpd vssa vssa) nmos1 l=1.0e-07n w=6.2e-07u m=1
	mn001 (out net13 vssa vssa) nmos1 l=2.1e-07n w=8.6e-07u m=1
	mnpd2 (net13 pd vssa vssa) nmos1 l=180n w=1u m=1
	mnc01 (net13 net69 net12 vssa) nmos1 l=180n w=1u m=1
	mpb02 (net27 net51 net158 vdda) pmos1 l=1.4e-07n w=5.3e-07u m=1
	mppd1 (net158 xpd vdda vdda) pmos1 l=180n w=1u m=1
	mps11 (net31 net158 vdda vdda) pmos1 l=180n w=1u m=1
	mpd11 (net56 inn net31 net31) pmos1 l=180n w=1u m=1
	mp001 (out net158 vdda vdda) pmos1 l=180n w=1u m=1
	mpd12 (net13 inp net31 net31) pmos1 l=180n w=1u m=1
	mpb01 (net158 net158 vdda vdda) pmos1 l=180n w=1u m=1
ends OPAMP1_variant590

subckt OPAMP1_variant591 inn inp out pd xpd vdda vssa
	xd1 (vssa vdda) prim_nwd AREA=6.13907e-9 PJ=476.6e-6 m=1
	xi0 (vssa net69) prim_nd AREA=1e-12 PJ=4e-6 m=1
	xi3 (net51 vdda) prim_pd AREA=3.0e-09 PJ=4.7e-05 m=1
	xr0 (vssa vdda net51) prim_rdiffp l=2.9e-07 w=6.6e-07 m=1
	xr1 (vdda vdda net69) prim_rdiffp l=1.7e-07 w=1.9e-06 m=1
	xcc01 (net12 out) prim_cpoly c=1p m=1
	mnm12 (net13 net56 vssa vssa) nmos1 l=180n w=1u m=1
	mnm11 (net56 net56 vssa vssa) nmos1 l=2.2e-07n w=1.4e-06u m=1
	mnb02 (net27 net27 net21 vssa) nmos1 l=180n w=1u m=1
	mnpd1 (net21 xpd vssa vssa) nmos1 l=180n w=1u m=1
	mn001 (out net13 vssa vssa) nmos1 l=180n w=1u m=1
	mnpd2 (net13 pd vssa vssa) nmos1 l=180n w=1u m=1
	mnc01 (net13 net69 net12 vssa) nmos1 l=180n w=1u m=1
	mpb02 (net27 net51 net158 vdda) pmos1 l=2.0e-07n w=1.4e-06u m=1
	mppd1 (net158 xpd vdda vdda) pmos1 l=180n w=1u m=1
	mps11 (net31 net158 vdda vdda) pmos1 l=180n w=1u m=1
	mpd11 (net56 inn net31 net31) pmos1 l=180n w=1u m=1
	mp001 (out net158 vdda vdda) pmos1 l=180n w=1u m=1
	mpd12 (net13 inp net31 net31) pmos1 l=180n w=1u m=1
	mpb01 (net158 net158 vdda vdda) pmos1 l=180n w=1u m=1
ends OPAMP1_variant591

subckt OPAMP1_variant592 inn inp out pd xpd vdda vssa
	xd1 (vssa vdda) prim_nwd AREA=6.13907e-9 PJ=476.6e-6 m=1
	xi0 (vssa net69) prim_nd AREA=1e-12 PJ=4e-6 m=1
	xi3 (net51 vdda) prim_pd AREA=790e-15 PJ=3.3e-6 m=1
	xr0 (vssa vdda net51) prim_rdiffp l=2.1e-6 w=700e-9 m=1
	xr1 (vdda vdda net69) prim_rdiffp l=2.1e-6 w=700e-9 m=1
	xcc01 (net12 out) prim_cpoly c=1.3e-12p m=1
	mnm12 (net13 net56 vssa vssa) nmos1 l=2.3e-07n w=5.2e-07u m=1
	mnm11 (net56 net56 vssa vssa) nmos1 l=2.8e-07n w=8.8e-07u m=1
	mnb02 (net27 net27 net21 vssa) nmos1 l=180n w=1u m=1
	mnpd1 (net21 xpd vssa vssa) nmos1 l=180n w=1u m=1
	mn001 (out net13 vssa vssa) nmos1 l=180n w=1u m=1
	mnpd2 (net13 pd vssa vssa) nmos1 l=180n w=1u m=1
	mnc01 (net13 net69 net12 vssa) nmos1 l=180n w=1u m=1
	mpb02 (net27 net51 net158 vdda) pmos1 l=180n w=1u m=1
	mppd1 (net158 xpd vdda vdda) pmos1 l=180n w=1u m=1
	mps11 (net31 net158 vdda vdda) pmos1 l=180n w=1u m=1
	mpd11 (net56 inn net31 net31) pmos1 l=2.2e-07n w=1.3e-06u m=1
	mp001 (out net158 vdda vdda) pmos1 l=180n w=1u m=1
	mpd12 (net13 inp net31 net31) pmos1 l=1.8e-07n w=5.3e-07u m=1
	mpb01 (net158 net158 vdda vdda) pmos1 l=180n w=1u m=1
ends OPAMP1_variant592

subckt OPAMP1_variant593 inn inp out pd xpd vdda vssa
	xd1 (vssa vdda) prim_nwd AREA=6.13907e-9 PJ=476.6e-6 m=1
	xi0 (vssa net69) prim_nd AREA=1e-12 PJ=4e-6 m=1
	xi3 (net51 vdda) prim_pd AREA=790e-15 PJ=3.3e-6 m=1
	xr0 (vssa vdda net51) prim_rdiffp l=2.1e-6 w=700e-9 m=1
	xr1 (vdda vdda net69) prim_rdiffp l=2.1e-6 w=700e-9 m=1
	xcc01 (net12 out) prim_cpoly c=1.8e-12p m=1
	mnm12 (net13 net56 vssa vssa) nmos1 l=2.4e-07n w=1.9e-06u m=1
	mnm11 (net56 net56 vssa vssa) nmos1 l=180n w=1u m=1
	mnb02 (net27 net27 net21 vssa) nmos1 l=180n w=1u m=1
	mnpd1 (net21 xpd vssa vssa) nmos1 l=180n w=1u m=1
	mn001 (out net13 vssa vssa) nmos1 l=180n w=1u m=1
	mnpd2 (net13 pd vssa vssa) nmos1 l=180n w=1u m=1
	mnc01 (net13 net69 net12 vssa) nmos1 l=180n w=1u m=1
	mpb02 (net27 net51 net158 vdda) pmos1 l=180n w=1u m=1
	mppd1 (net158 xpd vdda vdda) pmos1 l=180n w=1u m=1
	mps11 (net31 net158 vdda vdda) pmos1 l=180n w=1u m=1
	mpd11 (net56 inn net31 net31) pmos1 l=180n w=1u m=1
	mp001 (out net158 vdda vdda) pmos1 l=180n w=1u m=1
	mpd12 (net13 inp net31 net31) pmos1 l=180n w=1u m=1
	mpb01 (net158 net158 vdda vdda) pmos1 l=180n w=1u m=1
ends OPAMP1_variant593

subckt OPAMP1_variant594 inn inp out pd xpd vdda vssa
	xd1 (vssa vdda) prim_nwd AREA=6.13907e-9 PJ=476.6e-6 m=1
	xi0 (vssa net69) prim_nd AREA=1e-12 PJ=4e-6 m=1
	xi3 (net51 vdda) prim_pd AREA=790e-15 PJ=3.3e-6 m=1
	xr0 (vssa vdda net51) prim_rdiffp l=2.1e-6 w=700e-9 m=1
	xr1 (vdda vdda net69) prim_rdiffp l=1.2e-07 w=9.9e-07 m=1
	xcc01 (net12 out) prim_cpoly c=1p m=1
	mnm12 (net13 net56 vssa vssa) nmos1 l=180n w=1u m=1
	mnm11 (net56 net56 vssa vssa) nmos1 l=180n w=1u m=1
	mnb02 (net27 net27 net21 vssa) nmos1 l=2.1e-07n w=1.7e-06u m=1
	mnpd1 (net21 xpd vssa vssa) nmos1 l=2.6e-07n w=5.2e-07u m=1
	mn001 (out net13 vssa vssa) nmos1 l=180n w=1u m=1
	mnpd2 (net13 pd vssa vssa) nmos1 l=180n w=1u m=1
	mnc01 (net13 net69 net12 vssa) nmos1 l=180n w=1u m=1
	mpb02 (net27 net51 net158 vdda) pmos1 l=180n w=1u m=1
	mppd1 (net158 xpd vdda vdda) pmos1 l=180n w=1u m=1
	mps11 (net31 net158 vdda vdda) pmos1 l=180n w=1u m=1
	mpd11 (net56 inn net31 net31) pmos1 l=180n w=1u m=1
	mp001 (out net158 vdda vdda) pmos1 l=1.3e-07n w=1.2e-06u m=1
	mpd12 (net13 inp net31 net31) pmos1 l=180n w=1u m=1
	mpb01 (net158 net158 vdda vdda) pmos1 l=180n w=1u m=1
ends OPAMP1_variant594

subckt OPAMP1_variant595 inn inp out pd xpd vdda vssa
	xd1 (vssa vdda) prim_nwd AREA=6.13907e-9 PJ=476.6e-6 m=1
	xi0 (vssa net69) prim_nd AREA=5.3e-10 PJ=3.0e-05 m=1
	xi3 (net51 vdda) prim_pd AREA=790e-15 PJ=3.3e-6 m=1
	xr0 (vssa vdda net51) prim_rdiffp l=2.1e-6 w=700e-9 m=1
	xr1 (vdda vdda net69) prim_rdiffp l=2.5e-07 w=7.3e-07 m=1
	xcc01 (net12 out) prim_cpoly c=1p m=1
	mnm12 (net13 net56 vssa vssa) nmos1 l=180n w=1u m=1
	mnm11 (net56 net56 vssa vssa) nmos1 l=180n w=1u m=1
	mnb02 (net27 net27 net21 vssa) nmos1 l=180n w=1u m=1
	mnpd1 (net21 xpd vssa vssa) nmos1 l=180n w=1u m=1
	mn001 (out net13 vssa vssa) nmos1 l=180n w=1u m=1
	mnpd2 (net13 pd vssa vssa) nmos1 l=180n w=1u m=1
	mnc01 (net13 net69 net12 vssa) nmos1 l=180n w=1u m=1
	mpb02 (net27 net51 net158 vdda) pmos1 l=2.3e-07n w=1.7e-06u m=1
	mppd1 (net158 xpd vdda vdda) pmos1 l=2.7e-07n w=7.4e-07u m=1
	mps11 (net31 net158 vdda vdda) pmos1 l=180n w=1u m=1
	mpd11 (net56 inn net31 net31) pmos1 l=180n w=1u m=1
	mp001 (out net158 vdda vdda) pmos1 l=180n w=1u m=1
	mpd12 (net13 inp net31 net31) pmos1 l=180n w=1u m=1
	mpb01 (net158 net158 vdda vdda) pmos1 l=180n w=1u m=1
ends OPAMP1_variant595

subckt OPAMP1_variant596 inn inp out pd xpd vdda vssa
	xd1 (vssa vdda) prim_nwd AREA=6.13907e-9 PJ=476.6e-6 m=1
	xi0 (vssa net69) prim_nd AREA=1e-12 PJ=4e-6 m=1
	xi3 (net51 vdda) prim_pd AREA=790e-15 PJ=3.3e-6 m=1
	xr0 (vssa vdda net51) prim_rdiffp l=1.3e-07 w=1.2e-06 m=1
	xr1 (vdda vdda net69) prim_rdiffp l=2.1e-6 w=700e-9 m=1
	xcc01 (net12 out) prim_cpoly c=1p m=1
	mnm12 (net13 net56 vssa vssa) nmos1 l=1.5e-07n w=1.9e-06u m=1
	mnm11 (net56 net56 vssa vssa) nmos1 l=180n w=1u m=1
	mnb02 (net27 net27 net21 vssa) nmos1 l=2.8e-07n w=7.7e-07u m=1
	mnpd1 (net21 xpd vssa vssa) nmos1 l=2.4e-07n w=1.8e-06u m=1
	mn001 (out net13 vssa vssa) nmos1 l=180n w=1u m=1
	mnpd2 (net13 pd vssa vssa) nmos1 l=180n w=1u m=1
	mnc01 (net13 net69 net12 vssa) nmos1 l=180n w=1u m=1
	mpb02 (net27 net51 net158 vdda) pmos1 l=180n w=1u m=1
	mppd1 (net158 xpd vdda vdda) pmos1 l=180n w=1u m=1
	mps11 (net31 net158 vdda vdda) pmos1 l=180n w=1u m=1
	mpd11 (net56 inn net31 net31) pmos1 l=180n w=1u m=1
	mp001 (out net158 vdda vdda) pmos1 l=180n w=1u m=1
	mpd12 (net13 inp net31 net31) pmos1 l=180n w=1u m=1
	mpb01 (net158 net158 vdda vdda) pmos1 l=180n w=1u m=1
ends OPAMP1_variant596

subckt OPAMP1_variant597 inn inp out pd xpd vdda vssa
	xd1 (vssa vdda) prim_nwd AREA=6.13907e-9 PJ=476.6e-6 m=1
	xi0 (vssa net69) prim_nd AREA=1e-12 PJ=4e-6 m=1
	xi3 (net51 vdda) prim_pd AREA=6.3e-09 PJ=9.6e-05 m=1
	xr0 (vssa vdda net51) prim_rdiffp l=2.1e-6 w=700e-9 m=1
	xr1 (vdda vdda net69) prim_rdiffp l=2.1e-6 w=700e-9 m=1
	xcc01 (net12 out) prim_cpoly c=1p m=1
	mnm12 (net13 net56 vssa vssa) nmos1 l=180n w=1u m=1
	mnm11 (net56 net56 vssa vssa) nmos1 l=180n w=1u m=1
	mnb02 (net27 net27 net21 vssa) nmos1 l=180n w=1u m=1
	mnpd1 (net21 xpd vssa vssa) nmos1 l=2.7e-07n w=1.6e-06u m=1
	mn001 (out net13 vssa vssa) nmos1 l=180n w=1u m=1
	mnpd2 (net13 pd vssa vssa) nmos1 l=2.9e-07n w=6.9e-07u m=1
	mnc01 (net13 net69 net12 vssa) nmos1 l=180n w=1u m=1
	mpb02 (net27 net51 net158 vdda) pmos1 l=180n w=1u m=1
	mppd1 (net158 xpd vdda vdda) pmos1 l=180n w=1u m=1
	mps11 (net31 net158 vdda vdda) pmos1 l=1.5e-07n w=8.0e-07u m=1
	mpd11 (net56 inn net31 net31) pmos1 l=180n w=1u m=1
	mp001 (out net158 vdda vdda) pmos1 l=180n w=1u m=1
	mpd12 (net13 inp net31 net31) pmos1 l=180n w=1u m=1
	mpb01 (net158 net158 vdda vdda) pmos1 l=180n w=1u m=1
ends OPAMP1_variant597

subckt OPAMP1_variant598 inn inp out pd xpd vdda vssa
	xd1 (vssa vdda) prim_nwd AREA=6.13907e-9 PJ=476.6e-6 m=1
	xi0 (vssa net69) prim_nd AREA=1e-12 PJ=4e-6 m=1
	xi3 (net51 vdda) prim_pd AREA=790e-15 PJ=3.3e-6 m=1
	xr0 (vssa vdda net51) prim_rdiffp l=2.1e-6 w=700e-9 m=1
	xr1 (vdda vdda net69) prim_rdiffp l=2.1e-6 w=700e-9 m=1
	xcc01 (net12 out) prim_cpoly c=1p m=1
	mnm12 (net13 net56 vssa vssa) nmos1 l=180n w=1u m=1
	mnm11 (net56 net56 vssa vssa) nmos1 l=1.8e-07n w=1.5e-06u m=1
	mnb02 (net27 net27 net21 vssa) nmos1 l=180n w=1u m=1
	mnpd1 (net21 xpd vssa vssa) nmos1 l=180n w=1u m=1
	mn001 (out net13 vssa vssa) nmos1 l=1.8e-07n w=1.0e-06u m=1
	mnpd2 (net13 pd vssa vssa) nmos1 l=180n w=1u m=1
	mnc01 (net13 net69 net12 vssa) nmos1 l=180n w=1u m=1
	mpb02 (net27 net51 net158 vdda) pmos1 l=180n w=1u m=1
	mppd1 (net158 xpd vdda vdda) pmos1 l=180n w=1u m=1
	mps11 (net31 net158 vdda vdda) pmos1 l=180n w=1u m=1
	mpd11 (net56 inn net31 net31) pmos1 l=180n w=1u m=1
	mp001 (out net158 vdda vdda) pmos1 l=180n w=1u m=1
	mpd12 (net13 inp net31 net31) pmos1 l=180n w=1u m=1
	mpb01 (net158 net158 vdda vdda) pmos1 l=180n w=1u m=1
ends OPAMP1_variant598

subckt OPAMP1_variant599 inn inp out pd xpd vdda vssa
	xd1 (vssa vdda) prim_nwd AREA=6.13907e-9 PJ=476.6e-6 m=1
	xi0 (vssa net69) prim_nd AREA=1e-12 PJ=4e-6 m=1
	xi3 (net51 vdda) prim_pd AREA=790e-15 PJ=3.3e-6 m=1
	xr0 (vssa vdda net51) prim_rdiffp l=2.1e-6 w=700e-9 m=1
	xr1 (vdda vdda net69) prim_rdiffp l=2.1e-6 w=700e-9 m=1
	xcc01 (net12 out) prim_cpoly c=1p m=1
	mnm12 (net13 net56 vssa vssa) nmos1 l=180n w=1u m=1
	mnm11 (net56 net56 vssa vssa) nmos1 l=180n w=1u m=1
	mnb02 (net27 net27 net21 vssa) nmos1 l=180n w=1u m=1
	mnpd1 (net21 xpd vssa vssa) nmos1 l=1.9e-07n w=7.5e-07u m=1
	mn001 (out net13 vssa vssa) nmos1 l=180n w=1u m=1
	mnpd2 (net13 pd vssa vssa) nmos1 l=180n w=1u m=1
	mnc01 (net13 net69 net12 vssa) nmos1 l=180n w=1u m=1
	mpb02 (net27 net51 net158 vdda) pmos1 l=1.9e-07n w=6.8e-07u m=1
	mppd1 (net158 xpd vdda vdda) pmos1 l=180n w=1u m=1
	mps11 (net31 net158 vdda vdda) pmos1 l=2.9e-07n w=1.8e-06u m=1
	mpd11 (net56 inn net31 net31) pmos1 l=180n w=1u m=1
	mp001 (out net158 vdda vdda) pmos1 l=180n w=1u m=1
	mpd12 (net13 inp net31 net31) pmos1 l=180n w=1u m=1
	mpb01 (net158 net158 vdda vdda) pmos1 l=1.1e-07n w=1.7e-06u m=1
ends OPAMP1_variant599

subckt OPAMP1_variant600 inn inp out pd xpd vdda vssa
	xd1 (vssa vdda) prim_nwd AREA=6.13907e-9 PJ=476.6e-6 m=1
	xi0 (vssa net69) prim_nd AREA=1e-12 PJ=4e-6 m=1
	xi3 (net51 vdda) prim_pd AREA=790e-15 PJ=3.3e-6 m=1
	xr0 (vssa vdda net51) prim_rdiffp l=2.1e-6 w=700e-9 m=1
	xr1 (vdda vdda net69) prim_rdiffp l=2.1e-6 w=700e-9 m=1
	xcc01 (net12 out) prim_cpoly c=9.1e-13p m=1
	mnm12 (net13 net56 vssa vssa) nmos1 l=180n w=1u m=1
	mnm11 (net56 net56 vssa vssa) nmos1 l=180n w=1u m=1
	mnb02 (net27 net27 net21 vssa) nmos1 l=180n w=1u m=1
	mnpd1 (net21 xpd vssa vssa) nmos1 l=2.3e-07n w=1.5e-06u m=1
	mn001 (out net13 vssa vssa) nmos1 l=180n w=1u m=1
	mnpd2 (net13 pd vssa vssa) nmos1 l=180n w=1u m=1
	mnc01 (net13 net69 net12 vssa) nmos1 l=180n w=1u m=1
	mpb02 (net27 net51 net158 vdda) pmos1 l=1.4e-07n w=9.2e-07u m=1
	mppd1 (net158 xpd vdda vdda) pmos1 l=180n w=1u m=1
	mps11 (net31 net158 vdda vdda) pmos1 l=180n w=1u m=1
	mpd11 (net56 inn net31 net31) pmos1 l=180n w=1u m=1
	mp001 (out net158 vdda vdda) pmos1 l=180n w=1u m=1
	mpd12 (net13 inp net31 net31) pmos1 l=2.5e-07n w=8.2e-07u m=1
	mpb01 (net158 net158 vdda vdda) pmos1 l=2.5e-07n w=1.3e-06u m=1
ends OPAMP1_variant600

subckt OPAMP1_variant601 inn inp out pd xpd vdda vssa
	xd1 (vssa vdda) prim_nwd AREA=6.13907e-9 PJ=476.6e-6 m=1
	xi0 (vssa net69) prim_nd AREA=1e-12 PJ=4e-6 m=1
	xi3 (net51 vdda) prim_pd AREA=790e-15 PJ=3.3e-6 m=1
	xr0 (vssa vdda net51) prim_rdiffp l=2.1e-6 w=700e-9 m=1
	xr1 (vdda vdda net69) prim_rdiffp l=2.1e-6 w=700e-9 m=1
	xcc01 (net12 out) prim_cpoly c=1p m=1
	mnm12 (net13 net56 vssa vssa) nmos1 l=1.8e-07n w=1.1e-06u m=1
	mnm11 (net56 net56 vssa vssa) nmos1 l=180n w=1u m=1
	mnb02 (net27 net27 net21 vssa) nmos1 l=180n w=1u m=1
	mnpd1 (net21 xpd vssa vssa) nmos1 l=2.9e-07n w=1.9e-06u m=1
	mn001 (out net13 vssa vssa) nmos1 l=2.3e-07n w=8.6e-07u m=1
	mnpd2 (net13 pd vssa vssa) nmos1 l=180n w=1u m=1
	mnc01 (net13 net69 net12 vssa) nmos1 l=180n w=1u m=1
	mpb02 (net27 net51 net158 vdda) pmos1 l=180n w=1u m=1
	mppd1 (net158 xpd vdda vdda) pmos1 l=180n w=1u m=1
	mps11 (net31 net158 vdda vdda) pmos1 l=180n w=1u m=1
	mpd11 (net56 inn net31 net31) pmos1 l=180n w=1u m=1
	mp001 (out net158 vdda vdda) pmos1 l=2.5e-07n w=5.1e-07u m=1
	mpd12 (net13 inp net31 net31) pmos1 l=180n w=1u m=1
	mpb01 (net158 net158 vdda vdda) pmos1 l=2.5e-07n w=1.3e-06u m=1
ends OPAMP1_variant601

subckt OPAMP1_variant602 inn inp out pd xpd vdda vssa
	xd1 (vssa vdda) prim_nwd AREA=6.13907e-9 PJ=476.6e-6 m=1
	xi0 (vssa net69) prim_nd AREA=1e-12 PJ=4e-6 m=1
	xi3 (net51 vdda) prim_pd AREA=790e-15 PJ=3.3e-6 m=1
	xr0 (vssa vdda net51) prim_rdiffp l=2.1e-6 w=700e-9 m=1
	xr1 (vdda vdda net69) prim_rdiffp l=2.1e-6 w=700e-9 m=1
	xcc01 (net12 out) prim_cpoly c=1p m=1
	mnm12 (net13 net56 vssa vssa) nmos1 l=180n w=1u m=1
	mnm11 (net56 net56 vssa vssa) nmos1 l=2.2e-07n w=1.8e-06u m=1
	mnb02 (net27 net27 net21 vssa) nmos1 l=180n w=1u m=1
	mnpd1 (net21 xpd vssa vssa) nmos1 l=180n w=1u m=1
	mn001 (out net13 vssa vssa) nmos1 l=180n w=1u m=1
	mnpd2 (net13 pd vssa vssa) nmos1 l=180n w=1u m=1
	mnc01 (net13 net69 net12 vssa) nmos1 l=180n w=1u m=1
	mpb02 (net27 net51 net158 vdda) pmos1 l=180n w=1u m=1
	mppd1 (net158 xpd vdda vdda) pmos1 l=180n w=1u m=1
	mps11 (net31 net158 vdda vdda) pmos1 l=2.1e-07n w=1.6e-06u m=1
	mpd11 (net56 inn net31 net31) pmos1 l=180n w=1u m=1
	mp001 (out net158 vdda vdda) pmos1 l=180n w=1u m=1
	mpd12 (net13 inp net31 net31) pmos1 l=180n w=1u m=1
	mpb01 (net158 net158 vdda vdda) pmos1 l=180n w=1u m=1
ends OPAMP1_variant602

subckt OPAMP1_variant603 inn inp out pd xpd vdda vssa
	xd1 (vssa vdda) prim_nwd AREA=6.13907e-9 PJ=476.6e-6 m=1
	xi0 (vssa net69) prim_nd AREA=1e-12 PJ=4e-6 m=1
	xi3 (net51 vdda) prim_pd AREA=790e-15 PJ=3.3e-6 m=1
	xr0 (vssa vdda net51) prim_rdiffp l=2.9e-07 w=8.4e-07 m=1
	xr1 (vdda vdda net69) prim_rdiffp l=2.1e-6 w=700e-9 m=1
	xcc01 (net12 out) prim_cpoly c=1p m=1
	mnm12 (net13 net56 vssa vssa) nmos1 l=180n w=1u m=1
	mnm11 (net56 net56 vssa vssa) nmos1 l=180n w=1u m=1
	mnb02 (net27 net27 net21 vssa) nmos1 l=180n w=1u m=1
	mnpd1 (net21 xpd vssa vssa) nmos1 l=1.7e-07n w=5.7e-07u m=1
	mn001 (out net13 vssa vssa) nmos1 l=180n w=1u m=1
	mnpd2 (net13 pd vssa vssa) nmos1 l=2.0e-07n w=7.3e-07u m=1
	mnc01 (net13 net69 net12 vssa) nmos1 l=2.2e-07n w=1.5e-06u m=1
	mpb02 (net27 net51 net158 vdda) pmos1 l=180n w=1u m=1
	mppd1 (net158 xpd vdda vdda) pmos1 l=180n w=1u m=1
	mps11 (net31 net158 vdda vdda) pmos1 l=180n w=1u m=1
	mpd11 (net56 inn net31 net31) pmos1 l=180n w=1u m=1
	mp001 (out net158 vdda vdda) pmos1 l=180n w=1u m=1
	mpd12 (net13 inp net31 net31) pmos1 l=180n w=1u m=1
	mpb01 (net158 net158 vdda vdda) pmos1 l=180n w=1u m=1
ends OPAMP1_variant603

subckt OPAMP1_variant604 inn inp out pd xpd vdda vssa
	xd1 (vssa vdda) prim_nwd AREA=6.13907e-9 PJ=476.6e-6 m=1
	xi0 (vssa net69) prim_nd AREA=1e-12 PJ=4e-6 m=1
	xi3 (net51 vdda) prim_pd AREA=790e-15 PJ=3.3e-6 m=1
	xr0 (vssa vdda net51) prim_rdiffp l=2.1e-6 w=700e-9 m=1
	xr1 (vdda vdda net69) prim_rdiffp l=2.1e-6 w=700e-9 m=1
	xcc01 (net12 out) prim_cpoly c=8.3e-13p m=1
	mnm12 (net13 net56 vssa vssa) nmos1 l=180n w=1u m=1
	mnm11 (net56 net56 vssa vssa) nmos1 l=180n w=1u m=1
	mnb02 (net27 net27 net21 vssa) nmos1 l=180n w=1u m=1
	mnpd1 (net21 xpd vssa vssa) nmos1 l=180n w=1u m=1
	mn001 (out net13 vssa vssa) nmos1 l=180n w=1u m=1
	mnpd2 (net13 pd vssa vssa) nmos1 l=1.4e-07n w=1.3e-06u m=1
	mnc01 (net13 net69 net12 vssa) nmos1 l=1.8e-07n w=1.5e-06u m=1
	mpb02 (net27 net51 net158 vdda) pmos1 l=2.1e-07n w=1.5e-06u m=1
	mppd1 (net158 xpd vdda vdda) pmos1 l=1.8e-07n w=5.6e-07u m=1
	mps11 (net31 net158 vdda vdda) pmos1 l=180n w=1u m=1
	mpd11 (net56 inn net31 net31) pmos1 l=180n w=1u m=1
	mp001 (out net158 vdda vdda) pmos1 l=180n w=1u m=1
	mpd12 (net13 inp net31 net31) pmos1 l=180n w=1u m=1
	mpb01 (net158 net158 vdda vdda) pmos1 l=180n w=1u m=1
ends OPAMP1_variant604

subckt OPAMP1_variant605 inn inp out pd xpd vdda vssa
	xd1 (vssa vdda) prim_nwd AREA=6.13907e-9 PJ=476.6e-6 m=1
	xi0 (vssa net69) prim_nd AREA=1e-12 PJ=4e-6 m=1
	xi3 (net51 vdda) prim_pd AREA=8.5e-09 PJ=4.7e-05 m=1
	xr0 (vssa vdda net51) prim_rdiffp l=2.1e-6 w=700e-9 m=1
	xr1 (vdda vdda net69) prim_rdiffp l=2.1e-6 w=700e-9 m=1
	xcc01 (net12 out) prim_cpoly c=1p m=1
	mnm12 (net13 net56 vssa vssa) nmos1 l=1.6e-07n w=1.2e-06u m=1
	mnm11 (net56 net56 vssa vssa) nmos1 l=180n w=1u m=1
	mnb02 (net27 net27 net21 vssa) nmos1 l=180n w=1u m=1
	mnpd1 (net21 xpd vssa vssa) nmos1 l=180n w=1u m=1
	mn001 (out net13 vssa vssa) nmos1 l=180n w=1u m=1
	mnpd2 (net13 pd vssa vssa) nmos1 l=180n w=1u m=1
	mnc01 (net13 net69 net12 vssa) nmos1 l=180n w=1u m=1
	mpb02 (net27 net51 net158 vdda) pmos1 l=180n w=1u m=1
	mppd1 (net158 xpd vdda vdda) pmos1 l=180n w=1u m=1
	mps11 (net31 net158 vdda vdda) pmos1 l=180n w=1u m=1
	mpd11 (net56 inn net31 net31) pmos1 l=180n w=1u m=1
	mp001 (out net158 vdda vdda) pmos1 l=180n w=1u m=1
	mpd12 (net13 inp net31 net31) pmos1 l=180n w=1u m=1
	mpb01 (net158 net158 vdda vdda) pmos1 l=180n w=1u m=1
ends OPAMP1_variant605

subckt OPAMP1_variant606 inn inp out pd xpd vdda vssa
	xd1 (vssa vdda) prim_nwd AREA=6.13907e-9 PJ=476.6e-6 m=1
	xi0 (vssa net69) prim_nd AREA=4.7e-09 PJ=4.8e-05 m=1
	xi3 (net51 vdda) prim_pd AREA=7.0e-10 PJ=7.4e-05 m=1
	xr0 (vssa vdda net51) prim_rdiffp l=2.1e-6 w=700e-9 m=1
	xr1 (vdda vdda net69) prim_rdiffp l=2.1e-6 w=700e-9 m=1
	xcc01 (net12 out) prim_cpoly c=1p m=1
	mnm12 (net13 net56 vssa vssa) nmos1 l=180n w=1u m=1
	mnm11 (net56 net56 vssa vssa) nmos1 l=180n w=1u m=1
	mnb02 (net27 net27 net21 vssa) nmos1 l=180n w=1u m=1
	mnpd1 (net21 xpd vssa vssa) nmos1 l=180n w=1u m=1
	mn001 (out net13 vssa vssa) nmos1 l=180n w=1u m=1
	mnpd2 (net13 pd vssa vssa) nmos1 l=180n w=1u m=1
	mnc01 (net13 net69 net12 vssa) nmos1 l=1.3e-07n w=1.8e-06u m=1
	mpb02 (net27 net51 net158 vdda) pmos1 l=180n w=1u m=1
	mppd1 (net158 xpd vdda vdda) pmos1 l=180n w=1u m=1
	mps11 (net31 net158 vdda vdda) pmos1 l=180n w=1u m=1
	mpd11 (net56 inn net31 net31) pmos1 l=180n w=1u m=1
	mp001 (out net158 vdda vdda) pmos1 l=180n w=1u m=1
	mpd12 (net13 inp net31 net31) pmos1 l=2.6e-07n w=1.9e-06u m=1
	mpb01 (net158 net158 vdda vdda) pmos1 l=180n w=1u m=1
ends OPAMP1_variant606

subckt OPAMP1_variant607 inn inp out pd xpd vdda vssa
	xd1 (vssa vdda) prim_nwd AREA=6.13907e-9 PJ=476.6e-6 m=1
	xi0 (vssa net69) prim_nd AREA=1e-12 PJ=4e-6 m=1
	xi3 (net51 vdda) prim_pd AREA=790e-15 PJ=3.3e-6 m=1
	xr0 (vssa vdda net51) prim_rdiffp l=2.1e-6 w=700e-9 m=1
	xr1 (vdda vdda net69) prim_rdiffp l=1.8e-07 w=1.2e-06 m=1
	xcc01 (net12 out) prim_cpoly c=1p m=1
	mnm12 (net13 net56 vssa vssa) nmos1 l=2.4e-07n w=1.2e-06u m=1
	mnm11 (net56 net56 vssa vssa) nmos1 l=180n w=1u m=1
	mnb02 (net27 net27 net21 vssa) nmos1 l=180n w=1u m=1
	mnpd1 (net21 xpd vssa vssa) nmos1 l=180n w=1u m=1
	mn001 (out net13 vssa vssa) nmos1 l=180n w=1u m=1
	mnpd2 (net13 pd vssa vssa) nmos1 l=1.4e-07n w=1.4e-06u m=1
	mnc01 (net13 net69 net12 vssa) nmos1 l=180n w=1u m=1
	mpb02 (net27 net51 net158 vdda) pmos1 l=180n w=1u m=1
	mppd1 (net158 xpd vdda vdda) pmos1 l=180n w=1u m=1
	mps11 (net31 net158 vdda vdda) pmos1 l=180n w=1u m=1
	mpd11 (net56 inn net31 net31) pmos1 l=180n w=1u m=1
	mp001 (out net158 vdda vdda) pmos1 l=180n w=1u m=1
	mpd12 (net13 inp net31 net31) pmos1 l=180n w=1u m=1
	mpb01 (net158 net158 vdda vdda) pmos1 l=180n w=1u m=1
ends OPAMP1_variant607

subckt OPAMP1_variant608 inn inp out pd xpd vdda vssa
	xd1 (vssa vdda) prim_nwd AREA=6.13907e-9 PJ=476.6e-6 m=1
	xi0 (vssa net69) prim_nd AREA=1e-12 PJ=4e-6 m=1
	xi3 (net51 vdda) prim_pd AREA=790e-15 PJ=3.3e-6 m=1
	xr0 (vssa vdda net51) prim_rdiffp l=1.3e-07 w=7.4e-07 m=1
	xr1 (vdda vdda net69) prim_rdiffp l=2.1e-6 w=700e-9 m=1
	xcc01 (net12 out) prim_cpoly c=1p m=1
	mnm12 (net13 net56 vssa vssa) nmos1 l=180n w=1u m=1
	mnm11 (net56 net56 vssa vssa) nmos1 l=180n w=1u m=1
	mnb02 (net27 net27 net21 vssa) nmos1 l=180n w=1u m=1
	mnpd1 (net21 xpd vssa vssa) nmos1 l=2.2e-07n w=1.6e-06u m=1
	mn001 (out net13 vssa vssa) nmos1 l=180n w=1u m=1
	mnpd2 (net13 pd vssa vssa) nmos1 l=180n w=1u m=1
	mnc01 (net13 net69 net12 vssa) nmos1 l=180n w=1u m=1
	mpb02 (net27 net51 net158 vdda) pmos1 l=180n w=1u m=1
	mppd1 (net158 xpd vdda vdda) pmos1 l=180n w=1u m=1
	mps11 (net31 net158 vdda vdda) pmos1 l=180n w=1u m=1
	mpd11 (net56 inn net31 net31) pmos1 l=180n w=1u m=1
	mp001 (out net158 vdda vdda) pmos1 l=180n w=1u m=1
	mpd12 (net13 inp net31 net31) pmos1 l=180n w=1u m=1
	mpb01 (net158 net158 vdda vdda) pmos1 l=180n w=1u m=1
ends OPAMP1_variant608

subckt OPAMP1_variant609 inn inp out pd xpd vdda vssa
	xd1 (vssa vdda) prim_nwd AREA=6.13907e-9 PJ=476.6e-6 m=1
	xi0 (vssa net69) prim_nd AREA=1e-12 PJ=4e-6 m=1
	xi3 (net51 vdda) prim_pd AREA=790e-15 PJ=3.3e-6 m=1
	xr0 (vssa vdda net51) prim_rdiffp l=2.1e-6 w=700e-9 m=1
	xr1 (vdda vdda net69) prim_rdiffp l=2.1e-6 w=700e-9 m=1
	xcc01 (net12 out) prim_cpoly c=1p m=1
	mnm12 (net13 net56 vssa vssa) nmos1 l=180n w=1u m=1
	mnm11 (net56 net56 vssa vssa) nmos1 l=180n w=1u m=1
	mnb02 (net27 net27 net21 vssa) nmos1 l=180n w=1u m=1
	mnpd1 (net21 xpd vssa vssa) nmos1 l=180n w=1u m=1
	mn001 (out net13 vssa vssa) nmos1 l=2.7e-07n w=1.3e-06u m=1
	mnpd2 (net13 pd vssa vssa) nmos1 l=180n w=1u m=1
	mnc01 (net13 net69 net12 vssa) nmos1 l=2.1e-07n w=1.2e-06u m=1
	mpb02 (net27 net51 net158 vdda) pmos1 l=180n w=1u m=1
	mppd1 (net158 xpd vdda vdda) pmos1 l=180n w=1u m=1
	mps11 (net31 net158 vdda vdda) pmos1 l=180n w=1u m=1
	mpd11 (net56 inn net31 net31) pmos1 l=180n w=1u m=1
	mp001 (out net158 vdda vdda) pmos1 l=180n w=1u m=1
	mpd12 (net13 inp net31 net31) pmos1 l=180n w=1u m=1
	mpb01 (net158 net158 vdda vdda) pmos1 l=180n w=1u m=1
ends OPAMP1_variant609

subckt OPAMP1_variant610 inn inp out pd xpd vdda vssa
	xd1 (vssa vdda) prim_nwd AREA=6.13907e-9 PJ=476.6e-6 m=1
	xi0 (vssa net69) prim_nd AREA=1e-12 PJ=4e-6 m=1
	xi3 (net51 vdda) prim_pd AREA=790e-15 PJ=3.3e-6 m=1
	xr0 (vssa vdda net51) prim_rdiffp l=2.1e-6 w=700e-9 m=1
	xr1 (vdda vdda net69) prim_rdiffp l=2.1e-6 w=700e-9 m=1
	xcc01 (net12 out) prim_cpoly c=1p m=1
	mnm12 (net13 net56 vssa vssa) nmos1 l=180n w=1u m=1
	mnm11 (net56 net56 vssa vssa) nmos1 l=180n w=1u m=1
	mnb02 (net27 net27 net21 vssa) nmos1 l=180n w=1u m=1
	mnpd1 (net21 xpd vssa vssa) nmos1 l=180n w=1u m=1
	mn001 (out net13 vssa vssa) nmos1 l=180n w=1u m=1
	mnpd2 (net13 pd vssa vssa) nmos1 l=180n w=1u m=1
	mnc01 (net13 net69 net12 vssa) nmos1 l=1.2e-07n w=7.3e-07u m=1
	mpb02 (net27 net51 net158 vdda) pmos1 l=180n w=1u m=1
	mppd1 (net158 xpd vdda vdda) pmos1 l=1.3e-07n w=8.4e-07u m=1
	mps11 (net31 net158 vdda vdda) pmos1 l=180n w=1u m=1
	mpd11 (net56 inn net31 net31) pmos1 l=180n w=1u m=1
	mp001 (out net158 vdda vdda) pmos1 l=180n w=1u m=1
	mpd12 (net13 inp net31 net31) pmos1 l=180n w=1u m=1
	mpb01 (net158 net158 vdda vdda) pmos1 l=2.9e-07n w=1.8e-06u m=1
ends OPAMP1_variant610

subckt OPAMP1_variant611 inn inp out pd xpd vdda vssa
	xd1 (vssa vdda) prim_nwd AREA=6.13907e-9 PJ=476.6e-6 m=1
	xi0 (vssa net69) prim_nd AREA=1e-12 PJ=4e-6 m=1
	xi3 (net51 vdda) prim_pd AREA=790e-15 PJ=3.3e-6 m=1
	xr0 (vssa vdda net51) prim_rdiffp l=2.1e-6 w=700e-9 m=1
	xr1 (vdda vdda net69) prim_rdiffp l=2.6e-07 w=7.5e-07 m=1
	xcc01 (net12 out) prim_cpoly c=1p m=1
	mnm12 (net13 net56 vssa vssa) nmos1 l=180n w=1u m=1
	mnm11 (net56 net56 vssa vssa) nmos1 l=180n w=1u m=1
	mnb02 (net27 net27 net21 vssa) nmos1 l=180n w=1u m=1
	mnpd1 (net21 xpd vssa vssa) nmos1 l=180n w=1u m=1
	mn001 (out net13 vssa vssa) nmos1 l=180n w=1u m=1
	mnpd2 (net13 pd vssa vssa) nmos1 l=2.4e-07n w=1.5e-06u m=1
	mnc01 (net13 net69 net12 vssa) nmos1 l=180n w=1u m=1
	mpb02 (net27 net51 net158 vdda) pmos1 l=180n w=1u m=1
	mppd1 (net158 xpd vdda vdda) pmos1 l=180n w=1u m=1
	mps11 (net31 net158 vdda vdda) pmos1 l=180n w=1u m=1
	mpd11 (net56 inn net31 net31) pmos1 l=1.1e-07n w=1.1e-06u m=1
	mp001 (out net158 vdda vdda) pmos1 l=180n w=1u m=1
	mpd12 (net13 inp net31 net31) pmos1 l=180n w=1u m=1
	mpb01 (net158 net158 vdda vdda) pmos1 l=2.5e-07n w=1.6e-06u m=1
ends OPAMP1_variant611

subckt OPAMP1_variant612 inn inp out pd xpd vdda vssa
	xd1 (vssa vdda) prim_nwd AREA=6.13907e-9 PJ=476.6e-6 m=1
	xi0 (vssa net69) prim_nd AREA=2.7e-09 PJ=7.7e-05 m=1
	xi3 (net51 vdda) prim_pd AREA=790e-15 PJ=3.3e-6 m=1
	xr0 (vssa vdda net51) prim_rdiffp l=2.1e-6 w=700e-9 m=1
	xr1 (vdda vdda net69) prim_rdiffp l=2.1e-6 w=700e-9 m=1
	xcc01 (net12 out) prim_cpoly c=1p m=1
	mnm12 (net13 net56 vssa vssa) nmos1 l=180n w=1u m=1
	mnm11 (net56 net56 vssa vssa) nmos1 l=180n w=1u m=1
	mnb02 (net27 net27 net21 vssa) nmos1 l=2.3e-07n w=1.4e-06u m=1
	mnpd1 (net21 xpd vssa vssa) nmos1 l=180n w=1u m=1
	mn001 (out net13 vssa vssa) nmos1 l=180n w=1u m=1
	mnpd2 (net13 pd vssa vssa) nmos1 l=180n w=1u m=1
	mnc01 (net13 net69 net12 vssa) nmos1 l=180n w=1u m=1
	mpb02 (net27 net51 net158 vdda) pmos1 l=180n w=1u m=1
	mppd1 (net158 xpd vdda vdda) pmos1 l=180n w=1u m=1
	mps11 (net31 net158 vdda vdda) pmos1 l=180n w=1u m=1
	mpd11 (net56 inn net31 net31) pmos1 l=180n w=1u m=1
	mp001 (out net158 vdda vdda) pmos1 l=180n w=1u m=1
	mpd12 (net13 inp net31 net31) pmos1 l=180n w=1u m=1
	mpb01 (net158 net158 vdda vdda) pmos1 l=2.8e-07n w=8.5e-07u m=1
ends OPAMP1_variant612

subckt OPAMP1_variant613 inn inp out pd xpd vdda vssa
	xd1 (vssa vdda) prim_nwd AREA=6.13907e-9 PJ=476.6e-6 m=1
	xi0 (vssa net69) prim_nd AREA=1e-12 PJ=4e-6 m=1
	xi3 (net51 vdda) prim_pd AREA=790e-15 PJ=3.3e-6 m=1
	xr0 (vssa vdda net51) prim_rdiffp l=2.1e-6 w=700e-9 m=1
	xr1 (vdda vdda net69) prim_rdiffp l=2.1e-6 w=700e-9 m=1
	xcc01 (net12 out) prim_cpoly c=1p m=1
	mnm12 (net13 net56 vssa vssa) nmos1 l=180n w=1u m=1
	mnm11 (net56 net56 vssa vssa) nmos1 l=180n w=1u m=1
	mnb02 (net27 net27 net21 vssa) nmos1 l=180n w=1u m=1
	mnpd1 (net21 xpd vssa vssa) nmos1 l=180n w=1u m=1
	mn001 (out net13 vssa vssa) nmos1 l=180n w=1u m=1
	mnpd2 (net13 pd vssa vssa) nmos1 l=180n w=1u m=1
	mnc01 (net13 net69 net12 vssa) nmos1 l=2.2e-07n w=1.4e-06u m=1
	mpb02 (net27 net51 net158 vdda) pmos1 l=180n w=1u m=1
	mppd1 (net158 xpd vdda vdda) pmos1 l=180n w=1u m=1
	mps11 (net31 net158 vdda vdda) pmos1 l=180n w=1u m=1
	mpd11 (net56 inn net31 net31) pmos1 l=180n w=1u m=1
	mp001 (out net158 vdda vdda) pmos1 l=180n w=1u m=1
	mpd12 (net13 inp net31 net31) pmos1 l=2.2e-07n w=1.2e-06u m=1
	mpb01 (net158 net158 vdda vdda) pmos1 l=180n w=1u m=1
ends OPAMP1_variant613

subckt OPAMP1_variant614 inn inp out pd xpd vdda vssa
	xd1 (vssa vdda) prim_nwd AREA=6.13907e-9 PJ=476.6e-6 m=1
	xi0 (vssa net69) prim_nd AREA=1e-12 PJ=4e-6 m=1
	xi3 (net51 vdda) prim_pd AREA=790e-15 PJ=3.3e-6 m=1
	xr0 (vssa vdda net51) prim_rdiffp l=2.1e-6 w=700e-9 m=1
	xr1 (vdda vdda net69) prim_rdiffp l=2.1e-6 w=700e-9 m=1
	xcc01 (net12 out) prim_cpoly c=1p m=1
	mnm12 (net13 net56 vssa vssa) nmos1 l=180n w=1u m=1
	mnm11 (net56 net56 vssa vssa) nmos1 l=180n w=1u m=1
	mnb02 (net27 net27 net21 vssa) nmos1 l=2.6e-07n w=1.4e-06u m=1
	mnpd1 (net21 xpd vssa vssa) nmos1 l=1.8e-07n w=1.9e-06u m=1
	mn001 (out net13 vssa vssa) nmos1 l=180n w=1u m=1
	mnpd2 (net13 pd vssa vssa) nmos1 l=180n w=1u m=1
	mnc01 (net13 net69 net12 vssa) nmos1 l=180n w=1u m=1
	mpb02 (net27 net51 net158 vdda) pmos1 l=180n w=1u m=1
	mppd1 (net158 xpd vdda vdda) pmos1 l=2.5e-07n w=6.1e-07u m=1
	mps11 (net31 net158 vdda vdda) pmos1 l=180n w=1u m=1
	mpd11 (net56 inn net31 net31) pmos1 l=180n w=1u m=1
	mp001 (out net158 vdda vdda) pmos1 l=180n w=1u m=1
	mpd12 (net13 inp net31 net31) pmos1 l=1.5e-07n w=1.3e-06u m=1
	mpb01 (net158 net158 vdda vdda) pmos1 l=180n w=1u m=1
ends OPAMP1_variant614

subckt OPAMP1_variant615 inn inp out pd xpd vdda vssa
	xd1 (vssa vdda) prim_nwd AREA=6.13907e-9 PJ=476.6e-6 m=1
	xi0 (vssa net69) prim_nd AREA=1e-12 PJ=4e-6 m=1
	xi3 (net51 vdda) prim_pd AREA=790e-15 PJ=3.3e-6 m=1
	xr0 (vssa vdda net51) prim_rdiffp l=2.1e-6 w=700e-9 m=1
	xr1 (vdda vdda net69) prim_rdiffp l=1.8e-07 w=5.9e-07 m=1
	xcc01 (net12 out) prim_cpoly c=1p m=1
	mnm12 (net13 net56 vssa vssa) nmos1 l=180n w=1u m=1
	mnm11 (net56 net56 vssa vssa) nmos1 l=180n w=1u m=1
	mnb02 (net27 net27 net21 vssa) nmos1 l=180n w=1u m=1
	mnpd1 (net21 xpd vssa vssa) nmos1 l=180n w=1u m=1
	mn001 (out net13 vssa vssa) nmos1 l=180n w=1u m=1
	mnpd2 (net13 pd vssa vssa) nmos1 l=180n w=1u m=1
	mnc01 (net13 net69 net12 vssa) nmos1 l=3.0e-07n w=1.7e-06u m=1
	mpb02 (net27 net51 net158 vdda) pmos1 l=180n w=1u m=1
	mppd1 (net158 xpd vdda vdda) pmos1 l=2.2e-07n w=1.4e-06u m=1
	mps11 (net31 net158 vdda vdda) pmos1 l=180n w=1u m=1
	mpd11 (net56 inn net31 net31) pmos1 l=2.6e-07n w=1.3e-06u m=1
	mp001 (out net158 vdda vdda) pmos1 l=180n w=1u m=1
	mpd12 (net13 inp net31 net31) pmos1 l=180n w=1u m=1
	mpb01 (net158 net158 vdda vdda) pmos1 l=180n w=1u m=1
ends OPAMP1_variant615

subckt OPAMP1_variant616 inn inp out pd xpd vdda vssa
	xd1 (vssa vdda) prim_nwd AREA=6.13907e-9 PJ=476.6e-6 m=1
	xi0 (vssa net69) prim_nd AREA=4.0e-09 PJ=8.6e-05 m=1
	xi3 (net51 vdda) prim_pd AREA=790e-15 PJ=3.3e-6 m=1
	xr0 (vssa vdda net51) prim_rdiffp l=2.1e-6 w=700e-9 m=1
	xr1 (vdda vdda net69) prim_rdiffp l=2.1e-6 w=700e-9 m=1
	xcc01 (net12 out) prim_cpoly c=1p m=1
	mnm12 (net13 net56 vssa vssa) nmos1 l=180n w=1u m=1
	mnm11 (net56 net56 vssa vssa) nmos1 l=180n w=1u m=1
	mnb02 (net27 net27 net21 vssa) nmos1 l=180n w=1u m=1
	mnpd1 (net21 xpd vssa vssa) nmos1 l=1.7e-07n w=7.3e-07u m=1
	mn001 (out net13 vssa vssa) nmos1 l=180n w=1u m=1
	mnpd2 (net13 pd vssa vssa) nmos1 l=180n w=1u m=1
	mnc01 (net13 net69 net12 vssa) nmos1 l=2.1e-07n w=1.3e-06u m=1
	mpb02 (net27 net51 net158 vdda) pmos1 l=180n w=1u m=1
	mppd1 (net158 xpd vdda vdda) pmos1 l=180n w=1u m=1
	mps11 (net31 net158 vdda vdda) pmos1 l=180n w=1u m=1
	mpd11 (net56 inn net31 net31) pmos1 l=180n w=1u m=1
	mp001 (out net158 vdda vdda) pmos1 l=180n w=1u m=1
	mpd12 (net13 inp net31 net31) pmos1 l=180n w=1u m=1
	mpb01 (net158 net158 vdda vdda) pmos1 l=180n w=1u m=1
ends OPAMP1_variant616

subckt OPAMP1_variant617 inn inp out pd xpd vdda vssa
	xd1 (vssa vdda) prim_nwd AREA=6.13907e-9 PJ=476.6e-6 m=1
	xi0 (vssa net69) prim_nd AREA=1e-12 PJ=4e-6 m=1
	xi3 (net51 vdda) prim_pd AREA=9.2e-09 PJ=1.5e-05 m=1
	xr0 (vssa vdda net51) prim_rdiffp l=2.1e-6 w=700e-9 m=1
	xr1 (vdda vdda net69) prim_rdiffp l=2.1e-6 w=700e-9 m=1
	xcc01 (net12 out) prim_cpoly c=1.5e-12p m=1
	mnm12 (net13 net56 vssa vssa) nmos1 l=180n w=1u m=1
	mnm11 (net56 net56 vssa vssa) nmos1 l=180n w=1u m=1
	mnb02 (net27 net27 net21 vssa) nmos1 l=180n w=1u m=1
	mnpd1 (net21 xpd vssa vssa) nmos1 l=180n w=1u m=1
	mn001 (out net13 vssa vssa) nmos1 l=180n w=1u m=1
	mnpd2 (net13 pd vssa vssa) nmos1 l=180n w=1u m=1
	mnc01 (net13 net69 net12 vssa) nmos1 l=180n w=1u m=1
	mpb02 (net27 net51 net158 vdda) pmos1 l=180n w=1u m=1
	mppd1 (net158 xpd vdda vdda) pmos1 l=180n w=1u m=1
	mps11 (net31 net158 vdda vdda) pmos1 l=180n w=1u m=1
	mpd11 (net56 inn net31 net31) pmos1 l=180n w=1u m=1
	mp001 (out net158 vdda vdda) pmos1 l=180n w=1u m=1
	mpd12 (net13 inp net31 net31) pmos1 l=180n w=1u m=1
	mpb01 (net158 net158 vdda vdda) pmos1 l=180n w=1u m=1
ends OPAMP1_variant617

subckt OPAMP1_variant618 inn inp out pd xpd vdda vssa
	xd1 (vssa vdda) prim_nwd AREA=6.13907e-9 PJ=476.6e-6 m=1
	xi0 (vssa net69) prim_nd AREA=1e-12 PJ=4e-6 m=1
	xi3 (net51 vdda) prim_pd AREA=790e-15 PJ=3.3e-6 m=1
	xr0 (vssa vdda net51) prim_rdiffp l=2.1e-6 w=700e-9 m=1
	xr1 (vdda vdda net69) prim_rdiffp l=2.7e-07 w=1.3e-06 m=1
	xcc01 (net12 out) prim_cpoly c=1p m=1
	mnm12 (net13 net56 vssa vssa) nmos1 l=180n w=1u m=1
	mnm11 (net56 net56 vssa vssa) nmos1 l=180n w=1u m=1
	mnb02 (net27 net27 net21 vssa) nmos1 l=180n w=1u m=1
	mnpd1 (net21 xpd vssa vssa) nmos1 l=180n w=1u m=1
	mn001 (out net13 vssa vssa) nmos1 l=180n w=1u m=1
	mnpd2 (net13 pd vssa vssa) nmos1 l=2.7e-07n w=1.2e-06u m=1
	mnc01 (net13 net69 net12 vssa) nmos1 l=180n w=1u m=1
	mpb02 (net27 net51 net158 vdda) pmos1 l=1.4e-07n w=9.3e-07u m=1
	mppd1 (net158 xpd vdda vdda) pmos1 l=180n w=1u m=1
	mps11 (net31 net158 vdda vdda) pmos1 l=180n w=1u m=1
	mpd11 (net56 inn net31 net31) pmos1 l=2.0e-07n w=1.0e-06u m=1
	mp001 (out net158 vdda vdda) pmos1 l=1.1e-07n w=7.2e-07u m=1
	mpd12 (net13 inp net31 net31) pmos1 l=180n w=1u m=1
	mpb01 (net158 net158 vdda vdda) pmos1 l=180n w=1u m=1
ends OPAMP1_variant618

subckt OPAMP1_variant619 inn inp out pd xpd vdda vssa
	xd1 (vssa vdda) prim_nwd AREA=6.13907e-9 PJ=476.6e-6 m=1
	xi0 (vssa net69) prim_nd AREA=1e-12 PJ=4e-6 m=1
	xi3 (net51 vdda) prim_pd AREA=790e-15 PJ=3.3e-6 m=1
	xr0 (vssa vdda net51) prim_rdiffp l=2.1e-6 w=700e-9 m=1
	xr1 (vdda vdda net69) prim_rdiffp l=2.1e-6 w=700e-9 m=1
	xcc01 (net12 out) prim_cpoly c=1p m=1
	mnm12 (net13 net56 vssa vssa) nmos1 l=180n w=1u m=1
	mnm11 (net56 net56 vssa vssa) nmos1 l=180n w=1u m=1
	mnb02 (net27 net27 net21 vssa) nmos1 l=180n w=1u m=1
	mnpd1 (net21 xpd vssa vssa) nmos1 l=180n w=1u m=1
	mn001 (out net13 vssa vssa) nmos1 l=180n w=1u m=1
	mnpd2 (net13 pd vssa vssa) nmos1 l=180n w=1u m=1
	mnc01 (net13 net69 net12 vssa) nmos1 l=180n w=1u m=1
	mpb02 (net27 net51 net158 vdda) pmos1 l=180n w=1u m=1
	mppd1 (net158 xpd vdda vdda) pmos1 l=180n w=1u m=1
	mps11 (net31 net158 vdda vdda) pmos1 l=180n w=1u m=1
	mpd11 (net56 inn net31 net31) pmos1 l=180n w=1u m=1
	mp001 (out net158 vdda vdda) pmos1 l=1.7e-07n w=2.0e-06u m=1
	mpd12 (net13 inp net31 net31) pmos1 l=180n w=1u m=1
	mpb01 (net158 net158 vdda vdda) pmos1 l=2.8e-07n w=8.3e-07u m=1
ends OPAMP1_variant619

subckt OPAMP1_variant620 inn inp out pd xpd vdda vssa
	xd1 (vssa vdda) prim_nwd AREA=2.4e-09 PJ=7.9e-05 m=1
	xi0 (vssa net69) prim_nd AREA=1e-12 PJ=4e-6 m=1
	xi3 (net51 vdda) prim_pd AREA=790e-15 PJ=3.3e-6 m=1
	xr0 (vssa vdda net51) prim_rdiffp l=2.1e-6 w=700e-9 m=1
	xr1 (vdda vdda net69) prim_rdiffp l=2.1e-6 w=700e-9 m=1
	xcc01 (net12 out) prim_cpoly c=1p m=1
	mnm12 (net13 net56 vssa vssa) nmos1 l=1.8e-07n w=1.7e-06u m=1
	mnm11 (net56 net56 vssa vssa) nmos1 l=180n w=1u m=1
	mnb02 (net27 net27 net21 vssa) nmos1 l=180n w=1u m=1
	mnpd1 (net21 xpd vssa vssa) nmos1 l=180n w=1u m=1
	mn001 (out net13 vssa vssa) nmos1 l=180n w=1u m=1
	mnpd2 (net13 pd vssa vssa) nmos1 l=180n w=1u m=1
	mnc01 (net13 net69 net12 vssa) nmos1 l=180n w=1u m=1
	mpb02 (net27 net51 net158 vdda) pmos1 l=180n w=1u m=1
	mppd1 (net158 xpd vdda vdda) pmos1 l=180n w=1u m=1
	mps11 (net31 net158 vdda vdda) pmos1 l=180n w=1u m=1
	mpd11 (net56 inn net31 net31) pmos1 l=180n w=1u m=1
	mp001 (out net158 vdda vdda) pmos1 l=180n w=1u m=1
	mpd12 (net13 inp net31 net31) pmos1 l=180n w=1u m=1
	mpb01 (net158 net158 vdda vdda) pmos1 l=180n w=1u m=1
ends OPAMP1_variant620

subckt OPAMP1_variant621 inn inp out pd xpd vdda vssa
	xd1 (vssa vdda) prim_nwd AREA=3.3e-09 PJ=6.9e-05 m=1
	xi0 (vssa net69) prim_nd AREA=1e-12 PJ=4e-6 m=1
	xi3 (net51 vdda) prim_pd AREA=790e-15 PJ=3.3e-6 m=1
	xr0 (vssa vdda net51) prim_rdiffp l=2.1e-6 w=700e-9 m=1
	xr1 (vdda vdda net69) prim_rdiffp l=2.1e-6 w=700e-9 m=1
	xcc01 (net12 out) prim_cpoly c=1p m=1
	mnm12 (net13 net56 vssa vssa) nmos1 l=180n w=1u m=1
	mnm11 (net56 net56 vssa vssa) nmos1 l=180n w=1u m=1
	mnb02 (net27 net27 net21 vssa) nmos1 l=180n w=1u m=1
	mnpd1 (net21 xpd vssa vssa) nmos1 l=180n w=1u m=1
	mn001 (out net13 vssa vssa) nmos1 l=180n w=1u m=1
	mnpd2 (net13 pd vssa vssa) nmos1 l=1.3e-07n w=5.7e-07u m=1
	mnc01 (net13 net69 net12 vssa) nmos1 l=180n w=1u m=1
	mpb02 (net27 net51 net158 vdda) pmos1 l=2.9e-07n w=1.6e-06u m=1
	mppd1 (net158 xpd vdda vdda) pmos1 l=180n w=1u m=1
	mps11 (net31 net158 vdda vdda) pmos1 l=2.4e-07n w=1.4e-06u m=1
	mpd11 (net56 inn net31 net31) pmos1 l=180n w=1u m=1
	mp001 (out net158 vdda vdda) pmos1 l=180n w=1u m=1
	mpd12 (net13 inp net31 net31) pmos1 l=180n w=1u m=1
	mpb01 (net158 net158 vdda vdda) pmos1 l=1.1e-07n w=1.7e-06u m=1
ends OPAMP1_variant621

subckt OPAMP1_variant622 inn inp out pd xpd vdda vssa
	xd1 (vssa vdda) prim_nwd AREA=3.6e-09 PJ=9.6e-05 m=1
	xi0 (vssa net69) prim_nd AREA=1e-12 PJ=4e-6 m=1
	xi3 (net51 vdda) prim_pd AREA=790e-15 PJ=3.3e-6 m=1
	xr0 (vssa vdda net51) prim_rdiffp l=2.1e-6 w=700e-9 m=1
	xr1 (vdda vdda net69) prim_rdiffp l=2.1e-6 w=700e-9 m=1
	xcc01 (net12 out) prim_cpoly c=1p m=1
	mnm12 (net13 net56 vssa vssa) nmos1 l=180n w=1u m=1
	mnm11 (net56 net56 vssa vssa) nmos1 l=180n w=1u m=1
	mnb02 (net27 net27 net21 vssa) nmos1 l=180n w=1u m=1
	mnpd1 (net21 xpd vssa vssa) nmos1 l=180n w=1u m=1
	mn001 (out net13 vssa vssa) nmos1 l=2.1e-07n w=1.0e-06u m=1
	mnpd2 (net13 pd vssa vssa) nmos1 l=180n w=1u m=1
	mnc01 (net13 net69 net12 vssa) nmos1 l=180n w=1u m=1
	mpb02 (net27 net51 net158 vdda) pmos1 l=180n w=1u m=1
	mppd1 (net158 xpd vdda vdda) pmos1 l=180n w=1u m=1
	mps11 (net31 net158 vdda vdda) pmos1 l=180n w=1u m=1
	mpd11 (net56 inn net31 net31) pmos1 l=180n w=1u m=1
	mp001 (out net158 vdda vdda) pmos1 l=1.2e-07n w=5.7e-07u m=1
	mpd12 (net13 inp net31 net31) pmos1 l=180n w=1u m=1
	mpb01 (net158 net158 vdda vdda) pmos1 l=2.3e-07n w=1.5e-06u m=1
ends OPAMP1_variant622

subckt OPAMP1_variant623 inn inp out pd xpd vdda vssa
	xd1 (vssa vdda) prim_nwd AREA=6.13907e-9 PJ=476.6e-6 m=1
	xi0 (vssa net69) prim_nd AREA=1e-12 PJ=4e-6 m=1
	xi3 (net51 vdda) prim_pd AREA=790e-15 PJ=3.3e-6 m=1
	xr0 (vssa vdda net51) prim_rdiffp l=2.1e-6 w=700e-9 m=1
	xr1 (vdda vdda net69) prim_rdiffp l=2.1e-6 w=700e-9 m=1
	xcc01 (net12 out) prim_cpoly c=1p m=1
	mnm12 (net13 net56 vssa vssa) nmos1 l=180n w=1u m=1
	mnm11 (net56 net56 vssa vssa) nmos1 l=180n w=1u m=1
	mnb02 (net27 net27 net21 vssa) nmos1 l=1.1e-07n w=5.1e-07u m=1
	mnpd1 (net21 xpd vssa vssa) nmos1 l=180n w=1u m=1
	mn001 (out net13 vssa vssa) nmos1 l=1.7e-07n w=2.0e-06u m=1
	mnpd2 (net13 pd vssa vssa) nmos1 l=2.3e-07n w=1.4e-06u m=1
	mnc01 (net13 net69 net12 vssa) nmos1 l=2.1e-07n w=1.8e-06u m=1
	mpb02 (net27 net51 net158 vdda) pmos1 l=180n w=1u m=1
	mppd1 (net158 xpd vdda vdda) pmos1 l=180n w=1u m=1
	mps11 (net31 net158 vdda vdda) pmos1 l=180n w=1u m=1
	mpd11 (net56 inn net31 net31) pmos1 l=180n w=1u m=1
	mp001 (out net158 vdda vdda) pmos1 l=180n w=1u m=1
	mpd12 (net13 inp net31 net31) pmos1 l=2.7e-07n w=9.3e-07u m=1
	mpb01 (net158 net158 vdda vdda) pmos1 l=180n w=1u m=1
ends OPAMP1_variant623

subckt OPAMP1_variant624 inn inp out pd xpd vdda vssa
	xd1 (vssa vdda) prim_nwd AREA=3.4e-09 PJ=6.3e-06 m=1
	xi0 (vssa net69) prim_nd AREA=1e-12 PJ=4e-6 m=1
	xi3 (net51 vdda) prim_pd AREA=790e-15 PJ=3.3e-6 m=1
	xr0 (vssa vdda net51) prim_rdiffp l=2.1e-6 w=700e-9 m=1
	xr1 (vdda vdda net69) prim_rdiffp l=2.1e-6 w=700e-9 m=1
	xcc01 (net12 out) prim_cpoly c=1p m=1
	mnm12 (net13 net56 vssa vssa) nmos1 l=180n w=1u m=1
	mnm11 (net56 net56 vssa vssa) nmos1 l=2.7e-07n w=8.3e-07u m=1
	mnb02 (net27 net27 net21 vssa) nmos1 l=1.9e-07n w=7.4e-07u m=1
	mnpd1 (net21 xpd vssa vssa) nmos1 l=180n w=1u m=1
	mn001 (out net13 vssa vssa) nmos1 l=180n w=1u m=1
	mnpd2 (net13 pd vssa vssa) nmos1 l=180n w=1u m=1
	mnc01 (net13 net69 net12 vssa) nmos1 l=1.9e-07n w=9.5e-07u m=1
	mpb02 (net27 net51 net158 vdda) pmos1 l=180n w=1u m=1
	mppd1 (net158 xpd vdda vdda) pmos1 l=2.9e-07n w=1.3e-06u m=1
	mps11 (net31 net158 vdda vdda) pmos1 l=180n w=1u m=1
	mpd11 (net56 inn net31 net31) pmos1 l=180n w=1u m=1
	mp001 (out net158 vdda vdda) pmos1 l=180n w=1u m=1
	mpd12 (net13 inp net31 net31) pmos1 l=180n w=1u m=1
	mpb01 (net158 net158 vdda vdda) pmos1 l=180n w=1u m=1
ends OPAMP1_variant624

subckt OPAMP1_variant625 inn inp out pd xpd vdda vssa
	xd1 (vssa vdda) prim_nwd AREA=6.13907e-9 PJ=476.6e-6 m=1
	xi0 (vssa net69) prim_nd AREA=1e-12 PJ=4e-6 m=1
	xi3 (net51 vdda) prim_pd AREA=4.1e-09 PJ=1.3e-06 m=1
	xr0 (vssa vdda net51) prim_rdiffp l=2.1e-6 w=700e-9 m=1
	xr1 (vdda vdda net69) prim_rdiffp l=2.1e-6 w=700e-9 m=1
	xcc01 (net12 out) prim_cpoly c=5.7e-13p m=1
	mnm12 (net13 net56 vssa vssa) nmos1 l=180n w=1u m=1
	mnm11 (net56 net56 vssa vssa) nmos1 l=1.0e-07n w=7.9e-07u m=1
	mnb02 (net27 net27 net21 vssa) nmos1 l=180n w=1u m=1
	mnpd1 (net21 xpd vssa vssa) nmos1 l=180n w=1u m=1
	mn001 (out net13 vssa vssa) nmos1 l=1.0e-07n w=1.0e-06u m=1
	mnpd2 (net13 pd vssa vssa) nmos1 l=2.1e-07n w=7.9e-07u m=1
	mnc01 (net13 net69 net12 vssa) nmos1 l=180n w=1u m=1
	mpb02 (net27 net51 net158 vdda) pmos1 l=180n w=1u m=1
	mppd1 (net158 xpd vdda vdda) pmos1 l=180n w=1u m=1
	mps11 (net31 net158 vdda vdda) pmos1 l=180n w=1u m=1
	mpd11 (net56 inn net31 net31) pmos1 l=180n w=1u m=1
	mp001 (out net158 vdda vdda) pmos1 l=180n w=1u m=1
	mpd12 (net13 inp net31 net31) pmos1 l=180n w=1u m=1
	mpb01 (net158 net158 vdda vdda) pmos1 l=180n w=1u m=1
ends OPAMP1_variant625

subckt OPAMP1_variant626 inn inp out pd xpd vdda vssa
	xd1 (vssa vdda) prim_nwd AREA=2.9e-09 PJ=6.9e-06 m=1
	xi0 (vssa net69) prim_nd AREA=1e-12 PJ=4e-6 m=1
	xi3 (net51 vdda) prim_pd AREA=790e-15 PJ=3.3e-6 m=1
	xr0 (vssa vdda net51) prim_rdiffp l=2.1e-6 w=700e-9 m=1
	xr1 (vdda vdda net69) prim_rdiffp l=2.8e-07 w=1.2e-06 m=1
	xcc01 (net12 out) prim_cpoly c=1p m=1
	mnm12 (net13 net56 vssa vssa) nmos1 l=180n w=1u m=1
	mnm11 (net56 net56 vssa vssa) nmos1 l=180n w=1u m=1
	mnb02 (net27 net27 net21 vssa) nmos1 l=180n w=1u m=1
	mnpd1 (net21 xpd vssa vssa) nmos1 l=180n w=1u m=1
	mn001 (out net13 vssa vssa) nmos1 l=180n w=1u m=1
	mnpd2 (net13 pd vssa vssa) nmos1 l=180n w=1u m=1
	mnc01 (net13 net69 net12 vssa) nmos1 l=180n w=1u m=1
	mpb02 (net27 net51 net158 vdda) pmos1 l=2.3e-07n w=1.3e-06u m=1
	mppd1 (net158 xpd vdda vdda) pmos1 l=2.8e-07n w=1.6e-06u m=1
	mps11 (net31 net158 vdda vdda) pmos1 l=180n w=1u m=1
	mpd11 (net56 inn net31 net31) pmos1 l=2.6e-07n w=9.2e-07u m=1
	mp001 (out net158 vdda vdda) pmos1 l=180n w=1u m=1
	mpd12 (net13 inp net31 net31) pmos1 l=180n w=1u m=1
	mpb01 (net158 net158 vdda vdda) pmos1 l=180n w=1u m=1
ends OPAMP1_variant626

subckt OPAMP1_variant627 inn inp out pd xpd vdda vssa
	xd1 (vssa vdda) prim_nwd AREA=6.13907e-9 PJ=476.6e-6 m=1
	xi0 (vssa net69) prim_nd AREA=1e-12 PJ=4e-6 m=1
	xi3 (net51 vdda) prim_pd AREA=790e-15 PJ=3.3e-6 m=1
	xr0 (vssa vdda net51) prim_rdiffp l=2.1e-6 w=700e-9 m=1
	xr1 (vdda vdda net69) prim_rdiffp l=2.1e-6 w=700e-9 m=1
	xcc01 (net12 out) prim_cpoly c=1.4e-12p m=1
	mnm12 (net13 net56 vssa vssa) nmos1 l=180n w=1u m=1
	mnm11 (net56 net56 vssa vssa) nmos1 l=180n w=1u m=1
	mnb02 (net27 net27 net21 vssa) nmos1 l=2.6e-07n w=1.3e-06u m=1
	mnpd1 (net21 xpd vssa vssa) nmos1 l=180n w=1u m=1
	mn001 (out net13 vssa vssa) nmos1 l=2.7e-07n w=5.7e-07u m=1
	mnpd2 (net13 pd vssa vssa) nmos1 l=180n w=1u m=1
	mnc01 (net13 net69 net12 vssa) nmos1 l=180n w=1u m=1
	mpb02 (net27 net51 net158 vdda) pmos1 l=180n w=1u m=1
	mppd1 (net158 xpd vdda vdda) pmos1 l=1.7e-07n w=1.4e-06u m=1
	mps11 (net31 net158 vdda vdda) pmos1 l=1.1e-07n w=7.8e-07u m=1
	mpd11 (net56 inn net31 net31) pmos1 l=180n w=1u m=1
	mp001 (out net158 vdda vdda) pmos1 l=180n w=1u m=1
	mpd12 (net13 inp net31 net31) pmos1 l=180n w=1u m=1
	mpb01 (net158 net158 vdda vdda) pmos1 l=180n w=1u m=1
ends OPAMP1_variant627

subckt OPAMP1_variant628 inn inp out pd xpd vdda vssa
	xd1 (vssa vdda) prim_nwd AREA=6.13907e-9 PJ=476.6e-6 m=1
	xi0 (vssa net69) prim_nd AREA=4.9e-09 PJ=4.8e-05 m=1
	xi3 (net51 vdda) prim_pd AREA=790e-15 PJ=3.3e-6 m=1
	xr0 (vssa vdda net51) prim_rdiffp l=2.1e-6 w=700e-9 m=1
	xr1 (vdda vdda net69) prim_rdiffp l=2.1e-6 w=700e-9 m=1
	xcc01 (net12 out) prim_cpoly c=1p m=1
	mnm12 (net13 net56 vssa vssa) nmos1 l=180n w=1u m=1
	mnm11 (net56 net56 vssa vssa) nmos1 l=180n w=1u m=1
	mnb02 (net27 net27 net21 vssa) nmos1 l=180n w=1u m=1
	mnpd1 (net21 xpd vssa vssa) nmos1 l=180n w=1u m=1
	mn001 (out net13 vssa vssa) nmos1 l=180n w=1u m=1
	mnpd2 (net13 pd vssa vssa) nmos1 l=180n w=1u m=1
	mnc01 (net13 net69 net12 vssa) nmos1 l=180n w=1u m=1
	mpb02 (net27 net51 net158 vdda) pmos1 l=2.9e-07n w=1.1e-06u m=1
	mppd1 (net158 xpd vdda vdda) pmos1 l=180n w=1u m=1
	mps11 (net31 net158 vdda vdda) pmos1 l=1.2e-07n w=1.3e-06u m=1
	mpd11 (net56 inn net31 net31) pmos1 l=180n w=1u m=1
	mp001 (out net158 vdda vdda) pmos1 l=1.4e-07n w=1.1e-06u m=1
	mpd12 (net13 inp net31 net31) pmos1 l=180n w=1u m=1
	mpb01 (net158 net158 vdda vdda) pmos1 l=180n w=1u m=1
ends OPAMP1_variant628

subckt OPAMP1_variant629 inn inp out pd xpd vdda vssa
	xd1 (vssa vdda) prim_nwd AREA=5.5e-09 PJ=6.1e-05 m=1
	xi0 (vssa net69) prim_nd AREA=1e-12 PJ=4e-6 m=1
	xi3 (net51 vdda) prim_pd AREA=6.5e-09 PJ=5.4e-05 m=1
	xr0 (vssa vdda net51) prim_rdiffp l=2.1e-6 w=700e-9 m=1
	xr1 (vdda vdda net69) prim_rdiffp l=1.2e-07 w=1.8e-06 m=1
	xcc01 (net12 out) prim_cpoly c=1p m=1
	mnm12 (net13 net56 vssa vssa) nmos1 l=180n w=1u m=1
	mnm11 (net56 net56 vssa vssa) nmos1 l=180n w=1u m=1
	mnb02 (net27 net27 net21 vssa) nmos1 l=180n w=1u m=1
	mnpd1 (net21 xpd vssa vssa) nmos1 l=180n w=1u m=1
	mn001 (out net13 vssa vssa) nmos1 l=180n w=1u m=1
	mnpd2 (net13 pd vssa vssa) nmos1 l=1.5e-07n w=7.7e-07u m=1
	mnc01 (net13 net69 net12 vssa) nmos1 l=180n w=1u m=1
	mpb02 (net27 net51 net158 vdda) pmos1 l=180n w=1u m=1
	mppd1 (net158 xpd vdda vdda) pmos1 l=180n w=1u m=1
	mps11 (net31 net158 vdda vdda) pmos1 l=180n w=1u m=1
	mpd11 (net56 inn net31 net31) pmos1 l=180n w=1u m=1
	mp001 (out net158 vdda vdda) pmos1 l=180n w=1u m=1
	mpd12 (net13 inp net31 net31) pmos1 l=180n w=1u m=1
	mpb01 (net158 net158 vdda vdda) pmos1 l=2.4e-07n w=1.8e-06u m=1
ends OPAMP1_variant629

subckt OPAMP1_variant630 inn inp out pd xpd vdda vssa
	xd1 (vssa vdda) prim_nwd AREA=6.13907e-9 PJ=476.6e-6 m=1
	xi0 (vssa net69) prim_nd AREA=1e-12 PJ=4e-6 m=1
	xi3 (net51 vdda) prim_pd AREA=790e-15 PJ=3.3e-6 m=1
	xr0 (vssa vdda net51) prim_rdiffp l=2.1e-6 w=700e-9 m=1
	xr1 (vdda vdda net69) prim_rdiffp l=2.1e-6 w=700e-9 m=1
	xcc01 (net12 out) prim_cpoly c=1p m=1
	mnm12 (net13 net56 vssa vssa) nmos1 l=180n w=1u m=1
	mnm11 (net56 net56 vssa vssa) nmos1 l=180n w=1u m=1
	mnb02 (net27 net27 net21 vssa) nmos1 l=1.5e-07n w=1.0e-06u m=1
	mnpd1 (net21 xpd vssa vssa) nmos1 l=180n w=1u m=1
	mn001 (out net13 vssa vssa) nmos1 l=180n w=1u m=1
	mnpd2 (net13 pd vssa vssa) nmos1 l=180n w=1u m=1
	mnc01 (net13 net69 net12 vssa) nmos1 l=180n w=1u m=1
	mpb02 (net27 net51 net158 vdda) pmos1 l=1.1e-07n w=1.6e-06u m=1
	mppd1 (net158 xpd vdda vdda) pmos1 l=2.3e-07n w=8.5e-07u m=1
	mps11 (net31 net158 vdda vdda) pmos1 l=180n w=1u m=1
	mpd11 (net56 inn net31 net31) pmos1 l=180n w=1u m=1
	mp001 (out net158 vdda vdda) pmos1 l=180n w=1u m=1
	mpd12 (net13 inp net31 net31) pmos1 l=180n w=1u m=1
	mpb01 (net158 net158 vdda vdda) pmos1 l=180n w=1u m=1
ends OPAMP1_variant630

subckt OPAMP1_variant631 inn inp out pd xpd vdda vssa
	xd1 (vssa vdda) prim_nwd AREA=6.13907e-9 PJ=476.6e-6 m=1
	xi0 (vssa net69) prim_nd AREA=1e-12 PJ=4e-6 m=1
	xi3 (net51 vdda) prim_pd AREA=790e-15 PJ=3.3e-6 m=1
	xr0 (vssa vdda net51) prim_rdiffp l=2.1e-6 w=700e-9 m=1
	xr1 (vdda vdda net69) prim_rdiffp l=1.8e-07 w=6.1e-07 m=1
	xcc01 (net12 out) prim_cpoly c=1p m=1
	mnm12 (net13 net56 vssa vssa) nmos1 l=180n w=1u m=1
	mnm11 (net56 net56 vssa vssa) nmos1 l=180n w=1u m=1
	mnb02 (net27 net27 net21 vssa) nmos1 l=180n w=1u m=1
	mnpd1 (net21 xpd vssa vssa) nmos1 l=180n w=1u m=1
	mn001 (out net13 vssa vssa) nmos1 l=180n w=1u m=1
	mnpd2 (net13 pd vssa vssa) nmos1 l=180n w=1u m=1
	mnc01 (net13 net69 net12 vssa) nmos1 l=180n w=1u m=1
	mpb02 (net27 net51 net158 vdda) pmos1 l=1.4e-07n w=7.5e-07u m=1
	mppd1 (net158 xpd vdda vdda) pmos1 l=180n w=1u m=1
	mps11 (net31 net158 vdda vdda) pmos1 l=180n w=1u m=1
	mpd11 (net56 inn net31 net31) pmos1 l=180n w=1u m=1
	mp001 (out net158 vdda vdda) pmos1 l=180n w=1u m=1
	mpd12 (net13 inp net31 net31) pmos1 l=180n w=1u m=1
	mpb01 (net158 net158 vdda vdda) pmos1 l=180n w=1u m=1
ends OPAMP1_variant631

subckt OPAMP1_variant632 inn inp out pd xpd vdda vssa
	xd1 (vssa vdda) prim_nwd AREA=6.13907e-9 PJ=476.6e-6 m=1
	xi0 (vssa net69) prim_nd AREA=1e-12 PJ=4e-6 m=1
	xi3 (net51 vdda) prim_pd AREA=790e-15 PJ=3.3e-6 m=1
	xr0 (vssa vdda net51) prim_rdiffp l=2.1e-6 w=700e-9 m=1
	xr1 (vdda vdda net69) prim_rdiffp l=2.1e-6 w=700e-9 m=1
	xcc01 (net12 out) prim_cpoly c=1p m=1
	mnm12 (net13 net56 vssa vssa) nmos1 l=180n w=1u m=1
	mnm11 (net56 net56 vssa vssa) nmos1 l=180n w=1u m=1
	mnb02 (net27 net27 net21 vssa) nmos1 l=1.3e-07n w=1.4e-06u m=1
	mnpd1 (net21 xpd vssa vssa) nmos1 l=1.5e-07n w=8.4e-07u m=1
	mn001 (out net13 vssa vssa) nmos1 l=180n w=1u m=1
	mnpd2 (net13 pd vssa vssa) nmos1 l=180n w=1u m=1
	mnc01 (net13 net69 net12 vssa) nmos1 l=180n w=1u m=1
	mpb02 (net27 net51 net158 vdda) pmos1 l=180n w=1u m=1
	mppd1 (net158 xpd vdda vdda) pmos1 l=180n w=1u m=1
	mps11 (net31 net158 vdda vdda) pmos1 l=180n w=1u m=1
	mpd11 (net56 inn net31 net31) pmos1 l=180n w=1u m=1
	mp001 (out net158 vdda vdda) pmos1 l=180n w=1u m=1
	mpd12 (net13 inp net31 net31) pmos1 l=180n w=1u m=1
	mpb01 (net158 net158 vdda vdda) pmos1 l=180n w=1u m=1
ends OPAMP1_variant632

subckt OPAMP1_variant633 inn inp out pd xpd vdda vssa
	xd1 (vssa vdda) prim_nwd AREA=6.13907e-9 PJ=476.6e-6 m=1
	xi0 (vssa net69) prim_nd AREA=1e-12 PJ=4e-6 m=1
	xi3 (net51 vdda) prim_pd AREA=790e-15 PJ=3.3e-6 m=1
	xr0 (vssa vdda net51) prim_rdiffp l=2.1e-6 w=700e-9 m=1
	xr1 (vdda vdda net69) prim_rdiffp l=2.1e-6 w=700e-9 m=1
	xcc01 (net12 out) prim_cpoly c=1p m=1
	mnm12 (net13 net56 vssa vssa) nmos1 l=180n w=1u m=1
	mnm11 (net56 net56 vssa vssa) nmos1 l=1.0e-07n w=7.6e-07u m=1
	mnb02 (net27 net27 net21 vssa) nmos1 l=180n w=1u m=1
	mnpd1 (net21 xpd vssa vssa) nmos1 l=180n w=1u m=1
	mn001 (out net13 vssa vssa) nmos1 l=180n w=1u m=1
	mnpd2 (net13 pd vssa vssa) nmos1 l=1.3e-07n w=1.7e-06u m=1
	mnc01 (net13 net69 net12 vssa) nmos1 l=180n w=1u m=1
	mpb02 (net27 net51 net158 vdda) pmos1 l=180n w=1u m=1
	mppd1 (net158 xpd vdda vdda) pmos1 l=180n w=1u m=1
	mps11 (net31 net158 vdda vdda) pmos1 l=180n w=1u m=1
	mpd11 (net56 inn net31 net31) pmos1 l=180n w=1u m=1
	mp001 (out net158 vdda vdda) pmos1 l=180n w=1u m=1
	mpd12 (net13 inp net31 net31) pmos1 l=180n w=1u m=1
	mpb01 (net158 net158 vdda vdda) pmos1 l=180n w=1u m=1
ends OPAMP1_variant633

subckt OPAMP1_variant634 inn inp out pd xpd vdda vssa
	xd1 (vssa vdda) prim_nwd AREA=6.13907e-9 PJ=476.6e-6 m=1
	xi0 (vssa net69) prim_nd AREA=1e-12 PJ=4e-6 m=1
	xi3 (net51 vdda) prim_pd AREA=790e-15 PJ=3.3e-6 m=1
	xr0 (vssa vdda net51) prim_rdiffp l=2.1e-6 w=700e-9 m=1
	xr1 (vdda vdda net69) prim_rdiffp l=2.1e-6 w=700e-9 m=1
	xcc01 (net12 out) prim_cpoly c=1p m=1
	mnm12 (net13 net56 vssa vssa) nmos1 l=2.6e-07n w=1.0e-06u m=1
	mnm11 (net56 net56 vssa vssa) nmos1 l=180n w=1u m=1
	mnb02 (net27 net27 net21 vssa) nmos1 l=180n w=1u m=1
	mnpd1 (net21 xpd vssa vssa) nmos1 l=180n w=1u m=1
	mn001 (out net13 vssa vssa) nmos1 l=180n w=1u m=1
	mnpd2 (net13 pd vssa vssa) nmos1 l=180n w=1u m=1
	mnc01 (net13 net69 net12 vssa) nmos1 l=180n w=1u m=1
	mpb02 (net27 net51 net158 vdda) pmos1 l=2.4e-07n w=9.0e-07u m=1
	mppd1 (net158 xpd vdda vdda) pmos1 l=2.1e-07n w=7.0e-07u m=1
	mps11 (net31 net158 vdda vdda) pmos1 l=180n w=1u m=1
	mpd11 (net56 inn net31 net31) pmos1 l=180n w=1u m=1
	mp001 (out net158 vdda vdda) pmos1 l=180n w=1u m=1
	mpd12 (net13 inp net31 net31) pmos1 l=180n w=1u m=1
	mpb01 (net158 net158 vdda vdda) pmos1 l=180n w=1u m=1
ends OPAMP1_variant634

subckt OPAMP1_variant635 inn inp out pd xpd vdda vssa
	xd1 (vssa vdda) prim_nwd AREA=6.13907e-9 PJ=476.6e-6 m=1
	xi0 (vssa net69) prim_nd AREA=1e-12 PJ=4e-6 m=1
	xi3 (net51 vdda) prim_pd AREA=3.9e-09 PJ=7.8e-05 m=1
	xr0 (vssa vdda net51) prim_rdiffp l=2.1e-6 w=700e-9 m=1
	xr1 (vdda vdda net69) prim_rdiffp l=2.1e-6 w=700e-9 m=1
	xcc01 (net12 out) prim_cpoly c=1p m=1
	mnm12 (net13 net56 vssa vssa) nmos1 l=180n w=1u m=1
	mnm11 (net56 net56 vssa vssa) nmos1 l=180n w=1u m=1
	mnb02 (net27 net27 net21 vssa) nmos1 l=2.5e-07n w=1.5e-06u m=1
	mnpd1 (net21 xpd vssa vssa) nmos1 l=1.4e-07n w=1.6e-06u m=1
	mn001 (out net13 vssa vssa) nmos1 l=180n w=1u m=1
	mnpd2 (net13 pd vssa vssa) nmos1 l=180n w=1u m=1
	mnc01 (net13 net69 net12 vssa) nmos1 l=180n w=1u m=1
	mpb02 (net27 net51 net158 vdda) pmos1 l=180n w=1u m=1
	mppd1 (net158 xpd vdda vdda) pmos1 l=180n w=1u m=1
	mps11 (net31 net158 vdda vdda) pmos1 l=180n w=1u m=1
	mpd11 (net56 inn net31 net31) pmos1 l=2.6e-07n w=1.6e-06u m=1
	mp001 (out net158 vdda vdda) pmos1 l=180n w=1u m=1
	mpd12 (net13 inp net31 net31) pmos1 l=180n w=1u m=1
	mpb01 (net158 net158 vdda vdda) pmos1 l=1.2e-07n w=1.3e-06u m=1
ends OPAMP1_variant635

subckt OPAMP1_variant636 inn inp out pd xpd vdda vssa
	xd1 (vssa vdda) prim_nwd AREA=5.7e-09 PJ=6.0e-05 m=1
	xi0 (vssa net69) prim_nd AREA=1e-12 PJ=4e-6 m=1
	xi3 (net51 vdda) prim_pd AREA=7.1e-09 PJ=3.4e-05 m=1
	xr0 (vssa vdda net51) prim_rdiffp l=2.1e-6 w=700e-9 m=1
	xr1 (vdda vdda net69) prim_rdiffp l=2.1e-6 w=700e-9 m=1
	xcc01 (net12 out) prim_cpoly c=1.3e-12p m=1
	mnm12 (net13 net56 vssa vssa) nmos1 l=180n w=1u m=1
	mnm11 (net56 net56 vssa vssa) nmos1 l=180n w=1u m=1
	mnb02 (net27 net27 net21 vssa) nmos1 l=180n w=1u m=1
	mnpd1 (net21 xpd vssa vssa) nmos1 l=180n w=1u m=1
	mn001 (out net13 vssa vssa) nmos1 l=180n w=1u m=1
	mnpd2 (net13 pd vssa vssa) nmos1 l=180n w=1u m=1
	mnc01 (net13 net69 net12 vssa) nmos1 l=180n w=1u m=1
	mpb02 (net27 net51 net158 vdda) pmos1 l=180n w=1u m=1
	mppd1 (net158 xpd vdda vdda) pmos1 l=180n w=1u m=1
	mps11 (net31 net158 vdda vdda) pmos1 l=2.6e-07n w=1.3e-06u m=1
	mpd11 (net56 inn net31 net31) pmos1 l=180n w=1u m=1
	mp001 (out net158 vdda vdda) pmos1 l=180n w=1u m=1
	mpd12 (net13 inp net31 net31) pmos1 l=180n w=1u m=1
	mpb01 (net158 net158 vdda vdda) pmos1 l=180n w=1u m=1
ends OPAMP1_variant636

subckt OPAMP1_variant637 inn inp out pd xpd vdda vssa
	xd1 (vssa vdda) prim_nwd AREA=6.13907e-9 PJ=476.6e-6 m=1
	xi0 (vssa net69) prim_nd AREA=1e-12 PJ=4e-6 m=1
	xi3 (net51 vdda) prim_pd AREA=790e-15 PJ=3.3e-6 m=1
	xr0 (vssa vdda net51) prim_rdiffp l=2.1e-6 w=700e-9 m=1
	xr1 (vdda vdda net69) prim_rdiffp l=2.1e-6 w=700e-9 m=1
	xcc01 (net12 out) prim_cpoly c=1p m=1
	mnm12 (net13 net56 vssa vssa) nmos1 l=180n w=1u m=1
	mnm11 (net56 net56 vssa vssa) nmos1 l=180n w=1u m=1
	mnb02 (net27 net27 net21 vssa) nmos1 l=180n w=1u m=1
	mnpd1 (net21 xpd vssa vssa) nmos1 l=180n w=1u m=1
	mn001 (out net13 vssa vssa) nmos1 l=180n w=1u m=1
	mnpd2 (net13 pd vssa vssa) nmos1 l=180n w=1u m=1
	mnc01 (net13 net69 net12 vssa) nmos1 l=180n w=1u m=1
	mpb02 (net27 net51 net158 vdda) pmos1 l=180n w=1u m=1
	mppd1 (net158 xpd vdda vdda) pmos1 l=180n w=1u m=1
	mps11 (net31 net158 vdda vdda) pmos1 l=180n w=1u m=1
	mpd11 (net56 inn net31 net31) pmos1 l=180n w=1u m=1
	mp001 (out net158 vdda vdda) pmos1 l=2.5e-07n w=1.2e-06u m=1
	mpd12 (net13 inp net31 net31) pmos1 l=180n w=1u m=1
	mpb01 (net158 net158 vdda vdda) pmos1 l=1.4e-07n w=1.2e-06u m=1
ends OPAMP1_variant637

subckt OPAMP1_variant638 inn inp out pd xpd vdda vssa
	xd1 (vssa vdda) prim_nwd AREA=6.13907e-9 PJ=476.6e-6 m=1
	xi0 (vssa net69) prim_nd AREA=1e-12 PJ=4e-6 m=1
	xi3 (net51 vdda) prim_pd AREA=790e-15 PJ=3.3e-6 m=1
	xr0 (vssa vdda net51) prim_rdiffp l=2.1e-6 w=700e-9 m=1
	xr1 (vdda vdda net69) prim_rdiffp l=2.1e-6 w=700e-9 m=1
	xcc01 (net12 out) prim_cpoly c=1p m=1
	mnm12 (net13 net56 vssa vssa) nmos1 l=180n w=1u m=1
	mnm11 (net56 net56 vssa vssa) nmos1 l=180n w=1u m=1
	mnb02 (net27 net27 net21 vssa) nmos1 l=180n w=1u m=1
	mnpd1 (net21 xpd vssa vssa) nmos1 l=1.8e-07n w=1.1e-06u m=1
	mn001 (out net13 vssa vssa) nmos1 l=180n w=1u m=1
	mnpd2 (net13 pd vssa vssa) nmos1 l=180n w=1u m=1
	mnc01 (net13 net69 net12 vssa) nmos1 l=180n w=1u m=1
	mpb02 (net27 net51 net158 vdda) pmos1 l=2.5e-07n w=5.6e-07u m=1
	mppd1 (net158 xpd vdda vdda) pmos1 l=180n w=1u m=1
	mps11 (net31 net158 vdda vdda) pmos1 l=180n w=1u m=1
	mpd11 (net56 inn net31 net31) pmos1 l=180n w=1u m=1
	mp001 (out net158 vdda vdda) pmos1 l=180n w=1u m=1
	mpd12 (net13 inp net31 net31) pmos1 l=180n w=1u m=1
	mpb01 (net158 net158 vdda vdda) pmos1 l=180n w=1u m=1
ends OPAMP1_variant638

subckt OPAMP1_variant639 inn inp out pd xpd vdda vssa
	xd1 (vssa vdda) prim_nwd AREA=6.13907e-9 PJ=476.6e-6 m=1
	xi0 (vssa net69) prim_nd AREA=1e-12 PJ=4e-6 m=1
	xi3 (net51 vdda) prim_pd AREA=790e-15 PJ=3.3e-6 m=1
	xr0 (vssa vdda net51) prim_rdiffp l=2.1e-6 w=700e-9 m=1
	xr1 (vdda vdda net69) prim_rdiffp l=2.1e-6 w=700e-9 m=1
	xcc01 (net12 out) prim_cpoly c=6.9e-13p m=1
	mnm12 (net13 net56 vssa vssa) nmos1 l=180n w=1u m=1
	mnm11 (net56 net56 vssa vssa) nmos1 l=2.8e-07n w=1.7e-06u m=1
	mnb02 (net27 net27 net21 vssa) nmos1 l=2.6e-07n w=5.7e-07u m=1
	mnpd1 (net21 xpd vssa vssa) nmos1 l=1.0e-07n w=7.3e-07u m=1
	mn001 (out net13 vssa vssa) nmos1 l=180n w=1u m=1
	mnpd2 (net13 pd vssa vssa) nmos1 l=180n w=1u m=1
	mnc01 (net13 net69 net12 vssa) nmos1 l=180n w=1u m=1
	mpb02 (net27 net51 net158 vdda) pmos1 l=180n w=1u m=1
	mppd1 (net158 xpd vdda vdda) pmos1 l=180n w=1u m=1
	mps11 (net31 net158 vdda vdda) pmos1 l=180n w=1u m=1
	mpd11 (net56 inn net31 net31) pmos1 l=180n w=1u m=1
	mp001 (out net158 vdda vdda) pmos1 l=180n w=1u m=1
	mpd12 (net13 inp net31 net31) pmos1 l=180n w=1u m=1
	mpb01 (net158 net158 vdda vdda) pmos1 l=180n w=1u m=1
ends OPAMP1_variant639

subckt OPAMP1_variant640 inn inp out pd xpd vdda vssa
	xd1 (vssa vdda) prim_nwd AREA=6.13907e-9 PJ=476.6e-6 m=1
	xi0 (vssa net69) prim_nd AREA=6.4e-09 PJ=4.2e-05 m=1
	xi3 (net51 vdda) prim_pd AREA=790e-15 PJ=3.3e-6 m=1
	xr0 (vssa vdda net51) prim_rdiffp l=1.6e-07 w=1.6e-06 m=1
	xr1 (vdda vdda net69) prim_rdiffp l=2.0e-07 w=1.8e-06 m=1
	xcc01 (net12 out) prim_cpoly c=1p m=1
	mnm12 (net13 net56 vssa vssa) nmos1 l=180n w=1u m=1
	mnm11 (net56 net56 vssa vssa) nmos1 l=180n w=1u m=1
	mnb02 (net27 net27 net21 vssa) nmos1 l=2.8e-07n w=1.4e-06u m=1
	mnpd1 (net21 xpd vssa vssa) nmos1 l=180n w=1u m=1
	mn001 (out net13 vssa vssa) nmos1 l=180n w=1u m=1
	mnpd2 (net13 pd vssa vssa) nmos1 l=180n w=1u m=1
	mnc01 (net13 net69 net12 vssa) nmos1 l=180n w=1u m=1
	mpb02 (net27 net51 net158 vdda) pmos1 l=180n w=1u m=1
	mppd1 (net158 xpd vdda vdda) pmos1 l=180n w=1u m=1
	mps11 (net31 net158 vdda vdda) pmos1 l=180n w=1u m=1
	mpd11 (net56 inn net31 net31) pmos1 l=1.1e-07n w=1.7e-06u m=1
	mp001 (out net158 vdda vdda) pmos1 l=180n w=1u m=1
	mpd12 (net13 inp net31 net31) pmos1 l=180n w=1u m=1
	mpb01 (net158 net158 vdda vdda) pmos1 l=180n w=1u m=1
ends OPAMP1_variant640

subckt OPAMP1_variant641 inn inp out pd xpd vdda vssa
	xd1 (vssa vdda) prim_nwd AREA=6.13907e-9 PJ=476.6e-6 m=1
	xi0 (vssa net69) prim_nd AREA=1e-12 PJ=4e-6 m=1
	xi3 (net51 vdda) prim_pd AREA=790e-15 PJ=3.3e-6 m=1
	xr0 (vssa vdda net51) prim_rdiffp l=2.9e-07 w=1.7e-06 m=1
	xr1 (vdda vdda net69) prim_rdiffp l=2.1e-6 w=700e-9 m=1
	xcc01 (net12 out) prim_cpoly c=1.3e-12p m=1
	mnm12 (net13 net56 vssa vssa) nmos1 l=180n w=1u m=1
	mnm11 (net56 net56 vssa vssa) nmos1 l=180n w=1u m=1
	mnb02 (net27 net27 net21 vssa) nmos1 l=180n w=1u m=1
	mnpd1 (net21 xpd vssa vssa) nmos1 l=180n w=1u m=1
	mn001 (out net13 vssa vssa) nmos1 l=180n w=1u m=1
	mnpd2 (net13 pd vssa vssa) nmos1 l=180n w=1u m=1
	mnc01 (net13 net69 net12 vssa) nmos1 l=180n w=1u m=1
	mpb02 (net27 net51 net158 vdda) pmos1 l=180n w=1u m=1
	mppd1 (net158 xpd vdda vdda) pmos1 l=180n w=1u m=1
	mps11 (net31 net158 vdda vdda) pmos1 l=180n w=1u m=1
	mpd11 (net56 inn net31 net31) pmos1 l=180n w=1u m=1
	mp001 (out net158 vdda vdda) pmos1 l=1.8e-07n w=9.0e-07u m=1
	mpd12 (net13 inp net31 net31) pmos1 l=180n w=1u m=1
	mpb01 (net158 net158 vdda vdda) pmos1 l=180n w=1u m=1
ends OPAMP1_variant641

subckt OPAMP1_variant642 inn inp out pd xpd vdda vssa
	xd1 (vssa vdda) prim_nwd AREA=6.13907e-9 PJ=476.6e-6 m=1
	xi0 (vssa net69) prim_nd AREA=1e-12 PJ=4e-6 m=1
	xi3 (net51 vdda) prim_pd AREA=790e-15 PJ=3.3e-6 m=1
	xr0 (vssa vdda net51) prim_rdiffp l=2.7e-07 w=1.9e-06 m=1
	xr1 (vdda vdda net69) prim_rdiffp l=2.1e-6 w=700e-9 m=1
	xcc01 (net12 out) prim_cpoly c=1p m=1
	mnm12 (net13 net56 vssa vssa) nmos1 l=180n w=1u m=1
	mnm11 (net56 net56 vssa vssa) nmos1 l=180n w=1u m=1
	mnb02 (net27 net27 net21 vssa) nmos1 l=180n w=1u m=1
	mnpd1 (net21 xpd vssa vssa) nmos1 l=1.0e-07n w=2.0e-06u m=1
	mn001 (out net13 vssa vssa) nmos1 l=180n w=1u m=1
	mnpd2 (net13 pd vssa vssa) nmos1 l=180n w=1u m=1
	mnc01 (net13 net69 net12 vssa) nmos1 l=180n w=1u m=1
	mpb02 (net27 net51 net158 vdda) pmos1 l=180n w=1u m=1
	mppd1 (net158 xpd vdda vdda) pmos1 l=180n w=1u m=1
	mps11 (net31 net158 vdda vdda) pmos1 l=180n w=1u m=1
	mpd11 (net56 inn net31 net31) pmos1 l=180n w=1u m=1
	mp001 (out net158 vdda vdda) pmos1 l=180n w=1u m=1
	mpd12 (net13 inp net31 net31) pmos1 l=2.0e-07n w=1.8e-06u m=1
	mpb01 (net158 net158 vdda vdda) pmos1 l=180n w=1u m=1
ends OPAMP1_variant642

subckt OPAMP1_variant643 inn inp out pd xpd vdda vssa
	xd1 (vssa vdda) prim_nwd AREA=6.13907e-9 PJ=476.6e-6 m=1
	xi0 (vssa net69) prim_nd AREA=1e-12 PJ=4e-6 m=1
	xi3 (net51 vdda) prim_pd AREA=790e-15 PJ=3.3e-6 m=1
	xr0 (vssa vdda net51) prim_rdiffp l=2.1e-6 w=700e-9 m=1
	xr1 (vdda vdda net69) prim_rdiffp l=2.1e-6 w=700e-9 m=1
	xcc01 (net12 out) prim_cpoly c=2.0e-12p m=1
	mnm12 (net13 net56 vssa vssa) nmos1 l=180n w=1u m=1
	mnm11 (net56 net56 vssa vssa) nmos1 l=180n w=1u m=1
	mnb02 (net27 net27 net21 vssa) nmos1 l=180n w=1u m=1
	mnpd1 (net21 xpd vssa vssa) nmos1 l=180n w=1u m=1
	mn001 (out net13 vssa vssa) nmos1 l=180n w=1u m=1
	mnpd2 (net13 pd vssa vssa) nmos1 l=1.2e-07n w=7.6e-07u m=1
	mnc01 (net13 net69 net12 vssa) nmos1 l=180n w=1u m=1
	mpb02 (net27 net51 net158 vdda) pmos1 l=180n w=1u m=1
	mppd1 (net158 xpd vdda vdda) pmos1 l=1.2e-07n w=1.9e-06u m=1
	mps11 (net31 net158 vdda vdda) pmos1 l=180n w=1u m=1
	mpd11 (net56 inn net31 net31) pmos1 l=180n w=1u m=1
	mp001 (out net158 vdda vdda) pmos1 l=1.5e-07n w=2.0e-06u m=1
	mpd12 (net13 inp net31 net31) pmos1 l=180n w=1u m=1
	mpb01 (net158 net158 vdda vdda) pmos1 l=1.5e-07n w=1.1e-06u m=1
ends OPAMP1_variant643

subckt OPAMP1_variant644 inn inp out pd xpd vdda vssa
	xd1 (vssa vdda) prim_nwd AREA=6.13907e-9 PJ=476.6e-6 m=1
	xi0 (vssa net69) prim_nd AREA=1e-12 PJ=4e-6 m=1
	xi3 (net51 vdda) prim_pd AREA=790e-15 PJ=3.3e-6 m=1
	xr0 (vssa vdda net51) prim_rdiffp l=1.1e-07 w=5.5e-07 m=1
	xr1 (vdda vdda net69) prim_rdiffp l=2.1e-6 w=700e-9 m=1
	xcc01 (net12 out) prim_cpoly c=1p m=1
	mnm12 (net13 net56 vssa vssa) nmos1 l=180n w=1u m=1
	mnm11 (net56 net56 vssa vssa) nmos1 l=180n w=1u m=1
	mnb02 (net27 net27 net21 vssa) nmos1 l=180n w=1u m=1
	mnpd1 (net21 xpd vssa vssa) nmos1 l=180n w=1u m=1
	mn001 (out net13 vssa vssa) nmos1 l=180n w=1u m=1
	mnpd2 (net13 pd vssa vssa) nmos1 l=2.1e-07n w=1.6e-06u m=1
	mnc01 (net13 net69 net12 vssa) nmos1 l=180n w=1u m=1
	mpb02 (net27 net51 net158 vdda) pmos1 l=180n w=1u m=1
	mppd1 (net158 xpd vdda vdda) pmos1 l=180n w=1u m=1
	mps11 (net31 net158 vdda vdda) pmos1 l=2.8e-07n w=1.2e-06u m=1
	mpd11 (net56 inn net31 net31) pmos1 l=180n w=1u m=1
	mp001 (out net158 vdda vdda) pmos1 l=180n w=1u m=1
	mpd12 (net13 inp net31 net31) pmos1 l=180n w=1u m=1
	mpb01 (net158 net158 vdda vdda) pmos1 l=1.1e-07n w=1.2e-06u m=1
ends OPAMP1_variant644

subckt OPAMP1_variant645 inn inp out pd xpd vdda vssa
	xd1 (vssa vdda) prim_nwd AREA=6.13907e-9 PJ=476.6e-6 m=1
	xi0 (vssa net69) prim_nd AREA=1e-12 PJ=4e-6 m=1
	xi3 (net51 vdda) prim_pd AREA=790e-15 PJ=3.3e-6 m=1
	xr0 (vssa vdda net51) prim_rdiffp l=2.1e-6 w=700e-9 m=1
	xr1 (vdda vdda net69) prim_rdiffp l=2.1e-6 w=700e-9 m=1
	xcc01 (net12 out) prim_cpoly c=1.5e-12p m=1
	mnm12 (net13 net56 vssa vssa) nmos1 l=180n w=1u m=1
	mnm11 (net56 net56 vssa vssa) nmos1 l=180n w=1u m=1
	mnb02 (net27 net27 net21 vssa) nmos1 l=180n w=1u m=1
	mnpd1 (net21 xpd vssa vssa) nmos1 l=2.6e-07n w=1.1e-06u m=1
	mn001 (out net13 vssa vssa) nmos1 l=180n w=1u m=1
	mnpd2 (net13 pd vssa vssa) nmos1 l=180n w=1u m=1
	mnc01 (net13 net69 net12 vssa) nmos1 l=180n w=1u m=1
	mpb02 (net27 net51 net158 vdda) pmos1 l=1.2e-07n w=1.8e-06u m=1
	mppd1 (net158 xpd vdda vdda) pmos1 l=180n w=1u m=1
	mps11 (net31 net158 vdda vdda) pmos1 l=180n w=1u m=1
	mpd11 (net56 inn net31 net31) pmos1 l=1.9e-07n w=1.6e-06u m=1
	mp001 (out net158 vdda vdda) pmos1 l=180n w=1u m=1
	mpd12 (net13 inp net31 net31) pmos1 l=180n w=1u m=1
	mpb01 (net158 net158 vdda vdda) pmos1 l=180n w=1u m=1
ends OPAMP1_variant645

subckt OPAMP1_variant646 inn inp out pd xpd vdda vssa
	xd1 (vssa vdda) prim_nwd AREA=9.4e-09 PJ=4.2e-05 m=1
	xi0 (vssa net69) prim_nd AREA=5.8e-09 PJ=5.9e-06 m=1
	xi3 (net51 vdda) prim_pd AREA=790e-15 PJ=3.3e-6 m=1
	xr0 (vssa vdda net51) prim_rdiffp l=2.1e-6 w=700e-9 m=1
	xr1 (vdda vdda net69) prim_rdiffp l=2.1e-6 w=700e-9 m=1
	xcc01 (net12 out) prim_cpoly c=1p m=1
	mnm12 (net13 net56 vssa vssa) nmos1 l=180n w=1u m=1
	mnm11 (net56 net56 vssa vssa) nmos1 l=180n w=1u m=1
	mnb02 (net27 net27 net21 vssa) nmos1 l=180n w=1u m=1
	mnpd1 (net21 xpd vssa vssa) nmos1 l=180n w=1u m=1
	mn001 (out net13 vssa vssa) nmos1 l=1.5e-07n w=1.4e-06u m=1
	mnpd2 (net13 pd vssa vssa) nmos1 l=180n w=1u m=1
	mnc01 (net13 net69 net12 vssa) nmos1 l=1.1e-07n w=1.7e-06u m=1
	mpb02 (net27 net51 net158 vdda) pmos1 l=180n w=1u m=1
	mppd1 (net158 xpd vdda vdda) pmos1 l=180n w=1u m=1
	mps11 (net31 net158 vdda vdda) pmos1 l=180n w=1u m=1
	mpd11 (net56 inn net31 net31) pmos1 l=180n w=1u m=1
	mp001 (out net158 vdda vdda) pmos1 l=180n w=1u m=1
	mpd12 (net13 inp net31 net31) pmos1 l=180n w=1u m=1
	mpb01 (net158 net158 vdda vdda) pmos1 l=180n w=1u m=1
ends OPAMP1_variant646

subckt OPAMP1_variant647 inn inp out pd xpd vdda vssa
	xd1 (vssa vdda) prim_nwd AREA=6.13907e-9 PJ=476.6e-6 m=1
	xi0 (vssa net69) prim_nd AREA=1e-12 PJ=4e-6 m=1
	xi3 (net51 vdda) prim_pd AREA=4.1e-09 PJ=6.4e-05 m=1
	xr0 (vssa vdda net51) prim_rdiffp l=2.1e-6 w=700e-9 m=1
	xr1 (vdda vdda net69) prim_rdiffp l=2.1e-6 w=700e-9 m=1
	xcc01 (net12 out) prim_cpoly c=1p m=1
	mnm12 (net13 net56 vssa vssa) nmos1 l=180n w=1u m=1
	mnm11 (net56 net56 vssa vssa) nmos1 l=180n w=1u m=1
	mnb02 (net27 net27 net21 vssa) nmos1 l=180n w=1u m=1
	mnpd1 (net21 xpd vssa vssa) nmos1 l=180n w=1u m=1
	mn001 (out net13 vssa vssa) nmos1 l=180n w=1u m=1
	mnpd2 (net13 pd vssa vssa) nmos1 l=180n w=1u m=1
	mnc01 (net13 net69 net12 vssa) nmos1 l=180n w=1u m=1
	mpb02 (net27 net51 net158 vdda) pmos1 l=2.6e-07n w=2.0e-06u m=1
	mppd1 (net158 xpd vdda vdda) pmos1 l=180n w=1u m=1
	mps11 (net31 net158 vdda vdda) pmos1 l=1.0e-07n w=1.5e-06u m=1
	mpd11 (net56 inn net31 net31) pmos1 l=180n w=1u m=1
	mp001 (out net158 vdda vdda) pmos1 l=180n w=1u m=1
	mpd12 (net13 inp net31 net31) pmos1 l=2.6e-07n w=1.4e-06u m=1
	mpb01 (net158 net158 vdda vdda) pmos1 l=180n w=1u m=1
ends OPAMP1_variant647

subckt OPAMP1_variant648 inn inp out pd xpd vdda vssa
	xd1 (vssa vdda) prim_nwd AREA=6.13907e-9 PJ=476.6e-6 m=1
	xi0 (vssa net69) prim_nd AREA=1.6e-09 PJ=9.4e-05 m=1
	xi3 (net51 vdda) prim_pd AREA=790e-15 PJ=3.3e-6 m=1
	xr0 (vssa vdda net51) prim_rdiffp l=2.1e-6 w=700e-9 m=1
	xr1 (vdda vdda net69) prim_rdiffp l=2.6e-07 w=1.7e-06 m=1
	xcc01 (net12 out) prim_cpoly c=1p m=1
	mnm12 (net13 net56 vssa vssa) nmos1 l=180n w=1u m=1
	mnm11 (net56 net56 vssa vssa) nmos1 l=180n w=1u m=1
	mnb02 (net27 net27 net21 vssa) nmos1 l=2.7e-07n w=1.8e-06u m=1
	mnpd1 (net21 xpd vssa vssa) nmos1 l=180n w=1u m=1
	mn001 (out net13 vssa vssa) nmos1 l=180n w=1u m=1
	mnpd2 (net13 pd vssa vssa) nmos1 l=2.0e-07n w=1.8e-06u m=1
	mnc01 (net13 net69 net12 vssa) nmos1 l=2.7e-07n w=1.1e-06u m=1
	mpb02 (net27 net51 net158 vdda) pmos1 l=180n w=1u m=1
	mppd1 (net158 xpd vdda vdda) pmos1 l=180n w=1u m=1
	mps11 (net31 net158 vdda vdda) pmos1 l=180n w=1u m=1
	mpd11 (net56 inn net31 net31) pmos1 l=180n w=1u m=1
	mp001 (out net158 vdda vdda) pmos1 l=180n w=1u m=1
	mpd12 (net13 inp net31 net31) pmos1 l=180n w=1u m=1
	mpb01 (net158 net158 vdda vdda) pmos1 l=180n w=1u m=1
ends OPAMP1_variant648

subckt OPAMP1_variant649 inn inp out pd xpd vdda vssa
	xd1 (vssa vdda) prim_nwd AREA=6.9e-09 PJ=8.1e-05 m=1
	xi0 (vssa net69) prim_nd AREA=1e-12 PJ=4e-6 m=1
	xi3 (net51 vdda) prim_pd AREA=790e-15 PJ=3.3e-6 m=1
	xr0 (vssa vdda net51) prim_rdiffp l=2.1e-6 w=700e-9 m=1
	xr1 (vdda vdda net69) prim_rdiffp l=2.1e-6 w=700e-9 m=1
	xcc01 (net12 out) prim_cpoly c=1p m=1
	mnm12 (net13 net56 vssa vssa) nmos1 l=180n w=1u m=1
	mnm11 (net56 net56 vssa vssa) nmos1 l=180n w=1u m=1
	mnb02 (net27 net27 net21 vssa) nmos1 l=180n w=1u m=1
	mnpd1 (net21 xpd vssa vssa) nmos1 l=180n w=1u m=1
	mn001 (out net13 vssa vssa) nmos1 l=180n w=1u m=1
	mnpd2 (net13 pd vssa vssa) nmos1 l=180n w=1u m=1
	mnc01 (net13 net69 net12 vssa) nmos1 l=2.4e-07n w=1.1e-06u m=1
	mpb02 (net27 net51 net158 vdda) pmos1 l=2.7e-07n w=1.8e-06u m=1
	mppd1 (net158 xpd vdda vdda) pmos1 l=180n w=1u m=1
	mps11 (net31 net158 vdda vdda) pmos1 l=180n w=1u m=1
	mpd11 (net56 inn net31 net31) pmos1 l=180n w=1u m=1
	mp001 (out net158 vdda vdda) pmos1 l=180n w=1u m=1
	mpd12 (net13 inp net31 net31) pmos1 l=180n w=1u m=1
	mpb01 (net158 net158 vdda vdda) pmos1 l=180n w=1u m=1
ends OPAMP1_variant649

subckt OPAMP1_variant650 inn inp out pd xpd vdda vssa
	xd1 (vssa vdda) prim_nwd AREA=6.13907e-9 PJ=476.6e-6 m=1
	xi0 (vssa net69) prim_nd AREA=1e-12 PJ=4e-6 m=1
	xi3 (net51 vdda) prim_pd AREA=790e-15 PJ=3.3e-6 m=1
	xr0 (vssa vdda net51) prim_rdiffp l=2.1e-6 w=700e-9 m=1
	xr1 (vdda vdda net69) prim_rdiffp l=2.1e-6 w=700e-9 m=1
	xcc01 (net12 out) prim_cpoly c=1p m=1
	mnm12 (net13 net56 vssa vssa) nmos1 l=3.0e-07n w=1.0e-06u m=1
	mnm11 (net56 net56 vssa vssa) nmos1 l=1.4e-07n w=1.7e-06u m=1
	mnb02 (net27 net27 net21 vssa) nmos1 l=180n w=1u m=1
	mnpd1 (net21 xpd vssa vssa) nmos1 l=180n w=1u m=1
	mn001 (out net13 vssa vssa) nmos1 l=180n w=1u m=1
	mnpd2 (net13 pd vssa vssa) nmos1 l=180n w=1u m=1
	mnc01 (net13 net69 net12 vssa) nmos1 l=180n w=1u m=1
	mpb02 (net27 net51 net158 vdda) pmos1 l=180n w=1u m=1
	mppd1 (net158 xpd vdda vdda) pmos1 l=180n w=1u m=1
	mps11 (net31 net158 vdda vdda) pmos1 l=180n w=1u m=1
	mpd11 (net56 inn net31 net31) pmos1 l=180n w=1u m=1
	mp001 (out net158 vdda vdda) pmos1 l=180n w=1u m=1
	mpd12 (net13 inp net31 net31) pmos1 l=180n w=1u m=1
	mpb01 (net158 net158 vdda vdda) pmos1 l=180n w=1u m=1
ends OPAMP1_variant650

subckt OPAMP1_variant651 inn inp out pd xpd vdda vssa
	xd1 (vssa vdda) prim_nwd AREA=6.13907e-9 PJ=476.6e-6 m=1
	xi0 (vssa net69) prim_nd AREA=1e-12 PJ=4e-6 m=1
	xi3 (net51 vdda) prim_pd AREA=790e-15 PJ=3.3e-6 m=1
	xr0 (vssa vdda net51) prim_rdiffp l=2.1e-6 w=700e-9 m=1
	xr1 (vdda vdda net69) prim_rdiffp l=2.1e-6 w=700e-9 m=1
	xcc01 (net12 out) prim_cpoly c=1p m=1
	mnm12 (net13 net56 vssa vssa) nmos1 l=180n w=1u m=1
	mnm11 (net56 net56 vssa vssa) nmos1 l=180n w=1u m=1
	mnb02 (net27 net27 net21 vssa) nmos1 l=180n w=1u m=1
	mnpd1 (net21 xpd vssa vssa) nmos1 l=180n w=1u m=1
	mn001 (out net13 vssa vssa) nmos1 l=2.1e-07n w=8.2e-07u m=1
	mnpd2 (net13 pd vssa vssa) nmos1 l=2.5e-07n w=1.6e-06u m=1
	mnc01 (net13 net69 net12 vssa) nmos1 l=180n w=1u m=1
	mpb02 (net27 net51 net158 vdda) pmos1 l=180n w=1u m=1
	mppd1 (net158 xpd vdda vdda) pmos1 l=180n w=1u m=1
	mps11 (net31 net158 vdda vdda) pmos1 l=1.6e-07n w=1.2e-06u m=1
	mpd11 (net56 inn net31 net31) pmos1 l=180n w=1u m=1
	mp001 (out net158 vdda vdda) pmos1 l=2.9e-07n w=1.8e-06u m=1
	mpd12 (net13 inp net31 net31) pmos1 l=180n w=1u m=1
	mpb01 (net158 net158 vdda vdda) pmos1 l=2.6e-07n w=1.5e-06u m=1
ends OPAMP1_variant651

subckt OPAMP1_variant652 inn inp out pd xpd vdda vssa
	xd1 (vssa vdda) prim_nwd AREA=6.13907e-9 PJ=476.6e-6 m=1
	xi0 (vssa net69) prim_nd AREA=1e-12 PJ=4e-6 m=1
	xi3 (net51 vdda) prim_pd AREA=2.2e-09 PJ=7.9e-05 m=1
	xr0 (vssa vdda net51) prim_rdiffp l=2.1e-6 w=700e-9 m=1
	xr1 (vdda vdda net69) prim_rdiffp l=2.1e-6 w=700e-9 m=1
	xcc01 (net12 out) prim_cpoly c=1p m=1
	mnm12 (net13 net56 vssa vssa) nmos1 l=180n w=1u m=1
	mnm11 (net56 net56 vssa vssa) nmos1 l=180n w=1u m=1
	mnb02 (net27 net27 net21 vssa) nmos1 l=180n w=1u m=1
	mnpd1 (net21 xpd vssa vssa) nmos1 l=180n w=1u m=1
	mn001 (out net13 vssa vssa) nmos1 l=180n w=1u m=1
	mnpd2 (net13 pd vssa vssa) nmos1 l=2.6e-07n w=7.2e-07u m=1
	mnc01 (net13 net69 net12 vssa) nmos1 l=180n w=1u m=1
	mpb02 (net27 net51 net158 vdda) pmos1 l=180n w=1u m=1
	mppd1 (net158 xpd vdda vdda) pmos1 l=180n w=1u m=1
	mps11 (net31 net158 vdda vdda) pmos1 l=180n w=1u m=1
	mpd11 (net56 inn net31 net31) pmos1 l=180n w=1u m=1
	mp001 (out net158 vdda vdda) pmos1 l=180n w=1u m=1
	mpd12 (net13 inp net31 net31) pmos1 l=180n w=1u m=1
	mpb01 (net158 net158 vdda vdda) pmos1 l=180n w=1u m=1
ends OPAMP1_variant652

subckt OPAMP1_variant653 inn inp out pd xpd vdda vssa
	xd1 (vssa vdda) prim_nwd AREA=6.13907e-9 PJ=476.6e-6 m=1
	xi0 (vssa net69) prim_nd AREA=1e-12 PJ=4e-6 m=1
	xi3 (net51 vdda) prim_pd AREA=790e-15 PJ=3.3e-6 m=1
	xr0 (vssa vdda net51) prim_rdiffp l=2.1e-6 w=700e-9 m=1
	xr1 (vdda vdda net69) prim_rdiffp l=2.1e-6 w=700e-9 m=1
	xcc01 (net12 out) prim_cpoly c=1p m=1
	mnm12 (net13 net56 vssa vssa) nmos1 l=180n w=1u m=1
	mnm11 (net56 net56 vssa vssa) nmos1 l=180n w=1u m=1
	mnb02 (net27 net27 net21 vssa) nmos1 l=180n w=1u m=1
	mnpd1 (net21 xpd vssa vssa) nmos1 l=180n w=1u m=1
	mn001 (out net13 vssa vssa) nmos1 l=180n w=1u m=1
	mnpd2 (net13 pd vssa vssa) nmos1 l=2.6e-07n w=8.3e-07u m=1
	mnc01 (net13 net69 net12 vssa) nmos1 l=180n w=1u m=1
	mpb02 (net27 net51 net158 vdda) pmos1 l=180n w=1u m=1
	mppd1 (net158 xpd vdda vdda) pmos1 l=180n w=1u m=1
	mps11 (net31 net158 vdda vdda) pmos1 l=2.0e-07n w=7.1e-07u m=1
	mpd11 (net56 inn net31 net31) pmos1 l=180n w=1u m=1
	mp001 (out net158 vdda vdda) pmos1 l=180n w=1u m=1
	mpd12 (net13 inp net31 net31) pmos1 l=180n w=1u m=1
	mpb01 (net158 net158 vdda vdda) pmos1 l=180n w=1u m=1
ends OPAMP1_variant653

subckt OPAMP1_variant654 inn inp out pd xpd vdda vssa
	xd1 (vssa vdda) prim_nwd AREA=6.13907e-9 PJ=476.6e-6 m=1
	xi0 (vssa net69) prim_nd AREA=1e-12 PJ=4e-6 m=1
	xi3 (net51 vdda) prim_pd AREA=790e-15 PJ=3.3e-6 m=1
	xr0 (vssa vdda net51) prim_rdiffp l=2.1e-6 w=700e-9 m=1
	xr1 (vdda vdda net69) prim_rdiffp l=2.1e-6 w=700e-9 m=1
	xcc01 (net12 out) prim_cpoly c=1p m=1
	mnm12 (net13 net56 vssa vssa) nmos1 l=180n w=1u m=1
	mnm11 (net56 net56 vssa vssa) nmos1 l=180n w=1u m=1
	mnb02 (net27 net27 net21 vssa) nmos1 l=180n w=1u m=1
	mnpd1 (net21 xpd vssa vssa) nmos1 l=180n w=1u m=1
	mn001 (out net13 vssa vssa) nmos1 l=1.5e-07n w=8.8e-07u m=1
	mnpd2 (net13 pd vssa vssa) nmos1 l=180n w=1u m=1
	mnc01 (net13 net69 net12 vssa) nmos1 l=180n w=1u m=1
	mpb02 (net27 net51 net158 vdda) pmos1 l=180n w=1u m=1
	mppd1 (net158 xpd vdda vdda) pmos1 l=180n w=1u m=1
	mps11 (net31 net158 vdda vdda) pmos1 l=180n w=1u m=1
	mpd11 (net56 inn net31 net31) pmos1 l=180n w=1u m=1
	mp001 (out net158 vdda vdda) pmos1 l=180n w=1u m=1
	mpd12 (net13 inp net31 net31) pmos1 l=180n w=1u m=1
	mpb01 (net158 net158 vdda vdda) pmos1 l=1.8e-07n w=1.7e-06u m=1
ends OPAMP1_variant654

subckt OPAMP1_variant655 inn inp out pd xpd vdda vssa
	xd1 (vssa vdda) prim_nwd AREA=6.13907e-9 PJ=476.6e-6 m=1
	xi0 (vssa net69) prim_nd AREA=8.2e-09 PJ=2.9e-05 m=1
	xi3 (net51 vdda) prim_pd AREA=790e-15 PJ=3.3e-6 m=1
	xr0 (vssa vdda net51) prim_rdiffp l=1.9e-07 w=9.4e-07 m=1
	xr1 (vdda vdda net69) prim_rdiffp l=1.7e-07 w=1.3e-06 m=1
	xcc01 (net12 out) prim_cpoly c=1p m=1
	mnm12 (net13 net56 vssa vssa) nmos1 l=180n w=1u m=1
	mnm11 (net56 net56 vssa vssa) nmos1 l=180n w=1u m=1
	mnb02 (net27 net27 net21 vssa) nmos1 l=180n w=1u m=1
	mnpd1 (net21 xpd vssa vssa) nmos1 l=180n w=1u m=1
	mn001 (out net13 vssa vssa) nmos1 l=180n w=1u m=1
	mnpd2 (net13 pd vssa vssa) nmos1 l=180n w=1u m=1
	mnc01 (net13 net69 net12 vssa) nmos1 l=180n w=1u m=1
	mpb02 (net27 net51 net158 vdda) pmos1 l=180n w=1u m=1
	mppd1 (net158 xpd vdda vdda) pmos1 l=180n w=1u m=1
	mps11 (net31 net158 vdda vdda) pmos1 l=180n w=1u m=1
	mpd11 (net56 inn net31 net31) pmos1 l=180n w=1u m=1
	mp001 (out net158 vdda vdda) pmos1 l=180n w=1u m=1
	mpd12 (net13 inp net31 net31) pmos1 l=180n w=1u m=1
	mpb01 (net158 net158 vdda vdda) pmos1 l=2.8e-07n w=9.7e-07u m=1
ends OPAMP1_variant655

subckt OPAMP1_variant656 inn inp out pd xpd vdda vssa
	xd1 (vssa vdda) prim_nwd AREA=6.13907e-9 PJ=476.6e-6 m=1
	xi0 (vssa net69) prim_nd AREA=1e-12 PJ=4e-6 m=1
	xi3 (net51 vdda) prim_pd AREA=790e-15 PJ=3.3e-6 m=1
	xr0 (vssa vdda net51) prim_rdiffp l=2.1e-6 w=700e-9 m=1
	xr1 (vdda vdda net69) prim_rdiffp l=2.1e-6 w=700e-9 m=1
	xcc01 (net12 out) prim_cpoly c=1p m=1
	mnm12 (net13 net56 vssa vssa) nmos1 l=180n w=1u m=1
	mnm11 (net56 net56 vssa vssa) nmos1 l=180n w=1u m=1
	mnb02 (net27 net27 net21 vssa) nmos1 l=180n w=1u m=1
	mnpd1 (net21 xpd vssa vssa) nmos1 l=2.2e-07n w=1.1e-06u m=1
	mn001 (out net13 vssa vssa) nmos1 l=180n w=1u m=1
	mnpd2 (net13 pd vssa vssa) nmos1 l=180n w=1u m=1
	mnc01 (net13 net69 net12 vssa) nmos1 l=180n w=1u m=1
	mpb02 (net27 net51 net158 vdda) pmos1 l=180n w=1u m=1
	mppd1 (net158 xpd vdda vdda) pmos1 l=180n w=1u m=1
	mps11 (net31 net158 vdda vdda) pmos1 l=1.5e-07n w=1.8e-06u m=1
	mpd11 (net56 inn net31 net31) pmos1 l=1.7e-07n w=1.6e-06u m=1
	mp001 (out net158 vdda vdda) pmos1 l=180n w=1u m=1
	mpd12 (net13 inp net31 net31) pmos1 l=1.0e-07n w=9.8e-07u m=1
	mpb01 (net158 net158 vdda vdda) pmos1 l=1.8e-07n w=1.9e-06u m=1
ends OPAMP1_variant656

subckt OPAMP1_variant657 inn inp out pd xpd vdda vssa
	xd1 (vssa vdda) prim_nwd AREA=6.13907e-9 PJ=476.6e-6 m=1
	xi0 (vssa net69) prim_nd AREA=1e-12 PJ=4e-6 m=1
	xi3 (net51 vdda) prim_pd AREA=790e-15 PJ=3.3e-6 m=1
	xr0 (vssa vdda net51) prim_rdiffp l=2.1e-6 w=700e-9 m=1
	xr1 (vdda vdda net69) prim_rdiffp l=2.1e-6 w=700e-9 m=1
	xcc01 (net12 out) prim_cpoly c=1p m=1
	mnm12 (net13 net56 vssa vssa) nmos1 l=180n w=1u m=1
	mnm11 (net56 net56 vssa vssa) nmos1 l=180n w=1u m=1
	mnb02 (net27 net27 net21 vssa) nmos1 l=180n w=1u m=1
	mnpd1 (net21 xpd vssa vssa) nmos1 l=180n w=1u m=1
	mn001 (out net13 vssa vssa) nmos1 l=180n w=1u m=1
	mnpd2 (net13 pd vssa vssa) nmos1 l=180n w=1u m=1
	mnc01 (net13 net69 net12 vssa) nmos1 l=180n w=1u m=1
	mpb02 (net27 net51 net158 vdda) pmos1 l=2.2e-07n w=1.4e-06u m=1
	mppd1 (net158 xpd vdda vdda) pmos1 l=2.2e-07n w=1.9e-06u m=1
	mps11 (net31 net158 vdda vdda) pmos1 l=180n w=1u m=1
	mpd11 (net56 inn net31 net31) pmos1 l=180n w=1u m=1
	mp001 (out net158 vdda vdda) pmos1 l=180n w=1u m=1
	mpd12 (net13 inp net31 net31) pmos1 l=180n w=1u m=1
	mpb01 (net158 net158 vdda vdda) pmos1 l=180n w=1u m=1
ends OPAMP1_variant657

subckt OPAMP1_variant658 inn inp out pd xpd vdda vssa
	xd1 (vssa vdda) prim_nwd AREA=6.13907e-9 PJ=476.6e-6 m=1
	xi0 (vssa net69) prim_nd AREA=1e-12 PJ=4e-6 m=1
	xi3 (net51 vdda) prim_pd AREA=790e-15 PJ=3.3e-6 m=1
	xr0 (vssa vdda net51) prim_rdiffp l=2.1e-6 w=700e-9 m=1
	xr1 (vdda vdda net69) prim_rdiffp l=2.1e-6 w=700e-9 m=1
	xcc01 (net12 out) prim_cpoly c=1.4e-12p m=1
	mnm12 (net13 net56 vssa vssa) nmos1 l=180n w=1u m=1
	mnm11 (net56 net56 vssa vssa) nmos1 l=2.8e-07n w=2.0e-06u m=1
	mnb02 (net27 net27 net21 vssa) nmos1 l=180n w=1u m=1
	mnpd1 (net21 xpd vssa vssa) nmos1 l=180n w=1u m=1
	mn001 (out net13 vssa vssa) nmos1 l=180n w=1u m=1
	mnpd2 (net13 pd vssa vssa) nmos1 l=1.4e-07n w=1.7e-06u m=1
	mnc01 (net13 net69 net12 vssa) nmos1 l=1.3e-07n w=1.1e-06u m=1
	mpb02 (net27 net51 net158 vdda) pmos1 l=2.3e-07n w=1.1e-06u m=1
	mppd1 (net158 xpd vdda vdda) pmos1 l=180n w=1u m=1
	mps11 (net31 net158 vdda vdda) pmos1 l=180n w=1u m=1
	mpd11 (net56 inn net31 net31) pmos1 l=180n w=1u m=1
	mp001 (out net158 vdda vdda) pmos1 l=180n w=1u m=1
	mpd12 (net13 inp net31 net31) pmos1 l=180n w=1u m=1
	mpb01 (net158 net158 vdda vdda) pmos1 l=180n w=1u m=1
ends OPAMP1_variant658

subckt OPAMP1_variant659 inn inp out pd xpd vdda vssa
	xd1 (vssa vdda) prim_nwd AREA=6.13907e-9 PJ=476.6e-6 m=1
	xi0 (vssa net69) prim_nd AREA=3.8e-09 PJ=7.1e-05 m=1
	xi3 (net51 vdda) prim_pd AREA=790e-15 PJ=3.3e-6 m=1
	xr0 (vssa vdda net51) prim_rdiffp l=2.1e-6 w=700e-9 m=1
	xr1 (vdda vdda net69) prim_rdiffp l=2.1e-6 w=700e-9 m=1
	xcc01 (net12 out) prim_cpoly c=1p m=1
	mnm12 (net13 net56 vssa vssa) nmos1 l=180n w=1u m=1
	mnm11 (net56 net56 vssa vssa) nmos1 l=180n w=1u m=1
	mnb02 (net27 net27 net21 vssa) nmos1 l=180n w=1u m=1
	mnpd1 (net21 xpd vssa vssa) nmos1 l=180n w=1u m=1
	mn001 (out net13 vssa vssa) nmos1 l=180n w=1u m=1
	mnpd2 (net13 pd vssa vssa) nmos1 l=180n w=1u m=1
	mnc01 (net13 net69 net12 vssa) nmos1 l=2.6e-07n w=1.6e-06u m=1
	mpb02 (net27 net51 net158 vdda) pmos1 l=180n w=1u m=1
	mppd1 (net158 xpd vdda vdda) pmos1 l=180n w=1u m=1
	mps11 (net31 net158 vdda vdda) pmos1 l=180n w=1u m=1
	mpd11 (net56 inn net31 net31) pmos1 l=180n w=1u m=1
	mp001 (out net158 vdda vdda) pmos1 l=2.7e-07n w=1.9e-06u m=1
	mpd12 (net13 inp net31 net31) pmos1 l=180n w=1u m=1
	mpb01 (net158 net158 vdda vdda) pmos1 l=180n w=1u m=1
ends OPAMP1_variant659

subckt OPAMP1_variant660 inn inp out pd xpd vdda vssa
	xd1 (vssa vdda) prim_nwd AREA=6.13907e-9 PJ=476.6e-6 m=1
	xi0 (vssa net69) prim_nd AREA=1e-12 PJ=4e-6 m=1
	xi3 (net51 vdda) prim_pd AREA=790e-15 PJ=3.3e-6 m=1
	xr0 (vssa vdda net51) prim_rdiffp l=2.1e-6 w=700e-9 m=1
	xr1 (vdda vdda net69) prim_rdiffp l=2.1e-6 w=700e-9 m=1
	xcc01 (net12 out) prim_cpoly c=1.2e-12p m=1
	mnm12 (net13 net56 vssa vssa) nmos1 l=180n w=1u m=1
	mnm11 (net56 net56 vssa vssa) nmos1 l=180n w=1u m=1
	mnb02 (net27 net27 net21 vssa) nmos1 l=2.9e-07n w=1.2e-06u m=1
	mnpd1 (net21 xpd vssa vssa) nmos1 l=2.7e-07n w=1.9e-06u m=1
	mn001 (out net13 vssa vssa) nmos1 l=180n w=1u m=1
	mnpd2 (net13 pd vssa vssa) nmos1 l=180n w=1u m=1
	mnc01 (net13 net69 net12 vssa) nmos1 l=180n w=1u m=1
	mpb02 (net27 net51 net158 vdda) pmos1 l=180n w=1u m=1
	mppd1 (net158 xpd vdda vdda) pmos1 l=180n w=1u m=1
	mps11 (net31 net158 vdda vdda) pmos1 l=180n w=1u m=1
	mpd11 (net56 inn net31 net31) pmos1 l=180n w=1u m=1
	mp001 (out net158 vdda vdda) pmos1 l=1.3e-07n w=1.9e-06u m=1
	mpd12 (net13 inp net31 net31) pmos1 l=180n w=1u m=1
	mpb01 (net158 net158 vdda vdda) pmos1 l=180n w=1u m=1
ends OPAMP1_variant660

subckt OPAMP1_variant661 inn inp out pd xpd vdda vssa
	xd1 (vssa vdda) prim_nwd AREA=6.8e-09 PJ=2.0e-06 m=1
	xi0 (vssa net69) prim_nd AREA=1e-12 PJ=4e-6 m=1
	xi3 (net51 vdda) prim_pd AREA=790e-15 PJ=3.3e-6 m=1
	xr0 (vssa vdda net51) prim_rdiffp l=2.1e-6 w=700e-9 m=1
	xr1 (vdda vdda net69) prim_rdiffp l=2.1e-6 w=700e-9 m=1
	xcc01 (net12 out) prim_cpoly c=1.1e-12p m=1
	mnm12 (net13 net56 vssa vssa) nmos1 l=180n w=1u m=1
	mnm11 (net56 net56 vssa vssa) nmos1 l=180n w=1u m=1
	mnb02 (net27 net27 net21 vssa) nmos1 l=180n w=1u m=1
	mnpd1 (net21 xpd vssa vssa) nmos1 l=180n w=1u m=1
	mn001 (out net13 vssa vssa) nmos1 l=180n w=1u m=1
	mnpd2 (net13 pd vssa vssa) nmos1 l=180n w=1u m=1
	mnc01 (net13 net69 net12 vssa) nmos1 l=180n w=1u m=1
	mpb02 (net27 net51 net158 vdda) pmos1 l=180n w=1u m=1
	mppd1 (net158 xpd vdda vdda) pmos1 l=1.9e-07n w=1.7e-06u m=1
	mps11 (net31 net158 vdda vdda) pmos1 l=2.1e-07n w=1.4e-06u m=1
	mpd11 (net56 inn net31 net31) pmos1 l=180n w=1u m=1
	mp001 (out net158 vdda vdda) pmos1 l=2.7e-07n w=1.9e-06u m=1
	mpd12 (net13 inp net31 net31) pmos1 l=180n w=1u m=1
	mpb01 (net158 net158 vdda vdda) pmos1 l=180n w=1u m=1
ends OPAMP1_variant661

subckt OPAMP1_variant662 inn inp out pd xpd vdda vssa
	xd1 (vssa vdda) prim_nwd AREA=6.13907e-9 PJ=476.6e-6 m=1
	xi0 (vssa net69) prim_nd AREA=1e-12 PJ=4e-6 m=1
	xi3 (net51 vdda) prim_pd AREA=790e-15 PJ=3.3e-6 m=1
	xr0 (vssa vdda net51) prim_rdiffp l=2.1e-6 w=700e-9 m=1
	xr1 (vdda vdda net69) prim_rdiffp l=2.1e-6 w=700e-9 m=1
	xcc01 (net12 out) prim_cpoly c=1.9e-12p m=1
	mnm12 (net13 net56 vssa vssa) nmos1 l=180n w=1u m=1
	mnm11 (net56 net56 vssa vssa) nmos1 l=180n w=1u m=1
	mnb02 (net27 net27 net21 vssa) nmos1 l=2.3e-07n w=7.9e-07u m=1
	mnpd1 (net21 xpd vssa vssa) nmos1 l=180n w=1u m=1
	mn001 (out net13 vssa vssa) nmos1 l=180n w=1u m=1
	mnpd2 (net13 pd vssa vssa) nmos1 l=2.8e-07n w=1.6e-06u m=1
	mnc01 (net13 net69 net12 vssa) nmos1 l=1.2e-07n w=1.7e-06u m=1
	mpb02 (net27 net51 net158 vdda) pmos1 l=180n w=1u m=1
	mppd1 (net158 xpd vdda vdda) pmos1 l=180n w=1u m=1
	mps11 (net31 net158 vdda vdda) pmos1 l=180n w=1u m=1
	mpd11 (net56 inn net31 net31) pmos1 l=180n w=1u m=1
	mp001 (out net158 vdda vdda) pmos1 l=180n w=1u m=1
	mpd12 (net13 inp net31 net31) pmos1 l=180n w=1u m=1
	mpb01 (net158 net158 vdda vdda) pmos1 l=1.5e-07n w=1.4e-06u m=1
ends OPAMP1_variant662

subckt OPAMP1_variant663 inn inp out pd xpd vdda vssa
	xd1 (vssa vdda) prim_nwd AREA=6.13907e-9 PJ=476.6e-6 m=1
	xi0 (vssa net69) prim_nd AREA=1e-12 PJ=4e-6 m=1
	xi3 (net51 vdda) prim_pd AREA=790e-15 PJ=3.3e-6 m=1
	xr0 (vssa vdda net51) prim_rdiffp l=2.1e-6 w=700e-9 m=1
	xr1 (vdda vdda net69) prim_rdiffp l=1.1e-07 w=1.8e-06 m=1
	xcc01 (net12 out) prim_cpoly c=1p m=1
	mnm12 (net13 net56 vssa vssa) nmos1 l=180n w=1u m=1
	mnm11 (net56 net56 vssa vssa) nmos1 l=180n w=1u m=1
	mnb02 (net27 net27 net21 vssa) nmos1 l=180n w=1u m=1
	mnpd1 (net21 xpd vssa vssa) nmos1 l=180n w=1u m=1
	mn001 (out net13 vssa vssa) nmos1 l=2.7e-07n w=7.7e-07u m=1
	mnpd2 (net13 pd vssa vssa) nmos1 l=180n w=1u m=1
	mnc01 (net13 net69 net12 vssa) nmos1 l=180n w=1u m=1
	mpb02 (net27 net51 net158 vdda) pmos1 l=180n w=1u m=1
	mppd1 (net158 xpd vdda vdda) pmos1 l=180n w=1u m=1
	mps11 (net31 net158 vdda vdda) pmos1 l=180n w=1u m=1
	mpd11 (net56 inn net31 net31) pmos1 l=180n w=1u m=1
	mp001 (out net158 vdda vdda) pmos1 l=180n w=1u m=1
	mpd12 (net13 inp net31 net31) pmos1 l=180n w=1u m=1
	mpb01 (net158 net158 vdda vdda) pmos1 l=2.2e-07n w=1.8e-06u m=1
ends OPAMP1_variant663

subckt OPAMP1_variant664 inn inp out pd xpd vdda vssa
	xd1 (vssa vdda) prim_nwd AREA=6.13907e-9 PJ=476.6e-6 m=1
	xi0 (vssa net69) prim_nd AREA=1e-12 PJ=4e-6 m=1
	xi3 (net51 vdda) prim_pd AREA=790e-15 PJ=3.3e-6 m=1
	xr0 (vssa vdda net51) prim_rdiffp l=2.1e-07 w=2.0e-06 m=1
	xr1 (vdda vdda net69) prim_rdiffp l=2.1e-6 w=700e-9 m=1
	xcc01 (net12 out) prim_cpoly c=1p m=1
	mnm12 (net13 net56 vssa vssa) nmos1 l=2.0e-07n w=1.5e-06u m=1
	mnm11 (net56 net56 vssa vssa) nmos1 l=180n w=1u m=1
	mnb02 (net27 net27 net21 vssa) nmos1 l=2.4e-07n w=7.4e-07u m=1
	mnpd1 (net21 xpd vssa vssa) nmos1 l=180n w=1u m=1
	mn001 (out net13 vssa vssa) nmos1 l=180n w=1u m=1
	mnpd2 (net13 pd vssa vssa) nmos1 l=180n w=1u m=1
	mnc01 (net13 net69 net12 vssa) nmos1 l=180n w=1u m=1
	mpb02 (net27 net51 net158 vdda) pmos1 l=180n w=1u m=1
	mppd1 (net158 xpd vdda vdda) pmos1 l=180n w=1u m=1
	mps11 (net31 net158 vdda vdda) pmos1 l=180n w=1u m=1
	mpd11 (net56 inn net31 net31) pmos1 l=1.1e-07n w=1.6e-06u m=1
	mp001 (out net158 vdda vdda) pmos1 l=180n w=1u m=1
	mpd12 (net13 inp net31 net31) pmos1 l=180n w=1u m=1
	mpb01 (net158 net158 vdda vdda) pmos1 l=3.0e-07n w=1.0e-06u m=1
ends OPAMP1_variant664

subckt OPAMP1_variant665 inn inp out pd xpd vdda vssa
	xd1 (vssa vdda) prim_nwd AREA=6.13907e-9 PJ=476.6e-6 m=1
	xi0 (vssa net69) prim_nd AREA=1.5e-09 PJ=4.9e-05 m=1
	xi3 (net51 vdda) prim_pd AREA=790e-15 PJ=3.3e-6 m=1
	xr0 (vssa vdda net51) prim_rdiffp l=2.1e-6 w=700e-9 m=1
	xr1 (vdda vdda net69) prim_rdiffp l=2.1e-6 w=700e-9 m=1
	xcc01 (net12 out) prim_cpoly c=1p m=1
	mnm12 (net13 net56 vssa vssa) nmos1 l=2.0e-07n w=1.6e-06u m=1
	mnm11 (net56 net56 vssa vssa) nmos1 l=180n w=1u m=1
	mnb02 (net27 net27 net21 vssa) nmos1 l=2.7e-07n w=8.5e-07u m=1
	mnpd1 (net21 xpd vssa vssa) nmos1 l=180n w=1u m=1
	mn001 (out net13 vssa vssa) nmos1 l=180n w=1u m=1
	mnpd2 (net13 pd vssa vssa) nmos1 l=180n w=1u m=1
	mnc01 (net13 net69 net12 vssa) nmos1 l=180n w=1u m=1
	mpb02 (net27 net51 net158 vdda) pmos1 l=2.0e-07n w=1.8e-06u m=1
	mppd1 (net158 xpd vdda vdda) pmos1 l=180n w=1u m=1
	mps11 (net31 net158 vdda vdda) pmos1 l=180n w=1u m=1
	mpd11 (net56 inn net31 net31) pmos1 l=180n w=1u m=1
	mp001 (out net158 vdda vdda) pmos1 l=180n w=1u m=1
	mpd12 (net13 inp net31 net31) pmos1 l=180n w=1u m=1
	mpb01 (net158 net158 vdda vdda) pmos1 l=2.3e-07n w=7.1e-07u m=1
ends OPAMP1_variant665

subckt OPAMP1_variant666 inn inp out pd xpd vdda vssa
	xd1 (vssa vdda) prim_nwd AREA=6.13907e-9 PJ=476.6e-6 m=1
	xi0 (vssa net69) prim_nd AREA=1e-12 PJ=4e-6 m=1
	xi3 (net51 vdda) prim_pd AREA=790e-15 PJ=3.3e-6 m=1
	xr0 (vssa vdda net51) prim_rdiffp l=2.1e-6 w=700e-9 m=1
	xr1 (vdda vdda net69) prim_rdiffp l=2.1e-6 w=700e-9 m=1
	xcc01 (net12 out) prim_cpoly c=1p m=1
	mnm12 (net13 net56 vssa vssa) nmos1 l=180n w=1u m=1
	mnm11 (net56 net56 vssa vssa) nmos1 l=180n w=1u m=1
	mnb02 (net27 net27 net21 vssa) nmos1 l=180n w=1u m=1
	mnpd1 (net21 xpd vssa vssa) nmos1 l=180n w=1u m=1
	mn001 (out net13 vssa vssa) nmos1 l=180n w=1u m=1
	mnpd2 (net13 pd vssa vssa) nmos1 l=180n w=1u m=1
	mnc01 (net13 net69 net12 vssa) nmos1 l=2.2e-07n w=1.0e-06u m=1
	mpb02 (net27 net51 net158 vdda) pmos1 l=1.4e-07n w=6.2e-07u m=1
	mppd1 (net158 xpd vdda vdda) pmos1 l=180n w=1u m=1
	mps11 (net31 net158 vdda vdda) pmos1 l=2.8e-07n w=1.4e-06u m=1
	mpd11 (net56 inn net31 net31) pmos1 l=2.7e-07n w=1.6e-06u m=1
	mp001 (out net158 vdda vdda) pmos1 l=180n w=1u m=1
	mpd12 (net13 inp net31 net31) pmos1 l=180n w=1u m=1
	mpb01 (net158 net158 vdda vdda) pmos1 l=2.2e-07n w=1.8e-06u m=1
ends OPAMP1_variant666

subckt OPAMP1_variant667 inn inp out pd xpd vdda vssa
	xd1 (vssa vdda) prim_nwd AREA=6.13907e-9 PJ=476.6e-6 m=1
	xi0 (vssa net69) prim_nd AREA=1e-12 PJ=4e-6 m=1
	xi3 (net51 vdda) prim_pd AREA=2.8e-09 PJ=5.3e-05 m=1
	xr0 (vssa vdda net51) prim_rdiffp l=1.8e-07 w=6.1e-07 m=1
	xr1 (vdda vdda net69) prim_rdiffp l=2.1e-6 w=700e-9 m=1
	xcc01 (net12 out) prim_cpoly c=1p m=1
	mnm12 (net13 net56 vssa vssa) nmos1 l=180n w=1u m=1
	mnm11 (net56 net56 vssa vssa) nmos1 l=180n w=1u m=1
	mnb02 (net27 net27 net21 vssa) nmos1 l=180n w=1u m=1
	mnpd1 (net21 xpd vssa vssa) nmos1 l=1.3e-07n w=1.3e-06u m=1
	mn001 (out net13 vssa vssa) nmos1 l=180n w=1u m=1
	mnpd2 (net13 pd vssa vssa) nmos1 l=180n w=1u m=1
	mnc01 (net13 net69 net12 vssa) nmos1 l=180n w=1u m=1
	mpb02 (net27 net51 net158 vdda) pmos1 l=180n w=1u m=1
	mppd1 (net158 xpd vdda vdda) pmos1 l=180n w=1u m=1
	mps11 (net31 net158 vdda vdda) pmos1 l=180n w=1u m=1
	mpd11 (net56 inn net31 net31) pmos1 l=180n w=1u m=1
	mp001 (out net158 vdda vdda) pmos1 l=180n w=1u m=1
	mpd12 (net13 inp net31 net31) pmos1 l=180n w=1u m=1
	mpb01 (net158 net158 vdda vdda) pmos1 l=180n w=1u m=1
ends OPAMP1_variant667

subckt OPAMP1_variant668 inn inp out pd xpd vdda vssa
	xd1 (vssa vdda) prim_nwd AREA=6.13907e-9 PJ=476.6e-6 m=1
	xi0 (vssa net69) prim_nd AREA=1e-12 PJ=4e-6 m=1
	xi3 (net51 vdda) prim_pd AREA=790e-15 PJ=3.3e-6 m=1
	xr0 (vssa vdda net51) prim_rdiffp l=2.1e-6 w=700e-9 m=1
	xr1 (vdda vdda net69) prim_rdiffp l=2.0e-07 w=1.1e-06 m=1
	xcc01 (net12 out) prim_cpoly c=1p m=1
	mnm12 (net13 net56 vssa vssa) nmos1 l=2.0e-07n w=8.0e-07u m=1
	mnm11 (net56 net56 vssa vssa) nmos1 l=180n w=1u m=1
	mnb02 (net27 net27 net21 vssa) nmos1 l=180n w=1u m=1
	mnpd1 (net21 xpd vssa vssa) nmos1 l=180n w=1u m=1
	mn001 (out net13 vssa vssa) nmos1 l=180n w=1u m=1
	mnpd2 (net13 pd vssa vssa) nmos1 l=1.2e-07n w=6.7e-07u m=1
	mnc01 (net13 net69 net12 vssa) nmos1 l=180n w=1u m=1
	mpb02 (net27 net51 net158 vdda) pmos1 l=180n w=1u m=1
	mppd1 (net158 xpd vdda vdda) pmos1 l=180n w=1u m=1
	mps11 (net31 net158 vdda vdda) pmos1 l=180n w=1u m=1
	mpd11 (net56 inn net31 net31) pmos1 l=180n w=1u m=1
	mp001 (out net158 vdda vdda) pmos1 l=180n w=1u m=1
	mpd12 (net13 inp net31 net31) pmos1 l=180n w=1u m=1
	mpb01 (net158 net158 vdda vdda) pmos1 l=180n w=1u m=1
ends OPAMP1_variant668

subckt OPAMP1_variant669 inn inp out pd xpd vdda vssa
	xd1 (vssa vdda) prim_nwd AREA=6.13907e-9 PJ=476.6e-6 m=1
	xi0 (vssa net69) prim_nd AREA=1e-12 PJ=4e-6 m=1
	xi3 (net51 vdda) prim_pd AREA=8.9e-09 PJ=9.4e-05 m=1
	xr0 (vssa vdda net51) prim_rdiffp l=2.1e-6 w=700e-9 m=1
	xr1 (vdda vdda net69) prim_rdiffp l=2.1e-6 w=700e-9 m=1
	xcc01 (net12 out) prim_cpoly c=1p m=1
	mnm12 (net13 net56 vssa vssa) nmos1 l=180n w=1u m=1
	mnm11 (net56 net56 vssa vssa) nmos1 l=180n w=1u m=1
	mnb02 (net27 net27 net21 vssa) nmos1 l=180n w=1u m=1
	mnpd1 (net21 xpd vssa vssa) nmos1 l=2.3e-07n w=1.2e-06u m=1
	mn001 (out net13 vssa vssa) nmos1 l=180n w=1u m=1
	mnpd2 (net13 pd vssa vssa) nmos1 l=180n w=1u m=1
	mnc01 (net13 net69 net12 vssa) nmos1 l=180n w=1u m=1
	mpb02 (net27 net51 net158 vdda) pmos1 l=180n w=1u m=1
	mppd1 (net158 xpd vdda vdda) pmos1 l=180n w=1u m=1
	mps11 (net31 net158 vdda vdda) pmos1 l=180n w=1u m=1
	mpd11 (net56 inn net31 net31) pmos1 l=180n w=1u m=1
	mp001 (out net158 vdda vdda) pmos1 l=180n w=1u m=1
	mpd12 (net13 inp net31 net31) pmos1 l=180n w=1u m=1
	mpb01 (net158 net158 vdda vdda) pmos1 l=180n w=1u m=1
ends OPAMP1_variant669

subckt OPAMP1_variant670 inn inp out pd xpd vdda vssa
	xd1 (vssa vdda) prim_nwd AREA=6.13907e-9 PJ=476.6e-6 m=1
	xi0 (vssa net69) prim_nd AREA=1e-12 PJ=4e-6 m=1
	xi3 (net51 vdda) prim_pd AREA=790e-15 PJ=3.3e-6 m=1
	xr0 (vssa vdda net51) prim_rdiffp l=2.1e-6 w=700e-9 m=1
	xr1 (vdda vdda net69) prim_rdiffp l=2.1e-6 w=700e-9 m=1
	xcc01 (net12 out) prim_cpoly c=1p m=1
	mnm12 (net13 net56 vssa vssa) nmos1 l=180n w=1u m=1
	mnm11 (net56 net56 vssa vssa) nmos1 l=180n w=1u m=1
	mnb02 (net27 net27 net21 vssa) nmos1 l=1.1e-07n w=1.5e-06u m=1
	mnpd1 (net21 xpd vssa vssa) nmos1 l=2.8e-07n w=9.4e-07u m=1
	mn001 (out net13 vssa vssa) nmos1 l=1.1e-07n w=9.0e-07u m=1
	mnpd2 (net13 pd vssa vssa) nmos1 l=180n w=1u m=1
	mnc01 (net13 net69 net12 vssa) nmos1 l=2.6e-07n w=7.7e-07u m=1
	mpb02 (net27 net51 net158 vdda) pmos1 l=180n w=1u m=1
	mppd1 (net158 xpd vdda vdda) pmos1 l=180n w=1u m=1
	mps11 (net31 net158 vdda vdda) pmos1 l=180n w=1u m=1
	mpd11 (net56 inn net31 net31) pmos1 l=180n w=1u m=1
	mp001 (out net158 vdda vdda) pmos1 l=180n w=1u m=1
	mpd12 (net13 inp net31 net31) pmos1 l=180n w=1u m=1
	mpb01 (net158 net158 vdda vdda) pmos1 l=1.8e-07n w=2.0e-06u m=1
ends OPAMP1_variant670

subckt OPAMP1_variant671 inn inp out pd xpd vdda vssa
	xd1 (vssa vdda) prim_nwd AREA=6.13907e-9 PJ=476.6e-6 m=1
	xi0 (vssa net69) prim_nd AREA=1e-12 PJ=4e-6 m=1
	xi3 (net51 vdda) prim_pd AREA=790e-15 PJ=3.3e-6 m=1
	xr0 (vssa vdda net51) prim_rdiffp l=3.0e-07 w=1.2e-06 m=1
	xr1 (vdda vdda net69) prim_rdiffp l=2.2e-07 w=5.2e-07 m=1
	xcc01 (net12 out) prim_cpoly c=1p m=1
	mnm12 (net13 net56 vssa vssa) nmos1 l=180n w=1u m=1
	mnm11 (net56 net56 vssa vssa) nmos1 l=180n w=1u m=1
	mnb02 (net27 net27 net21 vssa) nmos1 l=180n w=1u m=1
	mnpd1 (net21 xpd vssa vssa) nmos1 l=180n w=1u m=1
	mn001 (out net13 vssa vssa) nmos1 l=1.9e-07n w=1.8e-06u m=1
	mnpd2 (net13 pd vssa vssa) nmos1 l=180n w=1u m=1
	mnc01 (net13 net69 net12 vssa) nmos1 l=1.4e-07n w=1.8e-06u m=1
	mpb02 (net27 net51 net158 vdda) pmos1 l=180n w=1u m=1
	mppd1 (net158 xpd vdda vdda) pmos1 l=1.4e-07n w=1.6e-06u m=1
	mps11 (net31 net158 vdda vdda) pmos1 l=180n w=1u m=1
	mpd11 (net56 inn net31 net31) pmos1 l=180n w=1u m=1
	mp001 (out net158 vdda vdda) pmos1 l=180n w=1u m=1
	mpd12 (net13 inp net31 net31) pmos1 l=180n w=1u m=1
	mpb01 (net158 net158 vdda vdda) pmos1 l=180n w=1u m=1
ends OPAMP1_variant671

subckt OPAMP1_variant672 inn inp out pd xpd vdda vssa
	xd1 (vssa vdda) prim_nwd AREA=6.13907e-9 PJ=476.6e-6 m=1
	xi0 (vssa net69) prim_nd AREA=1e-12 PJ=4e-6 m=1
	xi3 (net51 vdda) prim_pd AREA=790e-15 PJ=3.3e-6 m=1
	xr0 (vssa vdda net51) prim_rdiffp l=2.1e-6 w=700e-9 m=1
	xr1 (vdda vdda net69) prim_rdiffp l=2.1e-6 w=700e-9 m=1
	xcc01 (net12 out) prim_cpoly c=1p m=1
	mnm12 (net13 net56 vssa vssa) nmos1 l=2.4e-07n w=1.2e-06u m=1
	mnm11 (net56 net56 vssa vssa) nmos1 l=180n w=1u m=1
	mnb02 (net27 net27 net21 vssa) nmos1 l=180n w=1u m=1
	mnpd1 (net21 xpd vssa vssa) nmos1 l=180n w=1u m=1
	mn001 (out net13 vssa vssa) nmos1 l=180n w=1u m=1
	mnpd2 (net13 pd vssa vssa) nmos1 l=180n w=1u m=1
	mnc01 (net13 net69 net12 vssa) nmos1 l=180n w=1u m=1
	mpb02 (net27 net51 net158 vdda) pmos1 l=180n w=1u m=1
	mppd1 (net158 xpd vdda vdda) pmos1 l=1.6e-07n w=1.5e-06u m=1
	mps11 (net31 net158 vdda vdda) pmos1 l=180n w=1u m=1
	mpd11 (net56 inn net31 net31) pmos1 l=180n w=1u m=1
	mp001 (out net158 vdda vdda) pmos1 l=180n w=1u m=1
	mpd12 (net13 inp net31 net31) pmos1 l=180n w=1u m=1
	mpb01 (net158 net158 vdda vdda) pmos1 l=180n w=1u m=1
ends OPAMP1_variant672

subckt OPAMP1_variant673 inn inp out pd xpd vdda vssa
	xd1 (vssa vdda) prim_nwd AREA=6.13907e-9 PJ=476.6e-6 m=1
	xi0 (vssa net69) prim_nd AREA=1e-12 PJ=4e-6 m=1
	xi3 (net51 vdda) prim_pd AREA=790e-15 PJ=3.3e-6 m=1
	xr0 (vssa vdda net51) prim_rdiffp l=2.1e-6 w=700e-9 m=1
	xr1 (vdda vdda net69) prim_rdiffp l=2.1e-6 w=700e-9 m=1
	xcc01 (net12 out) prim_cpoly c=1p m=1
	mnm12 (net13 net56 vssa vssa) nmos1 l=2.0e-07n w=1.1e-06u m=1
	mnm11 (net56 net56 vssa vssa) nmos1 l=180n w=1u m=1
	mnb02 (net27 net27 net21 vssa) nmos1 l=180n w=1u m=1
	mnpd1 (net21 xpd vssa vssa) nmos1 l=180n w=1u m=1
	mn001 (out net13 vssa vssa) nmos1 l=180n w=1u m=1
	mnpd2 (net13 pd vssa vssa) nmos1 l=2.4e-07n w=5.7e-07u m=1
	mnc01 (net13 net69 net12 vssa) nmos1 l=180n w=1u m=1
	mpb02 (net27 net51 net158 vdda) pmos1 l=180n w=1u m=1
	mppd1 (net158 xpd vdda vdda) pmos1 l=180n w=1u m=1
	mps11 (net31 net158 vdda vdda) pmos1 l=180n w=1u m=1
	mpd11 (net56 inn net31 net31) pmos1 l=180n w=1u m=1
	mp001 (out net158 vdda vdda) pmos1 l=180n w=1u m=1
	mpd12 (net13 inp net31 net31) pmos1 l=180n w=1u m=1
	mpb01 (net158 net158 vdda vdda) pmos1 l=180n w=1u m=1
ends OPAMP1_variant673

subckt OPAMP1_variant674 inn inp out pd xpd vdda vssa
	xd1 (vssa vdda) prim_nwd AREA=6.13907e-9 PJ=476.6e-6 m=1
	xi0 (vssa net69) prim_nd AREA=1e-12 PJ=4e-6 m=1
	xi3 (net51 vdda) prim_pd AREA=790e-15 PJ=3.3e-6 m=1
	xr0 (vssa vdda net51) prim_rdiffp l=2.1e-6 w=700e-9 m=1
	xr1 (vdda vdda net69) prim_rdiffp l=2.1e-6 w=700e-9 m=1
	xcc01 (net12 out) prim_cpoly c=1p m=1
	mnm12 (net13 net56 vssa vssa) nmos1 l=1.0e-07n w=2.0e-06u m=1
	mnm11 (net56 net56 vssa vssa) nmos1 l=180n w=1u m=1
	mnb02 (net27 net27 net21 vssa) nmos1 l=180n w=1u m=1
	mnpd1 (net21 xpd vssa vssa) nmos1 l=180n w=1u m=1
	mn001 (out net13 vssa vssa) nmos1 l=180n w=1u m=1
	mnpd2 (net13 pd vssa vssa) nmos1 l=180n w=1u m=1
	mnc01 (net13 net69 net12 vssa) nmos1 l=180n w=1u m=1
	mpb02 (net27 net51 net158 vdda) pmos1 l=1.9e-07n w=6.5e-07u m=1
	mppd1 (net158 xpd vdda vdda) pmos1 l=2.5e-07n w=7.1e-07u m=1
	mps11 (net31 net158 vdda vdda) pmos1 l=180n w=1u m=1
	mpd11 (net56 inn net31 net31) pmos1 l=180n w=1u m=1
	mp001 (out net158 vdda vdda) pmos1 l=180n w=1u m=1
	mpd12 (net13 inp net31 net31) pmos1 l=180n w=1u m=1
	mpb01 (net158 net158 vdda vdda) pmos1 l=180n w=1u m=1
ends OPAMP1_variant674

subckt OPAMP1_variant675 inn inp out pd xpd vdda vssa
	xd1 (vssa vdda) prim_nwd AREA=9.7e-09 PJ=7.0e-05 m=1
	xi0 (vssa net69) prim_nd AREA=1e-12 PJ=4e-6 m=1
	xi3 (net51 vdda) prim_pd AREA=790e-15 PJ=3.3e-6 m=1
	xr0 (vssa vdda net51) prim_rdiffp l=2.1e-6 w=700e-9 m=1
	xr1 (vdda vdda net69) prim_rdiffp l=2.6e-07 w=1.5e-06 m=1
	xcc01 (net12 out) prim_cpoly c=1p m=1
	mnm12 (net13 net56 vssa vssa) nmos1 l=180n w=1u m=1
	mnm11 (net56 net56 vssa vssa) nmos1 l=2.2e-07n w=1.8e-06u m=1
	mnb02 (net27 net27 net21 vssa) nmos1 l=180n w=1u m=1
	mnpd1 (net21 xpd vssa vssa) nmos1 l=180n w=1u m=1
	mn001 (out net13 vssa vssa) nmos1 l=180n w=1u m=1
	mnpd2 (net13 pd vssa vssa) nmos1 l=180n w=1u m=1
	mnc01 (net13 net69 net12 vssa) nmos1 l=180n w=1u m=1
	mpb02 (net27 net51 net158 vdda) pmos1 l=180n w=1u m=1
	mppd1 (net158 xpd vdda vdda) pmos1 l=180n w=1u m=1
	mps11 (net31 net158 vdda vdda) pmos1 l=180n w=1u m=1
	mpd11 (net56 inn net31 net31) pmos1 l=2.9e-07n w=1.5e-06u m=1
	mp001 (out net158 vdda vdda) pmos1 l=180n w=1u m=1
	mpd12 (net13 inp net31 net31) pmos1 l=180n w=1u m=1
	mpb01 (net158 net158 vdda vdda) pmos1 l=180n w=1u m=1
ends OPAMP1_variant675

subckt OPAMP1_variant676 inn inp out pd xpd vdda vssa
	xd1 (vssa vdda) prim_nwd AREA=6.13907e-9 PJ=476.6e-6 m=1
	xi0 (vssa net69) prim_nd AREA=1e-12 PJ=4e-6 m=1
	xi3 (net51 vdda) prim_pd AREA=8.1e-09 PJ=1.5e-06 m=1
	xr0 (vssa vdda net51) prim_rdiffp l=2.1e-6 w=700e-9 m=1
	xr1 (vdda vdda net69) prim_rdiffp l=2.1e-6 w=700e-9 m=1
	xcc01 (net12 out) prim_cpoly c=1.7e-12p m=1
	mnm12 (net13 net56 vssa vssa) nmos1 l=2.3e-07n w=1.9e-06u m=1
	mnm11 (net56 net56 vssa vssa) nmos1 l=180n w=1u m=1
	mnb02 (net27 net27 net21 vssa) nmos1 l=180n w=1u m=1
	mnpd1 (net21 xpd vssa vssa) nmos1 l=180n w=1u m=1
	mn001 (out net13 vssa vssa) nmos1 l=180n w=1u m=1
	mnpd2 (net13 pd vssa vssa) nmos1 l=180n w=1u m=1
	mnc01 (net13 net69 net12 vssa) nmos1 l=180n w=1u m=1
	mpb02 (net27 net51 net158 vdda) pmos1 l=180n w=1u m=1
	mppd1 (net158 xpd vdda vdda) pmos1 l=180n w=1u m=1
	mps11 (net31 net158 vdda vdda) pmos1 l=180n w=1u m=1
	mpd11 (net56 inn net31 net31) pmos1 l=180n w=1u m=1
	mp001 (out net158 vdda vdda) pmos1 l=180n w=1u m=1
	mpd12 (net13 inp net31 net31) pmos1 l=2.8e-07n w=7.8e-07u m=1
	mpb01 (net158 net158 vdda vdda) pmos1 l=180n w=1u m=1
ends OPAMP1_variant676

subckt OPAMP1_variant677 inn inp out pd xpd vdda vssa
	xd1 (vssa vdda) prim_nwd AREA=6.13907e-9 PJ=476.6e-6 m=1
	xi0 (vssa net69) prim_nd AREA=1e-12 PJ=4e-6 m=1
	xi3 (net51 vdda) prim_pd AREA=790e-15 PJ=3.3e-6 m=1
	xr0 (vssa vdda net51) prim_rdiffp l=1.5e-07 w=1.3e-06 m=1
	xr1 (vdda vdda net69) prim_rdiffp l=2.1e-6 w=700e-9 m=1
	xcc01 (net12 out) prim_cpoly c=1p m=1
	mnm12 (net13 net56 vssa vssa) nmos1 l=2.8e-07n w=1.4e-06u m=1
	mnm11 (net56 net56 vssa vssa) nmos1 l=2.5e-07n w=1.5e-06u m=1
	mnb02 (net27 net27 net21 vssa) nmos1 l=180n w=1u m=1
	mnpd1 (net21 xpd vssa vssa) nmos1 l=180n w=1u m=1
	mn001 (out net13 vssa vssa) nmos1 l=180n w=1u m=1
	mnpd2 (net13 pd vssa vssa) nmos1 l=180n w=1u m=1
	mnc01 (net13 net69 net12 vssa) nmos1 l=180n w=1u m=1
	mpb02 (net27 net51 net158 vdda) pmos1 l=180n w=1u m=1
	mppd1 (net158 xpd vdda vdda) pmos1 l=180n w=1u m=1
	mps11 (net31 net158 vdda vdda) pmos1 l=2.8e-07n w=1.6e-06u m=1
	mpd11 (net56 inn net31 net31) pmos1 l=180n w=1u m=1
	mp001 (out net158 vdda vdda) pmos1 l=180n w=1u m=1
	mpd12 (net13 inp net31 net31) pmos1 l=180n w=1u m=1
	mpb01 (net158 net158 vdda vdda) pmos1 l=180n w=1u m=1
ends OPAMP1_variant677

subckt OPAMP1_variant678 inn inp out pd xpd vdda vssa
	xd1 (vssa vdda) prim_nwd AREA=6.13907e-9 PJ=476.6e-6 m=1
	xi0 (vssa net69) prim_nd AREA=1e-12 PJ=4e-6 m=1
	xi3 (net51 vdda) prim_pd AREA=790e-15 PJ=3.3e-6 m=1
	xr0 (vssa vdda net51) prim_rdiffp l=2.1e-6 w=700e-9 m=1
	xr1 (vdda vdda net69) prim_rdiffp l=2.1e-6 w=700e-9 m=1
	xcc01 (net12 out) prim_cpoly c=1p m=1
	mnm12 (net13 net56 vssa vssa) nmos1 l=180n w=1u m=1
	mnm11 (net56 net56 vssa vssa) nmos1 l=180n w=1u m=1
	mnb02 (net27 net27 net21 vssa) nmos1 l=180n w=1u m=1
	mnpd1 (net21 xpd vssa vssa) nmos1 l=180n w=1u m=1
	mn001 (out net13 vssa vssa) nmos1 l=1.2e-07n w=1.5e-06u m=1
	mnpd2 (net13 pd vssa vssa) nmos1 l=1.0e-07n w=2.0e-06u m=1
	mnc01 (net13 net69 net12 vssa) nmos1 l=180n w=1u m=1
	mpb02 (net27 net51 net158 vdda) pmos1 l=180n w=1u m=1
	mppd1 (net158 xpd vdda vdda) pmos1 l=180n w=1u m=1
	mps11 (net31 net158 vdda vdda) pmos1 l=2.0e-07n w=1.2e-06u m=1
	mpd11 (net56 inn net31 net31) pmos1 l=2.5e-07n w=1.4e-06u m=1
	mp001 (out net158 vdda vdda) pmos1 l=180n w=1u m=1
	mpd12 (net13 inp net31 net31) pmos1 l=180n w=1u m=1
	mpb01 (net158 net158 vdda vdda) pmos1 l=180n w=1u m=1
ends OPAMP1_variant678

subckt OPAMP1_variant679 inn inp out pd xpd vdda vssa
	xd1 (vssa vdda) prim_nwd AREA=2.7e-11 PJ=7.1e-05 m=1
	xi0 (vssa net69) prim_nd AREA=1e-12 PJ=4e-6 m=1
	xi3 (net51 vdda) prim_pd AREA=790e-15 PJ=3.3e-6 m=1
	xr0 (vssa vdda net51) prim_rdiffp l=3.0e-07 w=1.9e-06 m=1
	xr1 (vdda vdda net69) prim_rdiffp l=2.1e-6 w=700e-9 m=1
	xcc01 (net12 out) prim_cpoly c=1p m=1
	mnm12 (net13 net56 vssa vssa) nmos1 l=180n w=1u m=1
	mnm11 (net56 net56 vssa vssa) nmos1 l=180n w=1u m=1
	mnb02 (net27 net27 net21 vssa) nmos1 l=180n w=1u m=1
	mnpd1 (net21 xpd vssa vssa) nmos1 l=2.0e-07n w=1.2e-06u m=1
	mn001 (out net13 vssa vssa) nmos1 l=180n w=1u m=1
	mnpd2 (net13 pd vssa vssa) nmos1 l=180n w=1u m=1
	mnc01 (net13 net69 net12 vssa) nmos1 l=180n w=1u m=1
	mpb02 (net27 net51 net158 vdda) pmos1 l=180n w=1u m=1
	mppd1 (net158 xpd vdda vdda) pmos1 l=180n w=1u m=1
	mps11 (net31 net158 vdda vdda) pmos1 l=2.6e-07n w=1.9e-06u m=1
	mpd11 (net56 inn net31 net31) pmos1 l=180n w=1u m=1
	mp001 (out net158 vdda vdda) pmos1 l=180n w=1u m=1
	mpd12 (net13 inp net31 net31) pmos1 l=1.8e-07n w=6.7e-07u m=1
	mpb01 (net158 net158 vdda vdda) pmos1 l=180n w=1u m=1
ends OPAMP1_variant679

subckt OPAMP1_variant680 inn inp out pd xpd vdda vssa
	xd1 (vssa vdda) prim_nwd AREA=6.13907e-9 PJ=476.6e-6 m=1
	xi0 (vssa net69) prim_nd AREA=1.6e-09 PJ=5.4e-05 m=1
	xi3 (net51 vdda) prim_pd AREA=790e-15 PJ=3.3e-6 m=1
	xr0 (vssa vdda net51) prim_rdiffp l=2.1e-6 w=700e-9 m=1
	xr1 (vdda vdda net69) prim_rdiffp l=2.1e-6 w=700e-9 m=1
	xcc01 (net12 out) prim_cpoly c=1p m=1
	mnm12 (net13 net56 vssa vssa) nmos1 l=180n w=1u m=1
	mnm11 (net56 net56 vssa vssa) nmos1 l=180n w=1u m=1
	mnb02 (net27 net27 net21 vssa) nmos1 l=2.4e-07n w=8.9e-07u m=1
	mnpd1 (net21 xpd vssa vssa) nmos1 l=2.1e-07n w=1.1e-06u m=1
	mn001 (out net13 vssa vssa) nmos1 l=180n w=1u m=1
	mnpd2 (net13 pd vssa vssa) nmos1 l=180n w=1u m=1
	mnc01 (net13 net69 net12 vssa) nmos1 l=180n w=1u m=1
	mpb02 (net27 net51 net158 vdda) pmos1 l=180n w=1u m=1
	mppd1 (net158 xpd vdda vdda) pmos1 l=180n w=1u m=1
	mps11 (net31 net158 vdda vdda) pmos1 l=180n w=1u m=1
	mpd11 (net56 inn net31 net31) pmos1 l=180n w=1u m=1
	mp001 (out net158 vdda vdda) pmos1 l=2.3e-07n w=7.6e-07u m=1
	mpd12 (net13 inp net31 net31) pmos1 l=180n w=1u m=1
	mpb01 (net158 net158 vdda vdda) pmos1 l=180n w=1u m=1
ends OPAMP1_variant680

subckt OPAMP1_variant681 inn inp out pd xpd vdda vssa
	xd1 (vssa vdda) prim_nwd AREA=4.6e-09 PJ=9.6e-05 m=1
	xi0 (vssa net69) prim_nd AREA=9.6e-09 PJ=4.2e-05 m=1
	xi3 (net51 vdda) prim_pd AREA=790e-15 PJ=3.3e-6 m=1
	xr0 (vssa vdda net51) prim_rdiffp l=2.1e-6 w=700e-9 m=1
	xr1 (vdda vdda net69) prim_rdiffp l=2.1e-6 w=700e-9 m=1
	xcc01 (net12 out) prim_cpoly c=8.2e-13p m=1
	mnm12 (net13 net56 vssa vssa) nmos1 l=180n w=1u m=1
	mnm11 (net56 net56 vssa vssa) nmos1 l=180n w=1u m=1
	mnb02 (net27 net27 net21 vssa) nmos1 l=180n w=1u m=1
	mnpd1 (net21 xpd vssa vssa) nmos1 l=180n w=1u m=1
	mn001 (out net13 vssa vssa) nmos1 l=2.6e-07n w=6.4e-07u m=1
	mnpd2 (net13 pd vssa vssa) nmos1 l=180n w=1u m=1
	mnc01 (net13 net69 net12 vssa) nmos1 l=180n w=1u m=1
	mpb02 (net27 net51 net158 vdda) pmos1 l=180n w=1u m=1
	mppd1 (net158 xpd vdda vdda) pmos1 l=180n w=1u m=1
	mps11 (net31 net158 vdda vdda) pmos1 l=180n w=1u m=1
	mpd11 (net56 inn net31 net31) pmos1 l=180n w=1u m=1
	mp001 (out net158 vdda vdda) pmos1 l=180n w=1u m=1
	mpd12 (net13 inp net31 net31) pmos1 l=1.8e-07n w=6.8e-07u m=1
	mpb01 (net158 net158 vdda vdda) pmos1 l=180n w=1u m=1
ends OPAMP1_variant681

subckt OPAMP1_variant682 inn inp out pd xpd vdda vssa
	xd1 (vssa vdda) prim_nwd AREA=7.1e-09 PJ=9.6e-05 m=1
	xi0 (vssa net69) prim_nd AREA=1e-12 PJ=4e-6 m=1
	xi3 (net51 vdda) prim_pd AREA=7.2e-09 PJ=9.6e-05 m=1
	xr0 (vssa vdda net51) prim_rdiffp l=2.1e-6 w=700e-9 m=1
	xr1 (vdda vdda net69) prim_rdiffp l=2.1e-6 w=700e-9 m=1
	xcc01 (net12 out) prim_cpoly c=1p m=1
	mnm12 (net13 net56 vssa vssa) nmos1 l=180n w=1u m=1
	mnm11 (net56 net56 vssa vssa) nmos1 l=2.9e-07n w=8.2e-07u m=1
	mnb02 (net27 net27 net21 vssa) nmos1 l=180n w=1u m=1
	mnpd1 (net21 xpd vssa vssa) nmos1 l=180n w=1u m=1
	mn001 (out net13 vssa vssa) nmos1 l=180n w=1u m=1
	mnpd2 (net13 pd vssa vssa) nmos1 l=180n w=1u m=1
	mnc01 (net13 net69 net12 vssa) nmos1 l=180n w=1u m=1
	mpb02 (net27 net51 net158 vdda) pmos1 l=180n w=1u m=1
	mppd1 (net158 xpd vdda vdda) pmos1 l=180n w=1u m=1
	mps11 (net31 net158 vdda vdda) pmos1 l=180n w=1u m=1
	mpd11 (net56 inn net31 net31) pmos1 l=180n w=1u m=1
	mp001 (out net158 vdda vdda) pmos1 l=180n w=1u m=1
	mpd12 (net13 inp net31 net31) pmos1 l=2.8e-07n w=6.8e-07u m=1
	mpb01 (net158 net158 vdda vdda) pmos1 l=180n w=1u m=1
ends OPAMP1_variant682

subckt OPAMP1_variant683 inn inp out pd xpd vdda vssa
	xd1 (vssa vdda) prim_nwd AREA=6.13907e-9 PJ=476.6e-6 m=1
	xi0 (vssa net69) prim_nd AREA=1e-12 PJ=4e-6 m=1
	xi3 (net51 vdda) prim_pd AREA=790e-15 PJ=3.3e-6 m=1
	xr0 (vssa vdda net51) prim_rdiffp l=2.1e-6 w=700e-9 m=1
	xr1 (vdda vdda net69) prim_rdiffp l=2.1e-6 w=700e-9 m=1
	xcc01 (net12 out) prim_cpoly c=6.3e-13p m=1
	mnm12 (net13 net56 vssa vssa) nmos1 l=180n w=1u m=1
	mnm11 (net56 net56 vssa vssa) nmos1 l=2.3e-07n w=1.0e-06u m=1
	mnb02 (net27 net27 net21 vssa) nmos1 l=180n w=1u m=1
	mnpd1 (net21 xpd vssa vssa) nmos1 l=180n w=1u m=1
	mn001 (out net13 vssa vssa) nmos1 l=180n w=1u m=1
	mnpd2 (net13 pd vssa vssa) nmos1 l=1.2e-07n w=7.5e-07u m=1
	mnc01 (net13 net69 net12 vssa) nmos1 l=180n w=1u m=1
	mpb02 (net27 net51 net158 vdda) pmos1 l=180n w=1u m=1
	mppd1 (net158 xpd vdda vdda) pmos1 l=180n w=1u m=1
	mps11 (net31 net158 vdda vdda) pmos1 l=180n w=1u m=1
	mpd11 (net56 inn net31 net31) pmos1 l=180n w=1u m=1
	mp001 (out net158 vdda vdda) pmos1 l=180n w=1u m=1
	mpd12 (net13 inp net31 net31) pmos1 l=180n w=1u m=1
	mpb01 (net158 net158 vdda vdda) pmos1 l=180n w=1u m=1
ends OPAMP1_variant683

subckt OPAMP1_variant684 inn inp out pd xpd vdda vssa
	xd1 (vssa vdda) prim_nwd AREA=6.13907e-9 PJ=476.6e-6 m=1
	xi0 (vssa net69) prim_nd AREA=1e-12 PJ=4e-6 m=1
	xi3 (net51 vdda) prim_pd AREA=2.0e-09 PJ=2.7e-05 m=1
	xr0 (vssa vdda net51) prim_rdiffp l=2.3e-07 w=1.4e-06 m=1
	xr1 (vdda vdda net69) prim_rdiffp l=2.1e-6 w=700e-9 m=1
	xcc01 (net12 out) prim_cpoly c=1p m=1
	mnm12 (net13 net56 vssa vssa) nmos1 l=180n w=1u m=1
	mnm11 (net56 net56 vssa vssa) nmos1 l=180n w=1u m=1
	mnb02 (net27 net27 net21 vssa) nmos1 l=180n w=1u m=1
	mnpd1 (net21 xpd vssa vssa) nmos1 l=180n w=1u m=1
	mn001 (out net13 vssa vssa) nmos1 l=180n w=1u m=1
	mnpd2 (net13 pd vssa vssa) nmos1 l=2.8e-07n w=1.8e-06u m=1
	mnc01 (net13 net69 net12 vssa) nmos1 l=2.5e-07n w=1.8e-06u m=1
	mpb02 (net27 net51 net158 vdda) pmos1 l=180n w=1u m=1
	mppd1 (net158 xpd vdda vdda) pmos1 l=180n w=1u m=1
	mps11 (net31 net158 vdda vdda) pmos1 l=180n w=1u m=1
	mpd11 (net56 inn net31 net31) pmos1 l=180n w=1u m=1
	mp001 (out net158 vdda vdda) pmos1 l=180n w=1u m=1
	mpd12 (net13 inp net31 net31) pmos1 l=180n w=1u m=1
	mpb01 (net158 net158 vdda vdda) pmos1 l=1.5e-07n w=1.8e-06u m=1
ends OPAMP1_variant684

subckt OPAMP1_variant685 inn inp out pd xpd vdda vssa
	xd1 (vssa vdda) prim_nwd AREA=6.13907e-9 PJ=476.6e-6 m=1
	xi0 (vssa net69) prim_nd AREA=1e-12 PJ=4e-6 m=1
	xi3 (net51 vdda) prim_pd AREA=790e-15 PJ=3.3e-6 m=1
	xr0 (vssa vdda net51) prim_rdiffp l=2.1e-6 w=700e-9 m=1
	xr1 (vdda vdda net69) prim_rdiffp l=2.1e-6 w=700e-9 m=1
	xcc01 (net12 out) prim_cpoly c=1p m=1
	mnm12 (net13 net56 vssa vssa) nmos1 l=180n w=1u m=1
	mnm11 (net56 net56 vssa vssa) nmos1 l=180n w=1u m=1
	mnb02 (net27 net27 net21 vssa) nmos1 l=180n w=1u m=1
	mnpd1 (net21 xpd vssa vssa) nmos1 l=180n w=1u m=1
	mn001 (out net13 vssa vssa) nmos1 l=180n w=1u m=1
	mnpd2 (net13 pd vssa vssa) nmos1 l=180n w=1u m=1
	mnc01 (net13 net69 net12 vssa) nmos1 l=180n w=1u m=1
	mpb02 (net27 net51 net158 vdda) pmos1 l=180n w=1u m=1
	mppd1 (net158 xpd vdda vdda) pmos1 l=180n w=1u m=1
	mps11 (net31 net158 vdda vdda) pmos1 l=1.2e-07n w=1.8e-06u m=1
	mpd11 (net56 inn net31 net31) pmos1 l=180n w=1u m=1
	mp001 (out net158 vdda vdda) pmos1 l=180n w=1u m=1
	mpd12 (net13 inp net31 net31) pmos1 l=180n w=1u m=1
	mpb01 (net158 net158 vdda vdda) pmos1 l=2.9e-07n w=1.2e-06u m=1
ends OPAMP1_variant685

subckt OPAMP1_variant686 inn inp out pd xpd vdda vssa
	xd1 (vssa vdda) prim_nwd AREA=6.13907e-9 PJ=476.6e-6 m=1
	xi0 (vssa net69) prim_nd AREA=1e-12 PJ=4e-6 m=1
	xi3 (net51 vdda) prim_pd AREA=9.0e-09 PJ=3.9e-05 m=1
	xr0 (vssa vdda net51) prim_rdiffp l=2.1e-6 w=700e-9 m=1
	xr1 (vdda vdda net69) prim_rdiffp l=2.1e-6 w=700e-9 m=1
	xcc01 (net12 out) prim_cpoly c=1p m=1
	mnm12 (net13 net56 vssa vssa) nmos1 l=1.3e-07n w=1.2e-06u m=1
	mnm11 (net56 net56 vssa vssa) nmos1 l=180n w=1u m=1
	mnb02 (net27 net27 net21 vssa) nmos1 l=1.0e-07n w=6.5e-07u m=1
	mnpd1 (net21 xpd vssa vssa) nmos1 l=180n w=1u m=1
	mn001 (out net13 vssa vssa) nmos1 l=180n w=1u m=1
	mnpd2 (net13 pd vssa vssa) nmos1 l=180n w=1u m=1
	mnc01 (net13 net69 net12 vssa) nmos1 l=180n w=1u m=1
	mpb02 (net27 net51 net158 vdda) pmos1 l=180n w=1u m=1
	mppd1 (net158 xpd vdda vdda) pmos1 l=180n w=1u m=1
	mps11 (net31 net158 vdda vdda) pmos1 l=180n w=1u m=1
	mpd11 (net56 inn net31 net31) pmos1 l=180n w=1u m=1
	mp001 (out net158 vdda vdda) pmos1 l=1.2e-07n w=1.6e-06u m=1
	mpd12 (net13 inp net31 net31) pmos1 l=180n w=1u m=1
	mpb01 (net158 net158 vdda vdda) pmos1 l=180n w=1u m=1
ends OPAMP1_variant686

subckt OPAMP1_variant687 inn inp out pd xpd vdda vssa
	xd1 (vssa vdda) prim_nwd AREA=6.13907e-9 PJ=476.6e-6 m=1
	xi0 (vssa net69) prim_nd AREA=1e-12 PJ=4e-6 m=1
	xi3 (net51 vdda) prim_pd AREA=790e-15 PJ=3.3e-6 m=1
	xr0 (vssa vdda net51) prim_rdiffp l=2.6e-07 w=1.8e-06 m=1
	xr1 (vdda vdda net69) prim_rdiffp l=2.1e-6 w=700e-9 m=1
	xcc01 (net12 out) prim_cpoly c=1p m=1
	mnm12 (net13 net56 vssa vssa) nmos1 l=180n w=1u m=1
	mnm11 (net56 net56 vssa vssa) nmos1 l=180n w=1u m=1
	mnb02 (net27 net27 net21 vssa) nmos1 l=180n w=1u m=1
	mnpd1 (net21 xpd vssa vssa) nmos1 l=180n w=1u m=1
	mn001 (out net13 vssa vssa) nmos1 l=180n w=1u m=1
	mnpd2 (net13 pd vssa vssa) nmos1 l=180n w=1u m=1
	mnc01 (net13 net69 net12 vssa) nmos1 l=180n w=1u m=1
	mpb02 (net27 net51 net158 vdda) pmos1 l=180n w=1u m=1
	mppd1 (net158 xpd vdda vdda) pmos1 l=180n w=1u m=1
	mps11 (net31 net158 vdda vdda) pmos1 l=2.8e-07n w=1.4e-06u m=1
	mpd11 (net56 inn net31 net31) pmos1 l=180n w=1u m=1
	mp001 (out net158 vdda vdda) pmos1 l=1.2e-07n w=1.0e-06u m=1
	mpd12 (net13 inp net31 net31) pmos1 l=180n w=1u m=1
	mpb01 (net158 net158 vdda vdda) pmos1 l=180n w=1u m=1
ends OPAMP1_variant687

subckt OPAMP1_variant688 inn inp out pd xpd vdda vssa
	xd1 (vssa vdda) prim_nwd AREA=6.13907e-9 PJ=476.6e-6 m=1
	xi0 (vssa net69) prim_nd AREA=1e-12 PJ=4e-6 m=1
	xi3 (net51 vdda) prim_pd AREA=790e-15 PJ=3.3e-6 m=1
	xr0 (vssa vdda net51) prim_rdiffp l=2.1e-6 w=700e-9 m=1
	xr1 (vdda vdda net69) prim_rdiffp l=2.1e-6 w=700e-9 m=1
	xcc01 (net12 out) prim_cpoly c=1p m=1
	mnm12 (net13 net56 vssa vssa) nmos1 l=180n w=1u m=1
	mnm11 (net56 net56 vssa vssa) nmos1 l=180n w=1u m=1
	mnb02 (net27 net27 net21 vssa) nmos1 l=1.6e-07n w=1.3e-06u m=1
	mnpd1 (net21 xpd vssa vssa) nmos1 l=180n w=1u m=1
	mn001 (out net13 vssa vssa) nmos1 l=180n w=1u m=1
	mnpd2 (net13 pd vssa vssa) nmos1 l=180n w=1u m=1
	mnc01 (net13 net69 net12 vssa) nmos1 l=180n w=1u m=1
	mpb02 (net27 net51 net158 vdda) pmos1 l=180n w=1u m=1
	mppd1 (net158 xpd vdda vdda) pmos1 l=1.6e-07n w=1.7e-06u m=1
	mps11 (net31 net158 vdda vdda) pmos1 l=180n w=1u m=1
	mpd11 (net56 inn net31 net31) pmos1 l=180n w=1u m=1
	mp001 (out net158 vdda vdda) pmos1 l=180n w=1u m=1
	mpd12 (net13 inp net31 net31) pmos1 l=180n w=1u m=1
	mpb01 (net158 net158 vdda vdda) pmos1 l=180n w=1u m=1
ends OPAMP1_variant688

subckt OPAMP1_variant689 inn inp out pd xpd vdda vssa
	xd1 (vssa vdda) prim_nwd AREA=6.13907e-9 PJ=476.6e-6 m=1
	xi0 (vssa net69) prim_nd AREA=1e-12 PJ=4e-6 m=1
	xi3 (net51 vdda) prim_pd AREA=790e-15 PJ=3.3e-6 m=1
	xr0 (vssa vdda net51) prim_rdiffp l=2.6e-07 w=2.0e-06 m=1
	xr1 (vdda vdda net69) prim_rdiffp l=2.1e-6 w=700e-9 m=1
	xcc01 (net12 out) prim_cpoly c=1p m=1
	mnm12 (net13 net56 vssa vssa) nmos1 l=180n w=1u m=1
	mnm11 (net56 net56 vssa vssa) nmos1 l=1.5e-07n w=1.5e-06u m=1
	mnb02 (net27 net27 net21 vssa) nmos1 l=180n w=1u m=1
	mnpd1 (net21 xpd vssa vssa) nmos1 l=180n w=1u m=1
	mn001 (out net13 vssa vssa) nmos1 l=180n w=1u m=1
	mnpd2 (net13 pd vssa vssa) nmos1 l=180n w=1u m=1
	mnc01 (net13 net69 net12 vssa) nmos1 l=180n w=1u m=1
	mpb02 (net27 net51 net158 vdda) pmos1 l=180n w=1u m=1
	mppd1 (net158 xpd vdda vdda) pmos1 l=180n w=1u m=1
	mps11 (net31 net158 vdda vdda) pmos1 l=180n w=1u m=1
	mpd11 (net56 inn net31 net31) pmos1 l=180n w=1u m=1
	mp001 (out net158 vdda vdda) pmos1 l=180n w=1u m=1
	mpd12 (net13 inp net31 net31) pmos1 l=180n w=1u m=1
	mpb01 (net158 net158 vdda vdda) pmos1 l=180n w=1u m=1
ends OPAMP1_variant689

subckt OPAMP1_variant690 inn inp out pd xpd vdda vssa
	xd1 (vssa vdda) prim_nwd AREA=6.13907e-9 PJ=476.6e-6 m=1
	xi0 (vssa net69) prim_nd AREA=5.9e-09 PJ=2.1e-05 m=1
	xi3 (net51 vdda) prim_pd AREA=4.4e-09 PJ=1.3e-05 m=1
	xr0 (vssa vdda net51) prim_rdiffp l=2.1e-6 w=700e-9 m=1
	xr1 (vdda vdda net69) prim_rdiffp l=2.1e-6 w=700e-9 m=1
	xcc01 (net12 out) prim_cpoly c=1.8e-12p m=1
	mnm12 (net13 net56 vssa vssa) nmos1 l=180n w=1u m=1
	mnm11 (net56 net56 vssa vssa) nmos1 l=180n w=1u m=1
	mnb02 (net27 net27 net21 vssa) nmos1 l=180n w=1u m=1
	mnpd1 (net21 xpd vssa vssa) nmos1 l=180n w=1u m=1
	mn001 (out net13 vssa vssa) nmos1 l=1.4e-07n w=1.5e-06u m=1
	mnpd2 (net13 pd vssa vssa) nmos1 l=180n w=1u m=1
	mnc01 (net13 net69 net12 vssa) nmos1 l=180n w=1u m=1
	mpb02 (net27 net51 net158 vdda) pmos1 l=180n w=1u m=1
	mppd1 (net158 xpd vdda vdda) pmos1 l=180n w=1u m=1
	mps11 (net31 net158 vdda vdda) pmos1 l=180n w=1u m=1
	mpd11 (net56 inn net31 net31) pmos1 l=180n w=1u m=1
	mp001 (out net158 vdda vdda) pmos1 l=180n w=1u m=1
	mpd12 (net13 inp net31 net31) pmos1 l=180n w=1u m=1
	mpb01 (net158 net158 vdda vdda) pmos1 l=180n w=1u m=1
ends OPAMP1_variant690

subckt OPAMP1_variant691 inn inp out pd xpd vdda vssa
	xd1 (vssa vdda) prim_nwd AREA=2.0e-09 PJ=4.6e-05 m=1
	xi0 (vssa net69) prim_nd AREA=1e-12 PJ=4e-6 m=1
	xi3 (net51 vdda) prim_pd AREA=790e-15 PJ=3.3e-6 m=1
	xr0 (vssa vdda net51) prim_rdiffp l=2.1e-6 w=700e-9 m=1
	xr1 (vdda vdda net69) prim_rdiffp l=2.1e-6 w=700e-9 m=1
	xcc01 (net12 out) prim_cpoly c=1p m=1
	mnm12 (net13 net56 vssa vssa) nmos1 l=1.2e-07n w=1.1e-06u m=1
	mnm11 (net56 net56 vssa vssa) nmos1 l=180n w=1u m=1
	mnb02 (net27 net27 net21 vssa) nmos1 l=180n w=1u m=1
	mnpd1 (net21 xpd vssa vssa) nmos1 l=180n w=1u m=1
	mn001 (out net13 vssa vssa) nmos1 l=180n w=1u m=1
	mnpd2 (net13 pd vssa vssa) nmos1 l=180n w=1u m=1
	mnc01 (net13 net69 net12 vssa) nmos1 l=180n w=1u m=1
	mpb02 (net27 net51 net158 vdda) pmos1 l=180n w=1u m=1
	mppd1 (net158 xpd vdda vdda) pmos1 l=180n w=1u m=1
	mps11 (net31 net158 vdda vdda) pmos1 l=180n w=1u m=1
	mpd11 (net56 inn net31 net31) pmos1 l=180n w=1u m=1
	mp001 (out net158 vdda vdda) pmos1 l=180n w=1u m=1
	mpd12 (net13 inp net31 net31) pmos1 l=180n w=1u m=1
	mpb01 (net158 net158 vdda vdda) pmos1 l=180n w=1u m=1
ends OPAMP1_variant691

subckt OPAMP1_variant692 inn inp out pd xpd vdda vssa
	xd1 (vssa vdda) prim_nwd AREA=6.13907e-9 PJ=476.6e-6 m=1
	xi0 (vssa net69) prim_nd AREA=2.1e-09 PJ=8.8e-06 m=1
	xi3 (net51 vdda) prim_pd AREA=790e-15 PJ=3.3e-6 m=1
	xr0 (vssa vdda net51) prim_rdiffp l=2.1e-6 w=700e-9 m=1
	xr1 (vdda vdda net69) prim_rdiffp l=2.1e-6 w=700e-9 m=1
	xcc01 (net12 out) prim_cpoly c=1p m=1
	mnm12 (net13 net56 vssa vssa) nmos1 l=180n w=1u m=1
	mnm11 (net56 net56 vssa vssa) nmos1 l=2.7e-07n w=1.0e-06u m=1
	mnb02 (net27 net27 net21 vssa) nmos1 l=1.1e-07n w=1.1e-06u m=1
	mnpd1 (net21 xpd vssa vssa) nmos1 l=180n w=1u m=1
	mn001 (out net13 vssa vssa) nmos1 l=180n w=1u m=1
	mnpd2 (net13 pd vssa vssa) nmos1 l=180n w=1u m=1
	mnc01 (net13 net69 net12 vssa) nmos1 l=180n w=1u m=1
	mpb02 (net27 net51 net158 vdda) pmos1 l=180n w=1u m=1
	mppd1 (net158 xpd vdda vdda) pmos1 l=180n w=1u m=1
	mps11 (net31 net158 vdda vdda) pmos1 l=180n w=1u m=1
	mpd11 (net56 inn net31 net31) pmos1 l=180n w=1u m=1
	mp001 (out net158 vdda vdda) pmos1 l=180n w=1u m=1
	mpd12 (net13 inp net31 net31) pmos1 l=180n w=1u m=1
	mpb01 (net158 net158 vdda vdda) pmos1 l=180n w=1u m=1
ends OPAMP1_variant692

subckt OPAMP1_variant693 inn inp out pd xpd vdda vssa
	xd1 (vssa vdda) prim_nwd AREA=6.13907e-9 PJ=476.6e-6 m=1
	xi0 (vssa net69) prim_nd AREA=1e-12 PJ=4e-6 m=1
	xi3 (net51 vdda) prim_pd AREA=790e-15 PJ=3.3e-6 m=1
	xr0 (vssa vdda net51) prim_rdiffp l=2.1e-6 w=700e-9 m=1
	xr1 (vdda vdda net69) prim_rdiffp l=2.1e-6 w=700e-9 m=1
	xcc01 (net12 out) prim_cpoly c=1p m=1
	mnm12 (net13 net56 vssa vssa) nmos1 l=180n w=1u m=1
	mnm11 (net56 net56 vssa vssa) nmos1 l=180n w=1u m=1
	mnb02 (net27 net27 net21 vssa) nmos1 l=180n w=1u m=1
	mnpd1 (net21 xpd vssa vssa) nmos1 l=180n w=1u m=1
	mn001 (out net13 vssa vssa) nmos1 l=180n w=1u m=1
	mnpd2 (net13 pd vssa vssa) nmos1 l=180n w=1u m=1
	mnc01 (net13 net69 net12 vssa) nmos1 l=2.0e-07n w=9.6e-07u m=1
	mpb02 (net27 net51 net158 vdda) pmos1 l=180n w=1u m=1
	mppd1 (net158 xpd vdda vdda) pmos1 l=180n w=1u m=1
	mps11 (net31 net158 vdda vdda) pmos1 l=180n w=1u m=1
	mpd11 (net56 inn net31 net31) pmos1 l=180n w=1u m=1
	mp001 (out net158 vdda vdda) pmos1 l=2.5e-07n w=1.9e-06u m=1
	mpd12 (net13 inp net31 net31) pmos1 l=180n w=1u m=1
	mpb01 (net158 net158 vdda vdda) pmos1 l=180n w=1u m=1
ends OPAMP1_variant693

subckt OPAMP1_variant694 inn inp out pd xpd vdda vssa
	xd1 (vssa vdda) prim_nwd AREA=6.13907e-9 PJ=476.6e-6 m=1
	xi0 (vssa net69) prim_nd AREA=7.4e-09 PJ=6.2e-05 m=1
	xi3 (net51 vdda) prim_pd AREA=790e-15 PJ=3.3e-6 m=1
	xr0 (vssa vdda net51) prim_rdiffp l=2.1e-6 w=700e-9 m=1
	xr1 (vdda vdda net69) prim_rdiffp l=2.1e-6 w=700e-9 m=1
	xcc01 (net12 out) prim_cpoly c=1p m=1
	mnm12 (net13 net56 vssa vssa) nmos1 l=1.1e-07n w=7.0e-07u m=1
	mnm11 (net56 net56 vssa vssa) nmos1 l=180n w=1u m=1
	mnb02 (net27 net27 net21 vssa) nmos1 l=180n w=1u m=1
	mnpd1 (net21 xpd vssa vssa) nmos1 l=180n w=1u m=1
	mn001 (out net13 vssa vssa) nmos1 l=180n w=1u m=1
	mnpd2 (net13 pd vssa vssa) nmos1 l=180n w=1u m=1
	mnc01 (net13 net69 net12 vssa) nmos1 l=180n w=1u m=1
	mpb02 (net27 net51 net158 vdda) pmos1 l=180n w=1u m=1
	mppd1 (net158 xpd vdda vdda) pmos1 l=180n w=1u m=1
	mps11 (net31 net158 vdda vdda) pmos1 l=180n w=1u m=1
	mpd11 (net56 inn net31 net31) pmos1 l=180n w=1u m=1
	mp001 (out net158 vdda vdda) pmos1 l=180n w=1u m=1
	mpd12 (net13 inp net31 net31) pmos1 l=180n w=1u m=1
	mpb01 (net158 net158 vdda vdda) pmos1 l=180n w=1u m=1
ends OPAMP1_variant694

subckt OPAMP1_variant695 inn inp out pd xpd vdda vssa
	xd1 (vssa vdda) prim_nwd AREA=6.13907e-9 PJ=476.6e-6 m=1
	xi0 (vssa net69) prim_nd AREA=9.4e-09 PJ=4.7e-05 m=1
	xi3 (net51 vdda) prim_pd AREA=1.5e-09 PJ=1.9e-05 m=1
	xr0 (vssa vdda net51) prim_rdiffp l=2.1e-6 w=700e-9 m=1
	xr1 (vdda vdda net69) prim_rdiffp l=1.5e-07 w=1.2e-06 m=1
	xcc01 (net12 out) prim_cpoly c=1p m=1
	mnm12 (net13 net56 vssa vssa) nmos1 l=2.8e-07n w=7.5e-07u m=1
	mnm11 (net56 net56 vssa vssa) nmos1 l=180n w=1u m=1
	mnb02 (net27 net27 net21 vssa) nmos1 l=180n w=1u m=1
	mnpd1 (net21 xpd vssa vssa) nmos1 l=2.5e-07n w=2.0e-06u m=1
	mn001 (out net13 vssa vssa) nmos1 l=180n w=1u m=1
	mnpd2 (net13 pd vssa vssa) nmos1 l=180n w=1u m=1
	mnc01 (net13 net69 net12 vssa) nmos1 l=180n w=1u m=1
	mpb02 (net27 net51 net158 vdda) pmos1 l=180n w=1u m=1
	mppd1 (net158 xpd vdda vdda) pmos1 l=180n w=1u m=1
	mps11 (net31 net158 vdda vdda) pmos1 l=180n w=1u m=1
	mpd11 (net56 inn net31 net31) pmos1 l=180n w=1u m=1
	mp001 (out net158 vdda vdda) pmos1 l=180n w=1u m=1
	mpd12 (net13 inp net31 net31) pmos1 l=180n w=1u m=1
	mpb01 (net158 net158 vdda vdda) pmos1 l=180n w=1u m=1
ends OPAMP1_variant695

subckt OPAMP1_variant696 inn inp out pd xpd vdda vssa
	xd1 (vssa vdda) prim_nwd AREA=6.13907e-9 PJ=476.6e-6 m=1
	xi0 (vssa net69) prim_nd AREA=1e-12 PJ=4e-6 m=1
	xi3 (net51 vdda) prim_pd AREA=790e-15 PJ=3.3e-6 m=1
	xr0 (vssa vdda net51) prim_rdiffp l=2.1e-6 w=700e-9 m=1
	xr1 (vdda vdda net69) prim_rdiffp l=2.1e-6 w=700e-9 m=1
	xcc01 (net12 out) prim_cpoly c=1p m=1
	mnm12 (net13 net56 vssa vssa) nmos1 l=2.8e-07n w=8.1e-07u m=1
	mnm11 (net56 net56 vssa vssa) nmos1 l=180n w=1u m=1
	mnb02 (net27 net27 net21 vssa) nmos1 l=180n w=1u m=1
	mnpd1 (net21 xpd vssa vssa) nmos1 l=180n w=1u m=1
	mn001 (out net13 vssa vssa) nmos1 l=2.7e-07n w=6.4e-07u m=1
	mnpd2 (net13 pd vssa vssa) nmos1 l=180n w=1u m=1
	mnc01 (net13 net69 net12 vssa) nmos1 l=1.8e-07n w=1.3e-06u m=1
	mpb02 (net27 net51 net158 vdda) pmos1 l=180n w=1u m=1
	mppd1 (net158 xpd vdda vdda) pmos1 l=180n w=1u m=1
	mps11 (net31 net158 vdda vdda) pmos1 l=180n w=1u m=1
	mpd11 (net56 inn net31 net31) pmos1 l=180n w=1u m=1
	mp001 (out net158 vdda vdda) pmos1 l=180n w=1u m=1
	mpd12 (net13 inp net31 net31) pmos1 l=180n w=1u m=1
	mpb01 (net158 net158 vdda vdda) pmos1 l=180n w=1u m=1
ends OPAMP1_variant696

subckt OPAMP1_variant697 inn inp out pd xpd vdda vssa
	xd1 (vssa vdda) prim_nwd AREA=6.7e-09 PJ=1.6e-05 m=1
	xi0 (vssa net69) prim_nd AREA=1e-12 PJ=4e-6 m=1
	xi3 (net51 vdda) prim_pd AREA=790e-15 PJ=3.3e-6 m=1
	xr0 (vssa vdda net51) prim_rdiffp l=2.1e-6 w=700e-9 m=1
	xr1 (vdda vdda net69) prim_rdiffp l=2.1e-6 w=700e-9 m=1
	xcc01 (net12 out) prim_cpoly c=1p m=1
	mnm12 (net13 net56 vssa vssa) nmos1 l=180n w=1u m=1
	mnm11 (net56 net56 vssa vssa) nmos1 l=180n w=1u m=1
	mnb02 (net27 net27 net21 vssa) nmos1 l=180n w=1u m=1
	mnpd1 (net21 xpd vssa vssa) nmos1 l=180n w=1u m=1
	mn001 (out net13 vssa vssa) nmos1 l=1.4e-07n w=1.3e-06u m=1
	mnpd2 (net13 pd vssa vssa) nmos1 l=1.5e-07n w=1.7e-06u m=1
	mnc01 (net13 net69 net12 vssa) nmos1 l=180n w=1u m=1
	mpb02 (net27 net51 net158 vdda) pmos1 l=180n w=1u m=1
	mppd1 (net158 xpd vdda vdda) pmos1 l=180n w=1u m=1
	mps11 (net31 net158 vdda vdda) pmos1 l=180n w=1u m=1
	mpd11 (net56 inn net31 net31) pmos1 l=180n w=1u m=1
	mp001 (out net158 vdda vdda) pmos1 l=180n w=1u m=1
	mpd12 (net13 inp net31 net31) pmos1 l=1.4e-07n w=1.2e-06u m=1
	mpb01 (net158 net158 vdda vdda) pmos1 l=180n w=1u m=1
ends OPAMP1_variant697

subckt OPAMP1_variant698 inn inp out pd xpd vdda vssa
	xd1 (vssa vdda) prim_nwd AREA=9.0e-09 PJ=5.8e-05 m=1
	xi0 (vssa net69) prim_nd AREA=1e-12 PJ=4e-6 m=1
	xi3 (net51 vdda) prim_pd AREA=790e-15 PJ=3.3e-6 m=1
	xr0 (vssa vdda net51) prim_rdiffp l=2.1e-6 w=700e-9 m=1
	xr1 (vdda vdda net69) prim_rdiffp l=2.1e-6 w=700e-9 m=1
	xcc01 (net12 out) prim_cpoly c=1p m=1
	mnm12 (net13 net56 vssa vssa) nmos1 l=180n w=1u m=1
	mnm11 (net56 net56 vssa vssa) nmos1 l=180n w=1u m=1
	mnb02 (net27 net27 net21 vssa) nmos1 l=2.6e-07n w=8.7e-07u m=1
	mnpd1 (net21 xpd vssa vssa) nmos1 l=180n w=1u m=1
	mn001 (out net13 vssa vssa) nmos1 l=180n w=1u m=1
	mnpd2 (net13 pd vssa vssa) nmos1 l=180n w=1u m=1
	mnc01 (net13 net69 net12 vssa) nmos1 l=180n w=1u m=1
	mpb02 (net27 net51 net158 vdda) pmos1 l=180n w=1u m=1
	mppd1 (net158 xpd vdda vdda) pmos1 l=180n w=1u m=1
	mps11 (net31 net158 vdda vdda) pmos1 l=180n w=1u m=1
	mpd11 (net56 inn net31 net31) pmos1 l=180n w=1u m=1
	mp001 (out net158 vdda vdda) pmos1 l=180n w=1u m=1
	mpd12 (net13 inp net31 net31) pmos1 l=180n w=1u m=1
	mpb01 (net158 net158 vdda vdda) pmos1 l=2.6e-07n w=1.6e-06u m=1
ends OPAMP1_variant698

subckt OPAMP1_variant699 inn inp out pd xpd vdda vssa
	xd1 (vssa vdda) prim_nwd AREA=6.13907e-9 PJ=476.6e-6 m=1
	xi0 (vssa net69) prim_nd AREA=1e-12 PJ=4e-6 m=1
	xi3 (net51 vdda) prim_pd AREA=790e-15 PJ=3.3e-6 m=1
	xr0 (vssa vdda net51) prim_rdiffp l=2.1e-6 w=700e-9 m=1
	xr1 (vdda vdda net69) prim_rdiffp l=2.1e-6 w=700e-9 m=1
	xcc01 (net12 out) prim_cpoly c=1p m=1
	mnm12 (net13 net56 vssa vssa) nmos1 l=1.4e-07n w=1.2e-06u m=1
	mnm11 (net56 net56 vssa vssa) nmos1 l=180n w=1u m=1
	mnb02 (net27 net27 net21 vssa) nmos1 l=180n w=1u m=1
	mnpd1 (net21 xpd vssa vssa) nmos1 l=180n w=1u m=1
	mn001 (out net13 vssa vssa) nmos1 l=2.6e-07n w=1.4e-06u m=1
	mnpd2 (net13 pd vssa vssa) nmos1 l=1.7e-07n w=9.5e-07u m=1
	mnc01 (net13 net69 net12 vssa) nmos1 l=180n w=1u m=1
	mpb02 (net27 net51 net158 vdda) pmos1 l=180n w=1u m=1
	mppd1 (net158 xpd vdda vdda) pmos1 l=180n w=1u m=1
	mps11 (net31 net158 vdda vdda) pmos1 l=180n w=1u m=1
	mpd11 (net56 inn net31 net31) pmos1 l=180n w=1u m=1
	mp001 (out net158 vdda vdda) pmos1 l=2.7e-07n w=5.3e-07u m=1
	mpd12 (net13 inp net31 net31) pmos1 l=180n w=1u m=1
	mpb01 (net158 net158 vdda vdda) pmos1 l=180n w=1u m=1
ends OPAMP1_variant699

subckt OPAMP1_variant700 inn inp out pd xpd vdda vssa
	xd1 (vssa vdda) prim_nwd AREA=6.13907e-9 PJ=476.6e-6 m=1
	xi0 (vssa net69) prim_nd AREA=1e-12 PJ=4e-6 m=1
	xi3 (net51 vdda) prim_pd AREA=790e-15 PJ=3.3e-6 m=1
	xr0 (vssa vdda net51) prim_rdiffp l=2.1e-6 w=700e-9 m=1
	xr1 (vdda vdda net69) prim_rdiffp l=2.1e-6 w=700e-9 m=1
	xcc01 (net12 out) prim_cpoly c=1p m=1
	mnm12 (net13 net56 vssa vssa) nmos1 l=180n w=1u m=1
	mnm11 (net56 net56 vssa vssa) nmos1 l=2.7e-07n w=5.1e-07u m=1
	mnb02 (net27 net27 net21 vssa) nmos1 l=180n w=1u m=1
	mnpd1 (net21 xpd vssa vssa) nmos1 l=180n w=1u m=1
	mn001 (out net13 vssa vssa) nmos1 l=1.9e-07n w=1.6e-06u m=1
	mnpd2 (net13 pd vssa vssa) nmos1 l=1.4e-07n w=1.7e-06u m=1
	mnc01 (net13 net69 net12 vssa) nmos1 l=180n w=1u m=1
	mpb02 (net27 net51 net158 vdda) pmos1 l=180n w=1u m=1
	mppd1 (net158 xpd vdda vdda) pmos1 l=180n w=1u m=1
	mps11 (net31 net158 vdda vdda) pmos1 l=180n w=1u m=1
	mpd11 (net56 inn net31 net31) pmos1 l=180n w=1u m=1
	mp001 (out net158 vdda vdda) pmos1 l=1.4e-07n w=1.4e-06u m=1
	mpd12 (net13 inp net31 net31) pmos1 l=180n w=1u m=1
	mpb01 (net158 net158 vdda vdda) pmos1 l=180n w=1u m=1
ends OPAMP1_variant700

subckt OPAMP1_variant701 inn inp out pd xpd vdda vssa
	xd1 (vssa vdda) prim_nwd AREA=6.13907e-9 PJ=476.6e-6 m=1
	xi0 (vssa net69) prim_nd AREA=1e-12 PJ=4e-6 m=1
	xi3 (net51 vdda) prim_pd AREA=790e-15 PJ=3.3e-6 m=1
	xr0 (vssa vdda net51) prim_rdiffp l=2.0e-07 w=2.0e-06 m=1
	xr1 (vdda vdda net69) prim_rdiffp l=2.1e-6 w=700e-9 m=1
	xcc01 (net12 out) prim_cpoly c=1p m=1
	mnm12 (net13 net56 vssa vssa) nmos1 l=1.7e-07n w=6.7e-07u m=1
	mnm11 (net56 net56 vssa vssa) nmos1 l=1.3e-07n w=1.9e-06u m=1
	mnb02 (net27 net27 net21 vssa) nmos1 l=180n w=1u m=1
	mnpd1 (net21 xpd vssa vssa) nmos1 l=180n w=1u m=1
	mn001 (out net13 vssa vssa) nmos1 l=180n w=1u m=1
	mnpd2 (net13 pd vssa vssa) nmos1 l=180n w=1u m=1
	mnc01 (net13 net69 net12 vssa) nmos1 l=180n w=1u m=1
	mpb02 (net27 net51 net158 vdda) pmos1 l=180n w=1u m=1
	mppd1 (net158 xpd vdda vdda) pmos1 l=180n w=1u m=1
	mps11 (net31 net158 vdda vdda) pmos1 l=180n w=1u m=1
	mpd11 (net56 inn net31 net31) pmos1 l=180n w=1u m=1
	mp001 (out net158 vdda vdda) pmos1 l=1.5e-07n w=1.2e-06u m=1
	mpd12 (net13 inp net31 net31) pmos1 l=180n w=1u m=1
	mpb01 (net158 net158 vdda vdda) pmos1 l=180n w=1u m=1
ends OPAMP1_variant701

subckt OPAMP1_variant702 inn inp out pd xpd vdda vssa
	xd1 (vssa vdda) prim_nwd AREA=6.13907e-9 PJ=476.6e-6 m=1
	xi0 (vssa net69) prim_nd AREA=1e-12 PJ=4e-6 m=1
	xi3 (net51 vdda) prim_pd AREA=790e-15 PJ=3.3e-6 m=1
	xr0 (vssa vdda net51) prim_rdiffp l=2.1e-6 w=700e-9 m=1
	xr1 (vdda vdda net69) prim_rdiffp l=2.1e-6 w=700e-9 m=1
	xcc01 (net12 out) prim_cpoly c=1.1e-12p m=1
	mnm12 (net13 net56 vssa vssa) nmos1 l=180n w=1u m=1
	mnm11 (net56 net56 vssa vssa) nmos1 l=180n w=1u m=1
	mnb02 (net27 net27 net21 vssa) nmos1 l=2.3e-07n w=1.2e-06u m=1
	mnpd1 (net21 xpd vssa vssa) nmos1 l=180n w=1u m=1
	mn001 (out net13 vssa vssa) nmos1 l=1.7e-07n w=9.7e-07u m=1
	mnpd2 (net13 pd vssa vssa) nmos1 l=180n w=1u m=1
	mnc01 (net13 net69 net12 vssa) nmos1 l=180n w=1u m=1
	mpb02 (net27 net51 net158 vdda) pmos1 l=2.2e-07n w=1.5e-06u m=1
	mppd1 (net158 xpd vdda vdda) pmos1 l=180n w=1u m=1
	mps11 (net31 net158 vdda vdda) pmos1 l=180n w=1u m=1
	mpd11 (net56 inn net31 net31) pmos1 l=180n w=1u m=1
	mp001 (out net158 vdda vdda) pmos1 l=180n w=1u m=1
	mpd12 (net13 inp net31 net31) pmos1 l=1.0e-07n w=7.4e-07u m=1
	mpb01 (net158 net158 vdda vdda) pmos1 l=180n w=1u m=1
ends OPAMP1_variant702

subckt OPAMP1_variant703 inn inp out pd xpd vdda vssa
	xd1 (vssa vdda) prim_nwd AREA=6.13907e-9 PJ=476.6e-6 m=1
	xi0 (vssa net69) prim_nd AREA=1e-12 PJ=4e-6 m=1
	xi3 (net51 vdda) prim_pd AREA=790e-15 PJ=3.3e-6 m=1
	xr0 (vssa vdda net51) prim_rdiffp l=2.1e-6 w=700e-9 m=1
	xr1 (vdda vdda net69) prim_rdiffp l=2.1e-6 w=700e-9 m=1
	xcc01 (net12 out) prim_cpoly c=1p m=1
	mnm12 (net13 net56 vssa vssa) nmos1 l=2.2e-07n w=1.9e-06u m=1
	mnm11 (net56 net56 vssa vssa) nmos1 l=180n w=1u m=1
	mnb02 (net27 net27 net21 vssa) nmos1 l=180n w=1u m=1
	mnpd1 (net21 xpd vssa vssa) nmos1 l=1.4e-07n w=8.2e-07u m=1
	mn001 (out net13 vssa vssa) nmos1 l=180n w=1u m=1
	mnpd2 (net13 pd vssa vssa) nmos1 l=180n w=1u m=1
	mnc01 (net13 net69 net12 vssa) nmos1 l=180n w=1u m=1
	mpb02 (net27 net51 net158 vdda) pmos1 l=180n w=1u m=1
	mppd1 (net158 xpd vdda vdda) pmos1 l=180n w=1u m=1
	mps11 (net31 net158 vdda vdda) pmos1 l=180n w=1u m=1
	mpd11 (net56 inn net31 net31) pmos1 l=2.3e-07n w=1.1e-06u m=1
	mp001 (out net158 vdda vdda) pmos1 l=180n w=1u m=1
	mpd12 (net13 inp net31 net31) pmos1 l=1.8e-07n w=8.2e-07u m=1
	mpb01 (net158 net158 vdda vdda) pmos1 l=2.2e-07n w=5.2e-07u m=1
ends OPAMP1_variant703

subckt OPAMP1_variant704 inn inp out pd xpd vdda vssa
	xd1 (vssa vdda) prim_nwd AREA=6.13907e-9 PJ=476.6e-6 m=1
	xi0 (vssa net69) prim_nd AREA=1e-12 PJ=4e-6 m=1
	xi3 (net51 vdda) prim_pd AREA=1.5e-09 PJ=4.4e-05 m=1
	xr0 (vssa vdda net51) prim_rdiffp l=2.8e-07 w=1.1e-06 m=1
	xr1 (vdda vdda net69) prim_rdiffp l=2.1e-6 w=700e-9 m=1
	xcc01 (net12 out) prim_cpoly c=1p m=1
	mnm12 (net13 net56 vssa vssa) nmos1 l=180n w=1u m=1
	mnm11 (net56 net56 vssa vssa) nmos1 l=180n w=1u m=1
	mnb02 (net27 net27 net21 vssa) nmos1 l=180n w=1u m=1
	mnpd1 (net21 xpd vssa vssa) nmos1 l=180n w=1u m=1
	mn001 (out net13 vssa vssa) nmos1 l=180n w=1u m=1
	mnpd2 (net13 pd vssa vssa) nmos1 l=1.5e-07n w=1.1e-06u m=1
	mnc01 (net13 net69 net12 vssa) nmos1 l=180n w=1u m=1
	mpb02 (net27 net51 net158 vdda) pmos1 l=180n w=1u m=1
	mppd1 (net158 xpd vdda vdda) pmos1 l=180n w=1u m=1
	mps11 (net31 net158 vdda vdda) pmos1 l=2.9e-07n w=1.7e-06u m=1
	mpd11 (net56 inn net31 net31) pmos1 l=180n w=1u m=1
	mp001 (out net158 vdda vdda) pmos1 l=180n w=1u m=1
	mpd12 (net13 inp net31 net31) pmos1 l=180n w=1u m=1
	mpb01 (net158 net158 vdda vdda) pmos1 l=180n w=1u m=1
ends OPAMP1_variant704

subckt OPAMP1_variant705 inn inp out pd xpd vdda vssa
	xd1 (vssa vdda) prim_nwd AREA=6.13907e-9 PJ=476.6e-6 m=1
	xi0 (vssa net69) prim_nd AREA=1e-12 PJ=4e-6 m=1
	xi3 (net51 vdda) prim_pd AREA=790e-15 PJ=3.3e-6 m=1
	xr0 (vssa vdda net51) prim_rdiffp l=2.1e-6 w=700e-9 m=1
	xr1 (vdda vdda net69) prim_rdiffp l=2.1e-6 w=700e-9 m=1
	xcc01 (net12 out) prim_cpoly c=1p m=1
	mnm12 (net13 net56 vssa vssa) nmos1 l=180n w=1u m=1
	mnm11 (net56 net56 vssa vssa) nmos1 l=180n w=1u m=1
	mnb02 (net27 net27 net21 vssa) nmos1 l=1.3e-07n w=1.0e-06u m=1
	mnpd1 (net21 xpd vssa vssa) nmos1 l=180n w=1u m=1
	mn001 (out net13 vssa vssa) nmos1 l=2.3e-07n w=9.6e-07u m=1
	mnpd2 (net13 pd vssa vssa) nmos1 l=1.5e-07n w=1.7e-06u m=1
	mnc01 (net13 net69 net12 vssa) nmos1 l=180n w=1u m=1
	mpb02 (net27 net51 net158 vdda) pmos1 l=1.4e-07n w=8.1e-07u m=1
	mppd1 (net158 xpd vdda vdda) pmos1 l=180n w=1u m=1
	mps11 (net31 net158 vdda vdda) pmos1 l=1.0e-07n w=1.8e-06u m=1
	mpd11 (net56 inn net31 net31) pmos1 l=180n w=1u m=1
	mp001 (out net158 vdda vdda) pmos1 l=180n w=1u m=1
	mpd12 (net13 inp net31 net31) pmos1 l=180n w=1u m=1
	mpb01 (net158 net158 vdda vdda) pmos1 l=180n w=1u m=1
ends OPAMP1_variant705

subckt OPAMP1_variant706 inn inp out pd xpd vdda vssa
	xd1 (vssa vdda) prim_nwd AREA=2.9e-09 PJ=7.9e-05 m=1
	xi0 (vssa net69) prim_nd AREA=1e-12 PJ=4e-6 m=1
	xi3 (net51 vdda) prim_pd AREA=790e-15 PJ=3.3e-6 m=1
	xr0 (vssa vdda net51) prim_rdiffp l=2.1e-6 w=700e-9 m=1
	xr1 (vdda vdda net69) prim_rdiffp l=2.1e-6 w=700e-9 m=1
	xcc01 (net12 out) prim_cpoly c=1p m=1
	mnm12 (net13 net56 vssa vssa) nmos1 l=180n w=1u m=1
	mnm11 (net56 net56 vssa vssa) nmos1 l=1.3e-07n w=1.7e-06u m=1
	mnb02 (net27 net27 net21 vssa) nmos1 l=180n w=1u m=1
	mnpd1 (net21 xpd vssa vssa) nmos1 l=180n w=1u m=1
	mn001 (out net13 vssa vssa) nmos1 l=180n w=1u m=1
	mnpd2 (net13 pd vssa vssa) nmos1 l=180n w=1u m=1
	mnc01 (net13 net69 net12 vssa) nmos1 l=180n w=1u m=1
	mpb02 (net27 net51 net158 vdda) pmos1 l=180n w=1u m=1
	mppd1 (net158 xpd vdda vdda) pmos1 l=180n w=1u m=1
	mps11 (net31 net158 vdda vdda) pmos1 l=1.7e-07n w=9.1e-07u m=1
	mpd11 (net56 inn net31 net31) pmos1 l=180n w=1u m=1
	mp001 (out net158 vdda vdda) pmos1 l=180n w=1u m=1
	mpd12 (net13 inp net31 net31) pmos1 l=1.2e-07n w=1.5e-06u m=1
	mpb01 (net158 net158 vdda vdda) pmos1 l=180n w=1u m=1
ends OPAMP1_variant706

subckt OPAMP1_variant707 inn inp out pd xpd vdda vssa
	xd1 (vssa vdda) prim_nwd AREA=9.5e-09 PJ=3.4e-05 m=1
	xi0 (vssa net69) prim_nd AREA=1e-12 PJ=4e-6 m=1
	xi3 (net51 vdda) prim_pd AREA=4.4e-10 PJ=9.6e-05 m=1
	xr0 (vssa vdda net51) prim_rdiffp l=2.1e-6 w=700e-9 m=1
	xr1 (vdda vdda net69) prim_rdiffp l=2.1e-6 w=700e-9 m=1
	xcc01 (net12 out) prim_cpoly c=1p m=1
	mnm12 (net13 net56 vssa vssa) nmos1 l=180n w=1u m=1
	mnm11 (net56 net56 vssa vssa) nmos1 l=180n w=1u m=1
	mnb02 (net27 net27 net21 vssa) nmos1 l=180n w=1u m=1
	mnpd1 (net21 xpd vssa vssa) nmos1 l=180n w=1u m=1
	mn001 (out net13 vssa vssa) nmos1 l=180n w=1u m=1
	mnpd2 (net13 pd vssa vssa) nmos1 l=1.1e-07n w=1.2e-06u m=1
	mnc01 (net13 net69 net12 vssa) nmos1 l=180n w=1u m=1
	mpb02 (net27 net51 net158 vdda) pmos1 l=180n w=1u m=1
	mppd1 (net158 xpd vdda vdda) pmos1 l=180n w=1u m=1
	mps11 (net31 net158 vdda vdda) pmos1 l=180n w=1u m=1
	mpd11 (net56 inn net31 net31) pmos1 l=180n w=1u m=1
	mp001 (out net158 vdda vdda) pmos1 l=180n w=1u m=1
	mpd12 (net13 inp net31 net31) pmos1 l=2.7e-07n w=1.6e-06u m=1
	mpb01 (net158 net158 vdda vdda) pmos1 l=180n w=1u m=1
ends OPAMP1_variant707

subckt OPAMP1_variant708 inn inp out pd xpd vdda vssa
	xd1 (vssa vdda) prim_nwd AREA=6.13907e-9 PJ=476.6e-6 m=1
	xi0 (vssa net69) prim_nd AREA=1e-12 PJ=4e-6 m=1
	xi3 (net51 vdda) prim_pd AREA=790e-15 PJ=3.3e-6 m=1
	xr0 (vssa vdda net51) prim_rdiffp l=2.3e-07 w=1.4e-06 m=1
	xr1 (vdda vdda net69) prim_rdiffp l=2.1e-6 w=700e-9 m=1
	xcc01 (net12 out) prim_cpoly c=1p m=1
	mnm12 (net13 net56 vssa vssa) nmos1 l=180n w=1u m=1
	mnm11 (net56 net56 vssa vssa) nmos1 l=180n w=1u m=1
	mnb02 (net27 net27 net21 vssa) nmos1 l=180n w=1u m=1
	mnpd1 (net21 xpd vssa vssa) nmos1 l=180n w=1u m=1
	mn001 (out net13 vssa vssa) nmos1 l=180n w=1u m=1
	mnpd2 (net13 pd vssa vssa) nmos1 l=180n w=1u m=1
	mnc01 (net13 net69 net12 vssa) nmos1 l=2.4e-07n w=1.5e-06u m=1
	mpb02 (net27 net51 net158 vdda) pmos1 l=180n w=1u m=1
	mppd1 (net158 xpd vdda vdda) pmos1 l=180n w=1u m=1
	mps11 (net31 net158 vdda vdda) pmos1 l=180n w=1u m=1
	mpd11 (net56 inn net31 net31) pmos1 l=180n w=1u m=1
	mp001 (out net158 vdda vdda) pmos1 l=180n w=1u m=1
	mpd12 (net13 inp net31 net31) pmos1 l=180n w=1u m=1
	mpb01 (net158 net158 vdda vdda) pmos1 l=180n w=1u m=1
ends OPAMP1_variant708

subckt OPAMP1_variant709 inn inp out pd xpd vdda vssa
	xd1 (vssa vdda) prim_nwd AREA=6.13907e-9 PJ=476.6e-6 m=1
	xi0 (vssa net69) prim_nd AREA=1e-12 PJ=4e-6 m=1
	xi3 (net51 vdda) prim_pd AREA=8.3e-09 PJ=9.0e-05 m=1
	xr0 (vssa vdda net51) prim_rdiffp l=2.1e-6 w=700e-9 m=1
	xr1 (vdda vdda net69) prim_rdiffp l=2.1e-6 w=700e-9 m=1
	xcc01 (net12 out) prim_cpoly c=1.2e-12p m=1
	mnm12 (net13 net56 vssa vssa) nmos1 l=180n w=1u m=1
	mnm11 (net56 net56 vssa vssa) nmos1 l=180n w=1u m=1
	mnb02 (net27 net27 net21 vssa) nmos1 l=180n w=1u m=1
	mnpd1 (net21 xpd vssa vssa) nmos1 l=180n w=1u m=1
	mn001 (out net13 vssa vssa) nmos1 l=180n w=1u m=1
	mnpd2 (net13 pd vssa vssa) nmos1 l=180n w=1u m=1
	mnc01 (net13 net69 net12 vssa) nmos1 l=180n w=1u m=1
	mpb02 (net27 net51 net158 vdda) pmos1 l=180n w=1u m=1
	mppd1 (net158 xpd vdda vdda) pmos1 l=180n w=1u m=1
	mps11 (net31 net158 vdda vdda) pmos1 l=180n w=1u m=1
	mpd11 (net56 inn net31 net31) pmos1 l=180n w=1u m=1
	mp001 (out net158 vdda vdda) pmos1 l=180n w=1u m=1
	mpd12 (net13 inp net31 net31) pmos1 l=2.2e-07n w=1.3e-06u m=1
	mpb01 (net158 net158 vdda vdda) pmos1 l=180n w=1u m=1
ends OPAMP1_variant709

subckt OPAMP1_variant710 inn inp out pd xpd vdda vssa
	xd1 (vssa vdda) prim_nwd AREA=6.13907e-9 PJ=476.6e-6 m=1
	xi0 (vssa net69) prim_nd AREA=1e-12 PJ=4e-6 m=1
	xi3 (net51 vdda) prim_pd AREA=790e-15 PJ=3.3e-6 m=1
	xr0 (vssa vdda net51) prim_rdiffp l=1.5e-07 w=1.4e-06 m=1
	xr1 (vdda vdda net69) prim_rdiffp l=3.0e-07 w=1.4e-06 m=1
	xcc01 (net12 out) prim_cpoly c=1p m=1
	mnm12 (net13 net56 vssa vssa) nmos1 l=180n w=1u m=1
	mnm11 (net56 net56 vssa vssa) nmos1 l=180n w=1u m=1
	mnb02 (net27 net27 net21 vssa) nmos1 l=180n w=1u m=1
	mnpd1 (net21 xpd vssa vssa) nmos1 l=180n w=1u m=1
	mn001 (out net13 vssa vssa) nmos1 l=1.5e-07n w=2.0e-06u m=1
	mnpd2 (net13 pd vssa vssa) nmos1 l=180n w=1u m=1
	mnc01 (net13 net69 net12 vssa) nmos1 l=1.8e-07n w=1.3e-06u m=1
	mpb02 (net27 net51 net158 vdda) pmos1 l=2.9e-07n w=1.5e-06u m=1
	mppd1 (net158 xpd vdda vdda) pmos1 l=180n w=1u m=1
	mps11 (net31 net158 vdda vdda) pmos1 l=180n w=1u m=1
	mpd11 (net56 inn net31 net31) pmos1 l=180n w=1u m=1
	mp001 (out net158 vdda vdda) pmos1 l=180n w=1u m=1
	mpd12 (net13 inp net31 net31) pmos1 l=180n w=1u m=1
	mpb01 (net158 net158 vdda vdda) pmos1 l=180n w=1u m=1
ends OPAMP1_variant710

subckt OPAMP1_variant711 inn inp out pd xpd vdda vssa
	xd1 (vssa vdda) prim_nwd AREA=6.13907e-9 PJ=476.6e-6 m=1
	xi0 (vssa net69) prim_nd AREA=1e-12 PJ=4e-6 m=1
	xi3 (net51 vdda) prim_pd AREA=790e-15 PJ=3.3e-6 m=1
	xr0 (vssa vdda net51) prim_rdiffp l=2.1e-6 w=700e-9 m=1
	xr1 (vdda vdda net69) prim_rdiffp l=2.1e-6 w=700e-9 m=1
	xcc01 (net12 out) prim_cpoly c=9.4e-13p m=1
	mnm12 (net13 net56 vssa vssa) nmos1 l=180n w=1u m=1
	mnm11 (net56 net56 vssa vssa) nmos1 l=180n w=1u m=1
	mnb02 (net27 net27 net21 vssa) nmos1 l=180n w=1u m=1
	mnpd1 (net21 xpd vssa vssa) nmos1 l=180n w=1u m=1
	mn001 (out net13 vssa vssa) nmos1 l=180n w=1u m=1
	mnpd2 (net13 pd vssa vssa) nmos1 l=1.1e-07n w=5.8e-07u m=1
	mnc01 (net13 net69 net12 vssa) nmos1 l=180n w=1u m=1
	mpb02 (net27 net51 net158 vdda) pmos1 l=180n w=1u m=1
	mppd1 (net158 xpd vdda vdda) pmos1 l=180n w=1u m=1
	mps11 (net31 net158 vdda vdda) pmos1 l=180n w=1u m=1
	mpd11 (net56 inn net31 net31) pmos1 l=180n w=1u m=1
	mp001 (out net158 vdda vdda) pmos1 l=180n w=1u m=1
	mpd12 (net13 inp net31 net31) pmos1 l=180n w=1u m=1
	mpb01 (net158 net158 vdda vdda) pmos1 l=2.7e-07n w=1.8e-06u m=1
ends OPAMP1_variant711

subckt OPAMP1_variant712 inn inp out pd xpd vdda vssa
	xd1 (vssa vdda) prim_nwd AREA=6.13907e-9 PJ=476.6e-6 m=1
	xi0 (vssa net69) prim_nd AREA=1e-12 PJ=4e-6 m=1
	xi3 (net51 vdda) prim_pd AREA=790e-15 PJ=3.3e-6 m=1
	xr0 (vssa vdda net51) prim_rdiffp l=2.8e-07 w=1.0e-06 m=1
	xr1 (vdda vdda net69) prim_rdiffp l=2.1e-6 w=700e-9 m=1
	xcc01 (net12 out) prim_cpoly c=1p m=1
	mnm12 (net13 net56 vssa vssa) nmos1 l=180n w=1u m=1
	mnm11 (net56 net56 vssa vssa) nmos1 l=180n w=1u m=1
	mnb02 (net27 net27 net21 vssa) nmos1 l=180n w=1u m=1
	mnpd1 (net21 xpd vssa vssa) nmos1 l=180n w=1u m=1
	mn001 (out net13 vssa vssa) nmos1 l=180n w=1u m=1
	mnpd2 (net13 pd vssa vssa) nmos1 l=180n w=1u m=1
	mnc01 (net13 net69 net12 vssa) nmos1 l=180n w=1u m=1
	mpb02 (net27 net51 net158 vdda) pmos1 l=2.0e-07n w=1.6e-06u m=1
	mppd1 (net158 xpd vdda vdda) pmos1 l=1.8e-07n w=7.0e-07u m=1
	mps11 (net31 net158 vdda vdda) pmos1 l=180n w=1u m=1
	mpd11 (net56 inn net31 net31) pmos1 l=180n w=1u m=1
	mp001 (out net158 vdda vdda) pmos1 l=180n w=1u m=1
	mpd12 (net13 inp net31 net31) pmos1 l=180n w=1u m=1
	mpb01 (net158 net158 vdda vdda) pmos1 l=180n w=1u m=1
ends OPAMP1_variant712

subckt OPAMP1_variant713 inn inp out pd xpd vdda vssa
	xd1 (vssa vdda) prim_nwd AREA=6.13907e-9 PJ=476.6e-6 m=1
	xi0 (vssa net69) prim_nd AREA=1e-12 PJ=4e-6 m=1
	xi3 (net51 vdda) prim_pd AREA=790e-15 PJ=3.3e-6 m=1
	xr0 (vssa vdda net51) prim_rdiffp l=1.3e-07 w=1.5e-06 m=1
	xr1 (vdda vdda net69) prim_rdiffp l=2.1e-6 w=700e-9 m=1
	xcc01 (net12 out) prim_cpoly c=1p m=1
	mnm12 (net13 net56 vssa vssa) nmos1 l=180n w=1u m=1
	mnm11 (net56 net56 vssa vssa) nmos1 l=180n w=1u m=1
	mnb02 (net27 net27 net21 vssa) nmos1 l=180n w=1u m=1
	mnpd1 (net21 xpd vssa vssa) nmos1 l=180n w=1u m=1
	mn001 (out net13 vssa vssa) nmos1 l=180n w=1u m=1
	mnpd2 (net13 pd vssa vssa) nmos1 l=180n w=1u m=1
	mnc01 (net13 net69 net12 vssa) nmos1 l=180n w=1u m=1
	mpb02 (net27 net51 net158 vdda) pmos1 l=2.6e-07n w=1.3e-06u m=1
	mppd1 (net158 xpd vdda vdda) pmos1 l=180n w=1u m=1
	mps11 (net31 net158 vdda vdda) pmos1 l=1.4e-07n w=9.3e-07u m=1
	mpd11 (net56 inn net31 net31) pmos1 l=180n w=1u m=1
	mp001 (out net158 vdda vdda) pmos1 l=180n w=1u m=1
	mpd12 (net13 inp net31 net31) pmos1 l=180n w=1u m=1
	mpb01 (net158 net158 vdda vdda) pmos1 l=180n w=1u m=1
ends OPAMP1_variant713

subckt OPAMP1_variant714 inn inp out pd xpd vdda vssa
	xd1 (vssa vdda) prim_nwd AREA=6.13907e-9 PJ=476.6e-6 m=1
	xi0 (vssa net69) prim_nd AREA=1e-12 PJ=4e-6 m=1
	xi3 (net51 vdda) prim_pd AREA=790e-15 PJ=3.3e-6 m=1
	xr0 (vssa vdda net51) prim_rdiffp l=2.1e-6 w=700e-9 m=1
	xr1 (vdda vdda net69) prim_rdiffp l=2.1e-6 w=700e-9 m=1
	xcc01 (net12 out) prim_cpoly c=1p m=1
	mnm12 (net13 net56 vssa vssa) nmos1 l=180n w=1u m=1
	mnm11 (net56 net56 vssa vssa) nmos1 l=180n w=1u m=1
	mnb02 (net27 net27 net21 vssa) nmos1 l=180n w=1u m=1
	mnpd1 (net21 xpd vssa vssa) nmos1 l=2.0e-07n w=5.1e-07u m=1
	mn001 (out net13 vssa vssa) nmos1 l=180n w=1u m=1
	mnpd2 (net13 pd vssa vssa) nmos1 l=180n w=1u m=1
	mnc01 (net13 net69 net12 vssa) nmos1 l=180n w=1u m=1
	mpb02 (net27 net51 net158 vdda) pmos1 l=180n w=1u m=1
	mppd1 (net158 xpd vdda vdda) pmos1 l=180n w=1u m=1
	mps11 (net31 net158 vdda vdda) pmos1 l=180n w=1u m=1
	mpd11 (net56 inn net31 net31) pmos1 l=180n w=1u m=1
	mp001 (out net158 vdda vdda) pmos1 l=180n w=1u m=1
	mpd12 (net13 inp net31 net31) pmos1 l=180n w=1u m=1
	mpb01 (net158 net158 vdda vdda) pmos1 l=1.9e-07n w=1.2e-06u m=1
ends OPAMP1_variant714

subckt OPAMP1_variant715 inn inp out pd xpd vdda vssa
	xd1 (vssa vdda) prim_nwd AREA=5.3e-09 PJ=3.5e-05 m=1
	xi0 (vssa net69) prim_nd AREA=4.9e-09 PJ=2.8e-05 m=1
	xi3 (net51 vdda) prim_pd AREA=790e-15 PJ=3.3e-6 m=1
	xr0 (vssa vdda net51) prim_rdiffp l=2.1e-6 w=700e-9 m=1
	xr1 (vdda vdda net69) prim_rdiffp l=1.9e-07 w=7.9e-07 m=1
	xcc01 (net12 out) prim_cpoly c=1p m=1
	mnm12 (net13 net56 vssa vssa) nmos1 l=2.3e-07n w=9.8e-07u m=1
	mnm11 (net56 net56 vssa vssa) nmos1 l=180n w=1u m=1
	mnb02 (net27 net27 net21 vssa) nmos1 l=180n w=1u m=1
	mnpd1 (net21 xpd vssa vssa) nmos1 l=180n w=1u m=1
	mn001 (out net13 vssa vssa) nmos1 l=180n w=1u m=1
	mnpd2 (net13 pd vssa vssa) nmos1 l=180n w=1u m=1
	mnc01 (net13 net69 net12 vssa) nmos1 l=180n w=1u m=1
	mpb02 (net27 net51 net158 vdda) pmos1 l=180n w=1u m=1
	mppd1 (net158 xpd vdda vdda) pmos1 l=2.1e-07n w=1.2e-06u m=1
	mps11 (net31 net158 vdda vdda) pmos1 l=180n w=1u m=1
	mpd11 (net56 inn net31 net31) pmos1 l=180n w=1u m=1
	mp001 (out net158 vdda vdda) pmos1 l=180n w=1u m=1
	mpd12 (net13 inp net31 net31) pmos1 l=180n w=1u m=1
	mpb01 (net158 net158 vdda vdda) pmos1 l=180n w=1u m=1
ends OPAMP1_variant715

subckt OPAMP1_variant716 inn inp out pd xpd vdda vssa
	xd1 (vssa vdda) prim_nwd AREA=6.13907e-9 PJ=476.6e-6 m=1
	xi0 (vssa net69) prim_nd AREA=1e-12 PJ=4e-6 m=1
	xi3 (net51 vdda) prim_pd AREA=790e-15 PJ=3.3e-6 m=1
	xr0 (vssa vdda net51) prim_rdiffp l=2.1e-6 w=700e-9 m=1
	xr1 (vdda vdda net69) prim_rdiffp l=2.1e-6 w=700e-9 m=1
	xcc01 (net12 out) prim_cpoly c=1p m=1
	mnm12 (net13 net56 vssa vssa) nmos1 l=2.9e-07n w=1.2e-06u m=1
	mnm11 (net56 net56 vssa vssa) nmos1 l=2.1e-07n w=2.0e-06u m=1
	mnb02 (net27 net27 net21 vssa) nmos1 l=180n w=1u m=1
	mnpd1 (net21 xpd vssa vssa) nmos1 l=180n w=1u m=1
	mn001 (out net13 vssa vssa) nmos1 l=2.7e-07n w=1.8e-06u m=1
	mnpd2 (net13 pd vssa vssa) nmos1 l=1.9e-07n w=1.7e-06u m=1
	mnc01 (net13 net69 net12 vssa) nmos1 l=1.9e-07n w=1.1e-06u m=1
	mpb02 (net27 net51 net158 vdda) pmos1 l=180n w=1u m=1
	mppd1 (net158 xpd vdda vdda) pmos1 l=180n w=1u m=1
	mps11 (net31 net158 vdda vdda) pmos1 l=180n w=1u m=1
	mpd11 (net56 inn net31 net31) pmos1 l=180n w=1u m=1
	mp001 (out net158 vdda vdda) pmos1 l=180n w=1u m=1
	mpd12 (net13 inp net31 net31) pmos1 l=180n w=1u m=1
	mpb01 (net158 net158 vdda vdda) pmos1 l=180n w=1u m=1
ends OPAMP1_variant716

subckt OPAMP1_variant717 inn inp out pd xpd vdda vssa
	xd1 (vssa vdda) prim_nwd AREA=6.13907e-9 PJ=476.6e-6 m=1
	xi0 (vssa net69) prim_nd AREA=1e-12 PJ=4e-6 m=1
	xi3 (net51 vdda) prim_pd AREA=790e-15 PJ=3.3e-6 m=1
	xr0 (vssa vdda net51) prim_rdiffp l=2.1e-6 w=700e-9 m=1
	xr1 (vdda vdda net69) prim_rdiffp l=2.1e-07 w=6.6e-07 m=1
	xcc01 (net12 out) prim_cpoly c=1p m=1
	mnm12 (net13 net56 vssa vssa) nmos1 l=180n w=1u m=1
	mnm11 (net56 net56 vssa vssa) nmos1 l=180n w=1u m=1
	mnb02 (net27 net27 net21 vssa) nmos1 l=180n w=1u m=1
	mnpd1 (net21 xpd vssa vssa) nmos1 l=180n w=1u m=1
	mn001 (out net13 vssa vssa) nmos1 l=180n w=1u m=1
	mnpd2 (net13 pd vssa vssa) nmos1 l=180n w=1u m=1
	mnc01 (net13 net69 net12 vssa) nmos1 l=1.0e-07n w=1.6e-06u m=1
	mpb02 (net27 net51 net158 vdda) pmos1 l=180n w=1u m=1
	mppd1 (net158 xpd vdda vdda) pmos1 l=180n w=1u m=1
	mps11 (net31 net158 vdda vdda) pmos1 l=180n w=1u m=1
	mpd11 (net56 inn net31 net31) pmos1 l=180n w=1u m=1
	mp001 (out net158 vdda vdda) pmos1 l=180n w=1u m=1
	mpd12 (net13 inp net31 net31) pmos1 l=180n w=1u m=1
	mpb01 (net158 net158 vdda vdda) pmos1 l=180n w=1u m=1
ends OPAMP1_variant717

subckt OPAMP1_variant718 inn inp out pd xpd vdda vssa
	xd1 (vssa vdda) prim_nwd AREA=6.13907e-9 PJ=476.6e-6 m=1
	xi0 (vssa net69) prim_nd AREA=6.3e-09 PJ=2.6e-05 m=1
	xi3 (net51 vdda) prim_pd AREA=790e-15 PJ=3.3e-6 m=1
	xr0 (vssa vdda net51) prim_rdiffp l=2.1e-6 w=700e-9 m=1
	xr1 (vdda vdda net69) prim_rdiffp l=2.1e-6 w=700e-9 m=1
	xcc01 (net12 out) prim_cpoly c=1p m=1
	mnm12 (net13 net56 vssa vssa) nmos1 l=180n w=1u m=1
	mnm11 (net56 net56 vssa vssa) nmos1 l=180n w=1u m=1
	mnb02 (net27 net27 net21 vssa) nmos1 l=180n w=1u m=1
	mnpd1 (net21 xpd vssa vssa) nmos1 l=180n w=1u m=1
	mn001 (out net13 vssa vssa) nmos1 l=180n w=1u m=1
	mnpd2 (net13 pd vssa vssa) nmos1 l=180n w=1u m=1
	mnc01 (net13 net69 net12 vssa) nmos1 l=180n w=1u m=1
	mpb02 (net27 net51 net158 vdda) pmos1 l=180n w=1u m=1
	mppd1 (net158 xpd vdda vdda) pmos1 l=180n w=1u m=1
	mps11 (net31 net158 vdda vdda) pmos1 l=180n w=1u m=1
	mpd11 (net56 inn net31 net31) pmos1 l=180n w=1u m=1
	mp001 (out net158 vdda vdda) pmos1 l=180n w=1u m=1
	mpd12 (net13 inp net31 net31) pmos1 l=180n w=1u m=1
	mpb01 (net158 net158 vdda vdda) pmos1 l=1.6e-07n w=6.5e-07u m=1
ends OPAMP1_variant718

subckt OPAMP1_variant719 inn inp out pd xpd vdda vssa
	xd1 (vssa vdda) prim_nwd AREA=6.13907e-9 PJ=476.6e-6 m=1
	xi0 (vssa net69) prim_nd AREA=1e-12 PJ=4e-6 m=1
	xi3 (net51 vdda) prim_pd AREA=790e-15 PJ=3.3e-6 m=1
	xr0 (vssa vdda net51) prim_rdiffp l=2.1e-6 w=700e-9 m=1
	xr1 (vdda vdda net69) prim_rdiffp l=2.6e-07 w=8.8e-07 m=1
	xcc01 (net12 out) prim_cpoly c=1p m=1
	mnm12 (net13 net56 vssa vssa) nmos1 l=180n w=1u m=1
	mnm11 (net56 net56 vssa vssa) nmos1 l=180n w=1u m=1
	mnb02 (net27 net27 net21 vssa) nmos1 l=180n w=1u m=1
	mnpd1 (net21 xpd vssa vssa) nmos1 l=180n w=1u m=1
	mn001 (out net13 vssa vssa) nmos1 l=180n w=1u m=1
	mnpd2 (net13 pd vssa vssa) nmos1 l=180n w=1u m=1
	mnc01 (net13 net69 net12 vssa) nmos1 l=180n w=1u m=1
	mpb02 (net27 net51 net158 vdda) pmos1 l=180n w=1u m=1
	mppd1 (net158 xpd vdda vdda) pmos1 l=1.7e-07n w=1.8e-06u m=1
	mps11 (net31 net158 vdda vdda) pmos1 l=180n w=1u m=1
	mpd11 (net56 inn net31 net31) pmos1 l=180n w=1u m=1
	mp001 (out net158 vdda vdda) pmos1 l=2.0e-07n w=1.6e-06u m=1
	mpd12 (net13 inp net31 net31) pmos1 l=180n w=1u m=1
	mpb01 (net158 net158 vdda vdda) pmos1 l=180n w=1u m=1
ends OPAMP1_variant719

subckt OPAMP1_variant720 inn inp out pd xpd vdda vssa
	xd1 (vssa vdda) prim_nwd AREA=6.13907e-9 PJ=476.6e-6 m=1
	xi0 (vssa net69) prim_nd AREA=1e-12 PJ=4e-6 m=1
	xi3 (net51 vdda) prim_pd AREA=790e-15 PJ=3.3e-6 m=1
	xr0 (vssa vdda net51) prim_rdiffp l=2.1e-6 w=700e-9 m=1
	xr1 (vdda vdda net69) prim_rdiffp l=2.1e-6 w=700e-9 m=1
	xcc01 (net12 out) prim_cpoly c=1p m=1
	mnm12 (net13 net56 vssa vssa) nmos1 l=180n w=1u m=1
	mnm11 (net56 net56 vssa vssa) nmos1 l=180n w=1u m=1
	mnb02 (net27 net27 net21 vssa) nmos1 l=180n w=1u m=1
	mnpd1 (net21 xpd vssa vssa) nmos1 l=1.7e-07n w=7.6e-07u m=1
	mn001 (out net13 vssa vssa) nmos1 l=180n w=1u m=1
	mnpd2 (net13 pd vssa vssa) nmos1 l=180n w=1u m=1
	mnc01 (net13 net69 net12 vssa) nmos1 l=180n w=1u m=1
	mpb02 (net27 net51 net158 vdda) pmos1 l=2.1e-07n w=1.0e-06u m=1
	mppd1 (net158 xpd vdda vdda) pmos1 l=180n w=1u m=1
	mps11 (net31 net158 vdda vdda) pmos1 l=180n w=1u m=1
	mpd11 (net56 inn net31 net31) pmos1 l=2.0e-07n w=1.4e-06u m=1
	mp001 (out net158 vdda vdda) pmos1 l=180n w=1u m=1
	mpd12 (net13 inp net31 net31) pmos1 l=180n w=1u m=1
	mpb01 (net158 net158 vdda vdda) pmos1 l=180n w=1u m=1
ends OPAMP1_variant720

subckt OPAMP1_variant721 inn inp out pd xpd vdda vssa
	xd1 (vssa vdda) prim_nwd AREA=6.13907e-9 PJ=476.6e-6 m=1
	xi0 (vssa net69) prim_nd AREA=1e-12 PJ=4e-6 m=1
	xi3 (net51 vdda) prim_pd AREA=790e-15 PJ=3.3e-6 m=1
	xr0 (vssa vdda net51) prim_rdiffp l=2.1e-6 w=700e-9 m=1
	xr1 (vdda vdda net69) prim_rdiffp l=2.8e-07 w=1.4e-06 m=1
	xcc01 (net12 out) prim_cpoly c=1p m=1
	mnm12 (net13 net56 vssa vssa) nmos1 l=1.7e-07n w=1.9e-06u m=1
	mnm11 (net56 net56 vssa vssa) nmos1 l=180n w=1u m=1
	mnb02 (net27 net27 net21 vssa) nmos1 l=180n w=1u m=1
	mnpd1 (net21 xpd vssa vssa) nmos1 l=180n w=1u m=1
	mn001 (out net13 vssa vssa) nmos1 l=180n w=1u m=1
	mnpd2 (net13 pd vssa vssa) nmos1 l=180n w=1u m=1
	mnc01 (net13 net69 net12 vssa) nmos1 l=1.4e-07n w=1.9e-06u m=1
	mpb02 (net27 net51 net158 vdda) pmos1 l=180n w=1u m=1
	mppd1 (net158 xpd vdda vdda) pmos1 l=180n w=1u m=1
	mps11 (net31 net158 vdda vdda) pmos1 l=180n w=1u m=1
	mpd11 (net56 inn net31 net31) pmos1 l=180n w=1u m=1
	mp001 (out net158 vdda vdda) pmos1 l=180n w=1u m=1
	mpd12 (net13 inp net31 net31) pmos1 l=180n w=1u m=1
	mpb01 (net158 net158 vdda vdda) pmos1 l=2.8e-07n w=1.9e-06u m=1
ends OPAMP1_variant721

subckt OPAMP1_variant722 inn inp out pd xpd vdda vssa
	xd1 (vssa vdda) prim_nwd AREA=6.13907e-9 PJ=476.6e-6 m=1
	xi0 (vssa net69) prim_nd AREA=1e-12 PJ=4e-6 m=1
	xi3 (net51 vdda) prim_pd AREA=790e-15 PJ=3.3e-6 m=1
	xr0 (vssa vdda net51) prim_rdiffp l=2.1e-6 w=700e-9 m=1
	xr1 (vdda vdda net69) prim_rdiffp l=2.1e-6 w=700e-9 m=1
	xcc01 (net12 out) prim_cpoly c=1p m=1
	mnm12 (net13 net56 vssa vssa) nmos1 l=2.6e-07n w=9.9e-07u m=1
	mnm11 (net56 net56 vssa vssa) nmos1 l=180n w=1u m=1
	mnb02 (net27 net27 net21 vssa) nmos1 l=180n w=1u m=1
	mnpd1 (net21 xpd vssa vssa) nmos1 l=180n w=1u m=1
	mn001 (out net13 vssa vssa) nmos1 l=180n w=1u m=1
	mnpd2 (net13 pd vssa vssa) nmos1 l=180n w=1u m=1
	mnc01 (net13 net69 net12 vssa) nmos1 l=180n w=1u m=1
	mpb02 (net27 net51 net158 vdda) pmos1 l=180n w=1u m=1
	mppd1 (net158 xpd vdda vdda) pmos1 l=180n w=1u m=1
	mps11 (net31 net158 vdda vdda) pmos1 l=180n w=1u m=1
	mpd11 (net56 inn net31 net31) pmos1 l=180n w=1u m=1
	mp001 (out net158 vdda vdda) pmos1 l=180n w=1u m=1
	mpd12 (net13 inp net31 net31) pmos1 l=2.9e-07n w=1.8e-06u m=1
	mpb01 (net158 net158 vdda vdda) pmos1 l=180n w=1u m=1
ends OPAMP1_variant722

subckt OPAMP1_variant723 inn inp out pd xpd vdda vssa
	xd1 (vssa vdda) prim_nwd AREA=6.13907e-9 PJ=476.6e-6 m=1
	xi0 (vssa net69) prim_nd AREA=5.4e-10 PJ=1.8e-05 m=1
	xi3 (net51 vdda) prim_pd AREA=8.8e-09 PJ=3.0e-05 m=1
	xr0 (vssa vdda net51) prim_rdiffp l=2.1e-6 w=700e-9 m=1
	xr1 (vdda vdda net69) prim_rdiffp l=2.1e-07 w=9.3e-07 m=1
	xcc01 (net12 out) prim_cpoly c=1p m=1
	mnm12 (net13 net56 vssa vssa) nmos1 l=180n w=1u m=1
	mnm11 (net56 net56 vssa vssa) nmos1 l=2.0e-07n w=1.9e-06u m=1
	mnb02 (net27 net27 net21 vssa) nmos1 l=1.4e-07n w=6.9e-07u m=1
	mnpd1 (net21 xpd vssa vssa) nmos1 l=180n w=1u m=1
	mn001 (out net13 vssa vssa) nmos1 l=180n w=1u m=1
	mnpd2 (net13 pd vssa vssa) nmos1 l=180n w=1u m=1
	mnc01 (net13 net69 net12 vssa) nmos1 l=180n w=1u m=1
	mpb02 (net27 net51 net158 vdda) pmos1 l=180n w=1u m=1
	mppd1 (net158 xpd vdda vdda) pmos1 l=180n w=1u m=1
	mps11 (net31 net158 vdda vdda) pmos1 l=180n w=1u m=1
	mpd11 (net56 inn net31 net31) pmos1 l=180n w=1u m=1
	mp001 (out net158 vdda vdda) pmos1 l=180n w=1u m=1
	mpd12 (net13 inp net31 net31) pmos1 l=180n w=1u m=1
	mpb01 (net158 net158 vdda vdda) pmos1 l=180n w=1u m=1
ends OPAMP1_variant723

subckt OPAMP1_variant724 inn inp out pd xpd vdda vssa
	xd1 (vssa vdda) prim_nwd AREA=6.13907e-9 PJ=476.6e-6 m=1
	xi0 (vssa net69) prim_nd AREA=6.6e-09 PJ=4.6e-05 m=1
	xi3 (net51 vdda) prim_pd AREA=790e-15 PJ=3.3e-6 m=1
	xr0 (vssa vdda net51) prim_rdiffp l=2.1e-6 w=700e-9 m=1
	xr1 (vdda vdda net69) prim_rdiffp l=2.1e-6 w=700e-9 m=1
	xcc01 (net12 out) prim_cpoly c=1p m=1
	mnm12 (net13 net56 vssa vssa) nmos1 l=180n w=1u m=1
	mnm11 (net56 net56 vssa vssa) nmos1 l=180n w=1u m=1
	mnb02 (net27 net27 net21 vssa) nmos1 l=1.4e-07n w=1.8e-06u m=1
	mnpd1 (net21 xpd vssa vssa) nmos1 l=180n w=1u m=1
	mn001 (out net13 vssa vssa) nmos1 l=180n w=1u m=1
	mnpd2 (net13 pd vssa vssa) nmos1 l=180n w=1u m=1
	mnc01 (net13 net69 net12 vssa) nmos1 l=180n w=1u m=1
	mpb02 (net27 net51 net158 vdda) pmos1 l=180n w=1u m=1
	mppd1 (net158 xpd vdda vdda) pmos1 l=180n w=1u m=1
	mps11 (net31 net158 vdda vdda) pmos1 l=180n w=1u m=1
	mpd11 (net56 inn net31 net31) pmos1 l=180n w=1u m=1
	mp001 (out net158 vdda vdda) pmos1 l=180n w=1u m=1
	mpd12 (net13 inp net31 net31) pmos1 l=180n w=1u m=1
	mpb01 (net158 net158 vdda vdda) pmos1 l=180n w=1u m=1
ends OPAMP1_variant724

subckt OPAMP1_variant725 inn inp out pd xpd vdda vssa
	xd1 (vssa vdda) prim_nwd AREA=6.13907e-9 PJ=476.6e-6 m=1
	xi0 (vssa net69) prim_nd AREA=1e-12 PJ=4e-6 m=1
	xi3 (net51 vdda) prim_pd AREA=790e-15 PJ=3.3e-6 m=1
	xr0 (vssa vdda net51) prim_rdiffp l=3.0e-07 w=5.2e-07 m=1
	xr1 (vdda vdda net69) prim_rdiffp l=2.2e-07 w=9.5e-07 m=1
	xcc01 (net12 out) prim_cpoly c=1p m=1
	mnm12 (net13 net56 vssa vssa) nmos1 l=180n w=1u m=1
	mnm11 (net56 net56 vssa vssa) nmos1 l=180n w=1u m=1
	mnb02 (net27 net27 net21 vssa) nmos1 l=180n w=1u m=1
	mnpd1 (net21 xpd vssa vssa) nmos1 l=180n w=1u m=1
	mn001 (out net13 vssa vssa) nmos1 l=180n w=1u m=1
	mnpd2 (net13 pd vssa vssa) nmos1 l=180n w=1u m=1
	mnc01 (net13 net69 net12 vssa) nmos1 l=180n w=1u m=1
	mpb02 (net27 net51 net158 vdda) pmos1 l=180n w=1u m=1
	mppd1 (net158 xpd vdda vdda) pmos1 l=180n w=1u m=1
	mps11 (net31 net158 vdda vdda) pmos1 l=180n w=1u m=1
	mpd11 (net56 inn net31 net31) pmos1 l=180n w=1u m=1
	mp001 (out net158 vdda vdda) pmos1 l=180n w=1u m=1
	mpd12 (net13 inp net31 net31) pmos1 l=2.3e-07n w=1.9e-06u m=1
	mpb01 (net158 net158 vdda vdda) pmos1 l=2.0e-07n w=1.9e-06u m=1
ends OPAMP1_variant725

subckt OPAMP1_variant726 inn inp out pd xpd vdda vssa
	xd1 (vssa vdda) prim_nwd AREA=6.13907e-9 PJ=476.6e-6 m=1
	xi0 (vssa net69) prim_nd AREA=4.0e-09 PJ=6.7e-05 m=1
	xi3 (net51 vdda) prim_pd AREA=790e-15 PJ=3.3e-6 m=1
	xr0 (vssa vdda net51) prim_rdiffp l=2.1e-6 w=700e-9 m=1
	xr1 (vdda vdda net69) prim_rdiffp l=2.1e-6 w=700e-9 m=1
	xcc01 (net12 out) prim_cpoly c=1p m=1
	mnm12 (net13 net56 vssa vssa) nmos1 l=1.0e-07n w=1.0e-06u m=1
	mnm11 (net56 net56 vssa vssa) nmos1 l=180n w=1u m=1
	mnb02 (net27 net27 net21 vssa) nmos1 l=180n w=1u m=1
	mnpd1 (net21 xpd vssa vssa) nmos1 l=180n w=1u m=1
	mn001 (out net13 vssa vssa) nmos1 l=180n w=1u m=1
	mnpd2 (net13 pd vssa vssa) nmos1 l=180n w=1u m=1
	mnc01 (net13 net69 net12 vssa) nmos1 l=180n w=1u m=1
	mpb02 (net27 net51 net158 vdda) pmos1 l=180n w=1u m=1
	mppd1 (net158 xpd vdda vdda) pmos1 l=180n w=1u m=1
	mps11 (net31 net158 vdda vdda) pmos1 l=180n w=1u m=1
	mpd11 (net56 inn net31 net31) pmos1 l=180n w=1u m=1
	mp001 (out net158 vdda vdda) pmos1 l=180n w=1u m=1
	mpd12 (net13 inp net31 net31) pmos1 l=180n w=1u m=1
	mpb01 (net158 net158 vdda vdda) pmos1 l=1.5e-07n w=1.7e-06u m=1
ends OPAMP1_variant726

subckt OPAMP1_variant727 inn inp out pd xpd vdda vssa
	xd1 (vssa vdda) prim_nwd AREA=6.13907e-9 PJ=476.6e-6 m=1
	xi0 (vssa net69) prim_nd AREA=1e-12 PJ=4e-6 m=1
	xi3 (net51 vdda) prim_pd AREA=790e-15 PJ=3.3e-6 m=1
	xr0 (vssa vdda net51) prim_rdiffp l=1.4e-07 w=1.9e-06 m=1
	xr1 (vdda vdda net69) prim_rdiffp l=2.1e-6 w=700e-9 m=1
	xcc01 (net12 out) prim_cpoly c=5.6e-13p m=1
	mnm12 (net13 net56 vssa vssa) nmos1 l=180n w=1u m=1
	mnm11 (net56 net56 vssa vssa) nmos1 l=180n w=1u m=1
	mnb02 (net27 net27 net21 vssa) nmos1 l=180n w=1u m=1
	mnpd1 (net21 xpd vssa vssa) nmos1 l=180n w=1u m=1
	mn001 (out net13 vssa vssa) nmos1 l=180n w=1u m=1
	mnpd2 (net13 pd vssa vssa) nmos1 l=180n w=1u m=1
	mnc01 (net13 net69 net12 vssa) nmos1 l=180n w=1u m=1
	mpb02 (net27 net51 net158 vdda) pmos1 l=180n w=1u m=1
	mppd1 (net158 xpd vdda vdda) pmos1 l=180n w=1u m=1
	mps11 (net31 net158 vdda vdda) pmos1 l=180n w=1u m=1
	mpd11 (net56 inn net31 net31) pmos1 l=180n w=1u m=1
	mp001 (out net158 vdda vdda) pmos1 l=180n w=1u m=1
	mpd12 (net13 inp net31 net31) pmos1 l=180n w=1u m=1
	mpb01 (net158 net158 vdda vdda) pmos1 l=180n w=1u m=1
ends OPAMP1_variant727

subckt OPAMP1_variant728 inn inp out pd xpd vdda vssa
	xd1 (vssa vdda) prim_nwd AREA=6.13907e-9 PJ=476.6e-6 m=1
	xi0 (vssa net69) prim_nd AREA=1e-12 PJ=4e-6 m=1
	xi3 (net51 vdda) prim_pd AREA=790e-15 PJ=3.3e-6 m=1
	xr0 (vssa vdda net51) prim_rdiffp l=2.1e-6 w=700e-9 m=1
	xr1 (vdda vdda net69) prim_rdiffp l=2.1e-6 w=700e-9 m=1
	xcc01 (net12 out) prim_cpoly c=1.6e-12p m=1
	mnm12 (net13 net56 vssa vssa) nmos1 l=180n w=1u m=1
	mnm11 (net56 net56 vssa vssa) nmos1 l=180n w=1u m=1
	mnb02 (net27 net27 net21 vssa) nmos1 l=180n w=1u m=1
	mnpd1 (net21 xpd vssa vssa) nmos1 l=180n w=1u m=1
	mn001 (out net13 vssa vssa) nmos1 l=1.0e-07n w=1.7e-06u m=1
	mnpd2 (net13 pd vssa vssa) nmos1 l=180n w=1u m=1
	mnc01 (net13 net69 net12 vssa) nmos1 l=1.2e-07n w=1.1e-06u m=1
	mpb02 (net27 net51 net158 vdda) pmos1 l=180n w=1u m=1
	mppd1 (net158 xpd vdda vdda) pmos1 l=180n w=1u m=1
	mps11 (net31 net158 vdda vdda) pmos1 l=180n w=1u m=1
	mpd11 (net56 inn net31 net31) pmos1 l=2.0e-07n w=1.4e-06u m=1
	mp001 (out net158 vdda vdda) pmos1 l=2.0e-07n w=1.9e-06u m=1
	mpd12 (net13 inp net31 net31) pmos1 l=180n w=1u m=1
	mpb01 (net158 net158 vdda vdda) pmos1 l=180n w=1u m=1
ends OPAMP1_variant728

subckt OPAMP1_variant729 inn inp out pd xpd vdda vssa
	xd1 (vssa vdda) prim_nwd AREA=8.5e-09 PJ=2.0e-05 m=1
	xi0 (vssa net69) prim_nd AREA=1e-12 PJ=4e-6 m=1
	xi3 (net51 vdda) prim_pd AREA=790e-15 PJ=3.3e-6 m=1
	xr0 (vssa vdda net51) prim_rdiffp l=2.1e-6 w=700e-9 m=1
	xr1 (vdda vdda net69) prim_rdiffp l=2.1e-6 w=700e-9 m=1
	xcc01 (net12 out) prim_cpoly c=1.0e-12p m=1
	mnm12 (net13 net56 vssa vssa) nmos1 l=180n w=1u m=1
	mnm11 (net56 net56 vssa vssa) nmos1 l=180n w=1u m=1
	mnb02 (net27 net27 net21 vssa) nmos1 l=180n w=1u m=1
	mnpd1 (net21 xpd vssa vssa) nmos1 l=180n w=1u m=1
	mn001 (out net13 vssa vssa) nmos1 l=180n w=1u m=1
	mnpd2 (net13 pd vssa vssa) nmos1 l=180n w=1u m=1
	mnc01 (net13 net69 net12 vssa) nmos1 l=180n w=1u m=1
	mpb02 (net27 net51 net158 vdda) pmos1 l=180n w=1u m=1
	mppd1 (net158 xpd vdda vdda) pmos1 l=180n w=1u m=1
	mps11 (net31 net158 vdda vdda) pmos1 l=1.5e-07n w=1.9e-06u m=1
	mpd11 (net56 inn net31 net31) pmos1 l=2.4e-07n w=1.6e-06u m=1
	mp001 (out net158 vdda vdda) pmos1 l=180n w=1u m=1
	mpd12 (net13 inp net31 net31) pmos1 l=180n w=1u m=1
	mpb01 (net158 net158 vdda vdda) pmos1 l=180n w=1u m=1
ends OPAMP1_variant729

subckt OPAMP1_variant730 inn inp out pd xpd vdda vssa
	xd1 (vssa vdda) prim_nwd AREA=6.13907e-9 PJ=476.6e-6 m=1
	xi0 (vssa net69) prim_nd AREA=1e-12 PJ=4e-6 m=1
	xi3 (net51 vdda) prim_pd AREA=790e-15 PJ=3.3e-6 m=1
	xr0 (vssa vdda net51) prim_rdiffp l=2.1e-6 w=700e-9 m=1
	xr1 (vdda vdda net69) prim_rdiffp l=2.1e-6 w=700e-9 m=1
	xcc01 (net12 out) prim_cpoly c=1p m=1
	mnm12 (net13 net56 vssa vssa) nmos1 l=180n w=1u m=1
	mnm11 (net56 net56 vssa vssa) nmos1 l=180n w=1u m=1
	mnb02 (net27 net27 net21 vssa) nmos1 l=2.7e-07n w=1.8e-06u m=1
	mnpd1 (net21 xpd vssa vssa) nmos1 l=180n w=1u m=1
	mn001 (out net13 vssa vssa) nmos1 l=180n w=1u m=1
	mnpd2 (net13 pd vssa vssa) nmos1 l=180n w=1u m=1
	mnc01 (net13 net69 net12 vssa) nmos1 l=180n w=1u m=1
	mpb02 (net27 net51 net158 vdda) pmos1 l=180n w=1u m=1
	mppd1 (net158 xpd vdda vdda) pmos1 l=180n w=1u m=1
	mps11 (net31 net158 vdda vdda) pmos1 l=180n w=1u m=1
	mpd11 (net56 inn net31 net31) pmos1 l=2.2e-07n w=1.6e-06u m=1
	mp001 (out net158 vdda vdda) pmos1 l=180n w=1u m=1
	mpd12 (net13 inp net31 net31) pmos1 l=1.3e-07n w=7.4e-07u m=1
	mpb01 (net158 net158 vdda vdda) pmos1 l=180n w=1u m=1
ends OPAMP1_variant730

subckt OPAMP1_variant731 inn inp out pd xpd vdda vssa
	xd1 (vssa vdda) prim_nwd AREA=6.13907e-9 PJ=476.6e-6 m=1
	xi0 (vssa net69) prim_nd AREA=1e-12 PJ=4e-6 m=1
	xi3 (net51 vdda) prim_pd AREA=790e-15 PJ=3.3e-6 m=1
	xr0 (vssa vdda net51) prim_rdiffp l=2.1e-6 w=700e-9 m=1
	xr1 (vdda vdda net69) prim_rdiffp l=2.1e-6 w=700e-9 m=1
	xcc01 (net12 out) prim_cpoly c=1p m=1
	mnm12 (net13 net56 vssa vssa) nmos1 l=2.7e-07n w=1.8e-06u m=1
	mnm11 (net56 net56 vssa vssa) nmos1 l=180n w=1u m=1
	mnb02 (net27 net27 net21 vssa) nmos1 l=180n w=1u m=1
	mnpd1 (net21 xpd vssa vssa) nmos1 l=180n w=1u m=1
	mn001 (out net13 vssa vssa) nmos1 l=180n w=1u m=1
	mnpd2 (net13 pd vssa vssa) nmos1 l=180n w=1u m=1
	mnc01 (net13 net69 net12 vssa) nmos1 l=180n w=1u m=1
	mpb02 (net27 net51 net158 vdda) pmos1 l=180n w=1u m=1
	mppd1 (net158 xpd vdda vdda) pmos1 l=180n w=1u m=1
	mps11 (net31 net158 vdda vdda) pmos1 l=180n w=1u m=1
	mpd11 (net56 inn net31 net31) pmos1 l=1.5e-07n w=1.0e-06u m=1
	mp001 (out net158 vdda vdda) pmos1 l=180n w=1u m=1
	mpd12 (net13 inp net31 net31) pmos1 l=180n w=1u m=1
	mpb01 (net158 net158 vdda vdda) pmos1 l=1.6e-07n w=1.7e-06u m=1
ends OPAMP1_variant731

subckt OPAMP1_variant732 inn inp out pd xpd vdda vssa
	xd1 (vssa vdda) prim_nwd AREA=6.13907e-9 PJ=476.6e-6 m=1
	xi0 (vssa net69) prim_nd AREA=1e-12 PJ=4e-6 m=1
	xi3 (net51 vdda) prim_pd AREA=790e-15 PJ=3.3e-6 m=1
	xr0 (vssa vdda net51) prim_rdiffp l=2.1e-6 w=700e-9 m=1
	xr1 (vdda vdda net69) prim_rdiffp l=1.6e-07 w=1.3e-06 m=1
	xcc01 (net12 out) prim_cpoly c=1p m=1
	mnm12 (net13 net56 vssa vssa) nmos1 l=2.0e-07n w=5.9e-07u m=1
	mnm11 (net56 net56 vssa vssa) nmos1 l=180n w=1u m=1
	mnb02 (net27 net27 net21 vssa) nmos1 l=180n w=1u m=1
	mnpd1 (net21 xpd vssa vssa) nmos1 l=180n w=1u m=1
	mn001 (out net13 vssa vssa) nmos1 l=180n w=1u m=1
	mnpd2 (net13 pd vssa vssa) nmos1 l=180n w=1u m=1
	mnc01 (net13 net69 net12 vssa) nmos1 l=2.6e-07n w=1.7e-06u m=1
	mpb02 (net27 net51 net158 vdda) pmos1 l=180n w=1u m=1
	mppd1 (net158 xpd vdda vdda) pmos1 l=180n w=1u m=1
	mps11 (net31 net158 vdda vdda) pmos1 l=180n w=1u m=1
	mpd11 (net56 inn net31 net31) pmos1 l=180n w=1u m=1
	mp001 (out net158 vdda vdda) pmos1 l=180n w=1u m=1
	mpd12 (net13 inp net31 net31) pmos1 l=180n w=1u m=1
	mpb01 (net158 net158 vdda vdda) pmos1 l=180n w=1u m=1
ends OPAMP1_variant732

subckt OPAMP1_variant733 inn inp out pd xpd vdda vssa
	xd1 (vssa vdda) prim_nwd AREA=6.13907e-9 PJ=476.6e-6 m=1
	xi0 (vssa net69) prim_nd AREA=1e-12 PJ=4e-6 m=1
	xi3 (net51 vdda) prim_pd AREA=790e-15 PJ=3.3e-6 m=1
	xr0 (vssa vdda net51) prim_rdiffp l=2.1e-6 w=700e-9 m=1
	xr1 (vdda vdda net69) prim_rdiffp l=2.7e-07 w=5.1e-07 m=1
	xcc01 (net12 out) prim_cpoly c=1p m=1
	mnm12 (net13 net56 vssa vssa) nmos1 l=180n w=1u m=1
	mnm11 (net56 net56 vssa vssa) nmos1 l=180n w=1u m=1
	mnb02 (net27 net27 net21 vssa) nmos1 l=180n w=1u m=1
	mnpd1 (net21 xpd vssa vssa) nmos1 l=180n w=1u m=1
	mn001 (out net13 vssa vssa) nmos1 l=180n w=1u m=1
	mnpd2 (net13 pd vssa vssa) nmos1 l=180n w=1u m=1
	mnc01 (net13 net69 net12 vssa) nmos1 l=180n w=1u m=1
	mpb02 (net27 net51 net158 vdda) pmos1 l=180n w=1u m=1
	mppd1 (net158 xpd vdda vdda) pmos1 l=180n w=1u m=1
	mps11 (net31 net158 vdda vdda) pmos1 l=2.7e-07n w=1.3e-06u m=1
	mpd11 (net56 inn net31 net31) pmos1 l=2.3e-07n w=8.1e-07u m=1
	mp001 (out net158 vdda vdda) pmos1 l=180n w=1u m=1
	mpd12 (net13 inp net31 net31) pmos1 l=180n w=1u m=1
	mpb01 (net158 net158 vdda vdda) pmos1 l=180n w=1u m=1
ends OPAMP1_variant733

subckt OPAMP1_variant734 inn inp out pd xpd vdda vssa
	xd1 (vssa vdda) prim_nwd AREA=6.13907e-9 PJ=476.6e-6 m=1
	xi0 (vssa net69) prim_nd AREA=1e-12 PJ=4e-6 m=1
	xi3 (net51 vdda) prim_pd AREA=790e-15 PJ=3.3e-6 m=1
	xr0 (vssa vdda net51) prim_rdiffp l=2.1e-6 w=700e-9 m=1
	xr1 (vdda vdda net69) prim_rdiffp l=2.1e-6 w=700e-9 m=1
	xcc01 (net12 out) prim_cpoly c=1p m=1
	mnm12 (net13 net56 vssa vssa) nmos1 l=180n w=1u m=1
	mnm11 (net56 net56 vssa vssa) nmos1 l=180n w=1u m=1
	mnb02 (net27 net27 net21 vssa) nmos1 l=180n w=1u m=1
	mnpd1 (net21 xpd vssa vssa) nmos1 l=2.3e-07n w=6.3e-07u m=1
	mn001 (out net13 vssa vssa) nmos1 l=180n w=1u m=1
	mnpd2 (net13 pd vssa vssa) nmos1 l=2.4e-07n w=5.9e-07u m=1
	mnc01 (net13 net69 net12 vssa) nmos1 l=180n w=1u m=1
	mpb02 (net27 net51 net158 vdda) pmos1 l=180n w=1u m=1
	mppd1 (net158 xpd vdda vdda) pmos1 l=180n w=1u m=1
	mps11 (net31 net158 vdda vdda) pmos1 l=180n w=1u m=1
	mpd11 (net56 inn net31 net31) pmos1 l=180n w=1u m=1
	mp001 (out net158 vdda vdda) pmos1 l=180n w=1u m=1
	mpd12 (net13 inp net31 net31) pmos1 l=2.3e-07n w=7.0e-07u m=1
	mpb01 (net158 net158 vdda vdda) pmos1 l=1.2e-07n w=1.8e-06u m=1
ends OPAMP1_variant734

subckt OPAMP1_variant735 inn inp out pd xpd vdda vssa
	xd1 (vssa vdda) prim_nwd AREA=6.13907e-9 PJ=476.6e-6 m=1
	xi0 (vssa net69) prim_nd AREA=1e-12 PJ=4e-6 m=1
	xi3 (net51 vdda) prim_pd AREA=790e-15 PJ=3.3e-6 m=1
	xr0 (vssa vdda net51) prim_rdiffp l=2.1e-6 w=700e-9 m=1
	xr1 (vdda vdda net69) prim_rdiffp l=2.1e-6 w=700e-9 m=1
	xcc01 (net12 out) prim_cpoly c=1p m=1
	mnm12 (net13 net56 vssa vssa) nmos1 l=180n w=1u m=1
	mnm11 (net56 net56 vssa vssa) nmos1 l=180n w=1u m=1
	mnb02 (net27 net27 net21 vssa) nmos1 l=2.1e-07n w=6.7e-07u m=1
	mnpd1 (net21 xpd vssa vssa) nmos1 l=180n w=1u m=1
	mn001 (out net13 vssa vssa) nmos1 l=180n w=1u m=1
	mnpd2 (net13 pd vssa vssa) nmos1 l=180n w=1u m=1
	mnc01 (net13 net69 net12 vssa) nmos1 l=180n w=1u m=1
	mpb02 (net27 net51 net158 vdda) pmos1 l=1.9e-07n w=5.9e-07u m=1
	mppd1 (net158 xpd vdda vdda) pmos1 l=1.9e-07n w=6.6e-07u m=1
	mps11 (net31 net158 vdda vdda) pmos1 l=180n w=1u m=1
	mpd11 (net56 inn net31 net31) pmos1 l=180n w=1u m=1
	mp001 (out net158 vdda vdda) pmos1 l=180n w=1u m=1
	mpd12 (net13 inp net31 net31) pmos1 l=180n w=1u m=1
	mpb01 (net158 net158 vdda vdda) pmos1 l=180n w=1u m=1
ends OPAMP1_variant735

subckt OPAMP1_variant736 inn inp out pd xpd vdda vssa
	xd1 (vssa vdda) prim_nwd AREA=4.5e-09 PJ=7.7e-05 m=1
	xi0 (vssa net69) prim_nd AREA=1e-12 PJ=4e-6 m=1
	xi3 (net51 vdda) prim_pd AREA=790e-15 PJ=3.3e-6 m=1
	xr0 (vssa vdda net51) prim_rdiffp l=2.1e-6 w=700e-9 m=1
	xr1 (vdda vdda net69) prim_rdiffp l=2.1e-6 w=700e-9 m=1
	xcc01 (net12 out) prim_cpoly c=1p m=1
	mnm12 (net13 net56 vssa vssa) nmos1 l=180n w=1u m=1
	mnm11 (net56 net56 vssa vssa) nmos1 l=2.4e-07n w=6.0e-07u m=1
	mnb02 (net27 net27 net21 vssa) nmos1 l=180n w=1u m=1
	mnpd1 (net21 xpd vssa vssa) nmos1 l=1.7e-07n w=1.9e-06u m=1
	mn001 (out net13 vssa vssa) nmos1 l=180n w=1u m=1
	mnpd2 (net13 pd vssa vssa) nmos1 l=180n w=1u m=1
	mnc01 (net13 net69 net12 vssa) nmos1 l=180n w=1u m=1
	mpb02 (net27 net51 net158 vdda) pmos1 l=180n w=1u m=1
	mppd1 (net158 xpd vdda vdda) pmos1 l=180n w=1u m=1
	mps11 (net31 net158 vdda vdda) pmos1 l=1.5e-07n w=1.3e-06u m=1
	mpd11 (net56 inn net31 net31) pmos1 l=1.0e-07n w=1.8e-06u m=1
	mp001 (out net158 vdda vdda) pmos1 l=180n w=1u m=1
	mpd12 (net13 inp net31 net31) pmos1 l=180n w=1u m=1
	mpb01 (net158 net158 vdda vdda) pmos1 l=180n w=1u m=1
ends OPAMP1_variant736

subckt OPAMP1_variant737 inn inp out pd xpd vdda vssa
	xd1 (vssa vdda) prim_nwd AREA=6.13907e-9 PJ=476.6e-6 m=1
	xi0 (vssa net69) prim_nd AREA=1e-12 PJ=4e-6 m=1
	xi3 (net51 vdda) prim_pd AREA=790e-15 PJ=3.3e-6 m=1
	xr0 (vssa vdda net51) prim_rdiffp l=2.1e-6 w=700e-9 m=1
	xr1 (vdda vdda net69) prim_rdiffp l=2.1e-6 w=700e-9 m=1
	xcc01 (net12 out) prim_cpoly c=1p m=1
	mnm12 (net13 net56 vssa vssa) nmos1 l=180n w=1u m=1
	mnm11 (net56 net56 vssa vssa) nmos1 l=180n w=1u m=1
	mnb02 (net27 net27 net21 vssa) nmos1 l=180n w=1u m=1
	mnpd1 (net21 xpd vssa vssa) nmos1 l=180n w=1u m=1
	mn001 (out net13 vssa vssa) nmos1 l=180n w=1u m=1
	mnpd2 (net13 pd vssa vssa) nmos1 l=180n w=1u m=1
	mnc01 (net13 net69 net12 vssa) nmos1 l=180n w=1u m=1
	mpb02 (net27 net51 net158 vdda) pmos1 l=2.0e-07n w=8.6e-07u m=1
	mppd1 (net158 xpd vdda vdda) pmos1 l=1.8e-07n w=2.0e-06u m=1
	mps11 (net31 net158 vdda vdda) pmos1 l=1.8e-07n w=1.4e-06u m=1
	mpd11 (net56 inn net31 net31) pmos1 l=2.9e-07n w=6.6e-07u m=1
	mp001 (out net158 vdda vdda) pmos1 l=1.4e-07n w=1.1e-06u m=1
	mpd12 (net13 inp net31 net31) pmos1 l=180n w=1u m=1
	mpb01 (net158 net158 vdda vdda) pmos1 l=180n w=1u m=1
ends OPAMP1_variant737

subckt OPAMP1_variant738 inn inp out pd xpd vdda vssa
	xd1 (vssa vdda) prim_nwd AREA=6.13907e-9 PJ=476.6e-6 m=1
	xi0 (vssa net69) prim_nd AREA=1e-12 PJ=4e-6 m=1
	xi3 (net51 vdda) prim_pd AREA=790e-15 PJ=3.3e-6 m=1
	xr0 (vssa vdda net51) prim_rdiffp l=2.6e-07 w=1.3e-06 m=1
	xr1 (vdda vdda net69) prim_rdiffp l=2.1e-6 w=700e-9 m=1
	xcc01 (net12 out) prim_cpoly c=1p m=1
	mnm12 (net13 net56 vssa vssa) nmos1 l=180n w=1u m=1
	mnm11 (net56 net56 vssa vssa) nmos1 l=1.8e-07n w=7.9e-07u m=1
	mnb02 (net27 net27 net21 vssa) nmos1 l=180n w=1u m=1
	mnpd1 (net21 xpd vssa vssa) nmos1 l=180n w=1u m=1
	mn001 (out net13 vssa vssa) nmos1 l=2.0e-07n w=9.4e-07u m=1
	mnpd2 (net13 pd vssa vssa) nmos1 l=180n w=1u m=1
	mnc01 (net13 net69 net12 vssa) nmos1 l=180n w=1u m=1
	mpb02 (net27 net51 net158 vdda) pmos1 l=2.0e-07n w=1.5e-06u m=1
	mppd1 (net158 xpd vdda vdda) pmos1 l=180n w=1u m=1
	mps11 (net31 net158 vdda vdda) pmos1 l=180n w=1u m=1
	mpd11 (net56 inn net31 net31) pmos1 l=2.2e-07n w=1.4e-06u m=1
	mp001 (out net158 vdda vdda) pmos1 l=180n w=1u m=1
	mpd12 (net13 inp net31 net31) pmos1 l=180n w=1u m=1
	mpb01 (net158 net158 vdda vdda) pmos1 l=180n w=1u m=1
ends OPAMP1_variant738

subckt OPAMP1_variant739 inn inp out pd xpd vdda vssa
	xd1 (vssa vdda) prim_nwd AREA=6.13907e-9 PJ=476.6e-6 m=1
	xi0 (vssa net69) prim_nd AREA=1e-12 PJ=4e-6 m=1
	xi3 (net51 vdda) prim_pd AREA=790e-15 PJ=3.3e-6 m=1
	xr0 (vssa vdda net51) prim_rdiffp l=2.2e-07 w=8.0e-07 m=1
	xr1 (vdda vdda net69) prim_rdiffp l=2.1e-6 w=700e-9 m=1
	xcc01 (net12 out) prim_cpoly c=1p m=1
	mnm12 (net13 net56 vssa vssa) nmos1 l=180n w=1u m=1
	mnm11 (net56 net56 vssa vssa) nmos1 l=180n w=1u m=1
	mnb02 (net27 net27 net21 vssa) nmos1 l=2.9e-07n w=6.9e-07u m=1
	mnpd1 (net21 xpd vssa vssa) nmos1 l=180n w=1u m=1
	mn001 (out net13 vssa vssa) nmos1 l=180n w=1u m=1
	mnpd2 (net13 pd vssa vssa) nmos1 l=2.5e-07n w=1.4e-06u m=1
	mnc01 (net13 net69 net12 vssa) nmos1 l=180n w=1u m=1
	mpb02 (net27 net51 net158 vdda) pmos1 l=180n w=1u m=1
	mppd1 (net158 xpd vdda vdda) pmos1 l=180n w=1u m=1
	mps11 (net31 net158 vdda vdda) pmos1 l=180n w=1u m=1
	mpd11 (net56 inn net31 net31) pmos1 l=1.5e-07n w=1.6e-06u m=1
	mp001 (out net158 vdda vdda) pmos1 l=180n w=1u m=1
	mpd12 (net13 inp net31 net31) pmos1 l=180n w=1u m=1
	mpb01 (net158 net158 vdda vdda) pmos1 l=180n w=1u m=1
ends OPAMP1_variant739

subckt OPAMP1_variant740 inn inp out pd xpd vdda vssa
	xd1 (vssa vdda) prim_nwd AREA=6.13907e-9 PJ=476.6e-6 m=1
	xi0 (vssa net69) prim_nd AREA=1e-12 PJ=4e-6 m=1
	xi3 (net51 vdda) prim_pd AREA=790e-15 PJ=3.3e-6 m=1
	xr0 (vssa vdda net51) prim_rdiffp l=2.1e-6 w=700e-9 m=1
	xr1 (vdda vdda net69) prim_rdiffp l=2.1e-6 w=700e-9 m=1
	xcc01 (net12 out) prim_cpoly c=1p m=1
	mnm12 (net13 net56 vssa vssa) nmos1 l=180n w=1u m=1
	mnm11 (net56 net56 vssa vssa) nmos1 l=180n w=1u m=1
	mnb02 (net27 net27 net21 vssa) nmos1 l=2.4e-07n w=8.7e-07u m=1
	mnpd1 (net21 xpd vssa vssa) nmos1 l=180n w=1u m=1
	mn001 (out net13 vssa vssa) nmos1 l=180n w=1u m=1
	mnpd2 (net13 pd vssa vssa) nmos1 l=180n w=1u m=1
	mnc01 (net13 net69 net12 vssa) nmos1 l=180n w=1u m=1
	mpb02 (net27 net51 net158 vdda) pmos1 l=2.2e-07n w=1.5e-06u m=1
	mppd1 (net158 xpd vdda vdda) pmos1 l=1.2e-07n w=1.0e-06u m=1
	mps11 (net31 net158 vdda vdda) pmos1 l=180n w=1u m=1
	mpd11 (net56 inn net31 net31) pmos1 l=180n w=1u m=1
	mp001 (out net158 vdda vdda) pmos1 l=180n w=1u m=1
	mpd12 (net13 inp net31 net31) pmos1 l=180n w=1u m=1
	mpb01 (net158 net158 vdda vdda) pmos1 l=180n w=1u m=1
ends OPAMP1_variant740

subckt OPAMP1_variant741 inn inp out pd xpd vdda vssa
	xd1 (vssa vdda) prim_nwd AREA=6.13907e-9 PJ=476.6e-6 m=1
	xi0 (vssa net69) prim_nd AREA=1e-12 PJ=4e-6 m=1
	xi3 (net51 vdda) prim_pd AREA=790e-15 PJ=3.3e-6 m=1
	xr0 (vssa vdda net51) prim_rdiffp l=1.4e-07 w=1.1e-06 m=1
	xr1 (vdda vdda net69) prim_rdiffp l=2.1e-6 w=700e-9 m=1
	xcc01 (net12 out) prim_cpoly c=1p m=1
	mnm12 (net13 net56 vssa vssa) nmos1 l=1.4e-07n w=1.4e-06u m=1
	mnm11 (net56 net56 vssa vssa) nmos1 l=180n w=1u m=1
	mnb02 (net27 net27 net21 vssa) nmos1 l=180n w=1u m=1
	mnpd1 (net21 xpd vssa vssa) nmos1 l=180n w=1u m=1
	mn001 (out net13 vssa vssa) nmos1 l=180n w=1u m=1
	mnpd2 (net13 pd vssa vssa) nmos1 l=180n w=1u m=1
	mnc01 (net13 net69 net12 vssa) nmos1 l=180n w=1u m=1
	mpb02 (net27 net51 net158 vdda) pmos1 l=180n w=1u m=1
	mppd1 (net158 xpd vdda vdda) pmos1 l=180n w=1u m=1
	mps11 (net31 net158 vdda vdda) pmos1 l=2.7e-07n w=1.4e-06u m=1
	mpd11 (net56 inn net31 net31) pmos1 l=180n w=1u m=1
	mp001 (out net158 vdda vdda) pmos1 l=180n w=1u m=1
	mpd12 (net13 inp net31 net31) pmos1 l=180n w=1u m=1
	mpb01 (net158 net158 vdda vdda) pmos1 l=180n w=1u m=1
ends OPAMP1_variant741

subckt OPAMP1_variant742 inn inp out pd xpd vdda vssa
	xd1 (vssa vdda) prim_nwd AREA=6.13907e-9 PJ=476.6e-6 m=1
	xi0 (vssa net69) prim_nd AREA=1e-12 PJ=4e-6 m=1
	xi3 (net51 vdda) prim_pd AREA=790e-15 PJ=3.3e-6 m=1
	xr0 (vssa vdda net51) prim_rdiffp l=3.0e-07 w=9.6e-07 m=1
	xr1 (vdda vdda net69) prim_rdiffp l=2.1e-6 w=700e-9 m=1
	xcc01 (net12 out) prim_cpoly c=1p m=1
	mnm12 (net13 net56 vssa vssa) nmos1 l=180n w=1u m=1
	mnm11 (net56 net56 vssa vssa) nmos1 l=180n w=1u m=1
	mnb02 (net27 net27 net21 vssa) nmos1 l=180n w=1u m=1
	mnpd1 (net21 xpd vssa vssa) nmos1 l=180n w=1u m=1
	mn001 (out net13 vssa vssa) nmos1 l=3.0e-07n w=9.4e-07u m=1
	mnpd2 (net13 pd vssa vssa) nmos1 l=180n w=1u m=1
	mnc01 (net13 net69 net12 vssa) nmos1 l=1.7e-07n w=1.5e-06u m=1
	mpb02 (net27 net51 net158 vdda) pmos1 l=180n w=1u m=1
	mppd1 (net158 xpd vdda vdda) pmos1 l=180n w=1u m=1
	mps11 (net31 net158 vdda vdda) pmos1 l=180n w=1u m=1
	mpd11 (net56 inn net31 net31) pmos1 l=180n w=1u m=1
	mp001 (out net158 vdda vdda) pmos1 l=180n w=1u m=1
	mpd12 (net13 inp net31 net31) pmos1 l=180n w=1u m=1
	mpb01 (net158 net158 vdda vdda) pmos1 l=180n w=1u m=1
ends OPAMP1_variant742

subckt OPAMP1_variant743 inn inp out pd xpd vdda vssa
	xd1 (vssa vdda) prim_nwd AREA=7.8e-09 PJ=9.1e-05 m=1
	xi0 (vssa net69) prim_nd AREA=1e-12 PJ=4e-6 m=1
	xi3 (net51 vdda) prim_pd AREA=790e-15 PJ=3.3e-6 m=1
	xr0 (vssa vdda net51) prim_rdiffp l=2.1e-6 w=700e-9 m=1
	xr1 (vdda vdda net69) prim_rdiffp l=1.2e-07 w=8.1e-07 m=1
	xcc01 (net12 out) prim_cpoly c=1p m=1
	mnm12 (net13 net56 vssa vssa) nmos1 l=180n w=1u m=1
	mnm11 (net56 net56 vssa vssa) nmos1 l=180n w=1u m=1
	mnb02 (net27 net27 net21 vssa) nmos1 l=180n w=1u m=1
	mnpd1 (net21 xpd vssa vssa) nmos1 l=180n w=1u m=1
	mn001 (out net13 vssa vssa) nmos1 l=180n w=1u m=1
	mnpd2 (net13 pd vssa vssa) nmos1 l=180n w=1u m=1
	mnc01 (net13 net69 net12 vssa) nmos1 l=180n w=1u m=1
	mpb02 (net27 net51 net158 vdda) pmos1 l=180n w=1u m=1
	mppd1 (net158 xpd vdda vdda) pmos1 l=180n w=1u m=1
	mps11 (net31 net158 vdda vdda) pmos1 l=180n w=1u m=1
	mpd11 (net56 inn net31 net31) pmos1 l=180n w=1u m=1
	mp001 (out net158 vdda vdda) pmos1 l=180n w=1u m=1
	mpd12 (net13 inp net31 net31) pmos1 l=1.0e-07n w=2.0e-06u m=1
	mpb01 (net158 net158 vdda vdda) pmos1 l=180n w=1u m=1
ends OPAMP1_variant743

subckt OPAMP1_variant744 inn inp out pd xpd vdda vssa
	xd1 (vssa vdda) prim_nwd AREA=6.13907e-9 PJ=476.6e-6 m=1
	xi0 (vssa net69) prim_nd AREA=1e-12 PJ=4e-6 m=1
	xi3 (net51 vdda) prim_pd AREA=790e-15 PJ=3.3e-6 m=1
	xr0 (vssa vdda net51) prim_rdiffp l=2.2e-07 w=6.8e-07 m=1
	xr1 (vdda vdda net69) prim_rdiffp l=2.1e-6 w=700e-9 m=1
	xcc01 (net12 out) prim_cpoly c=1p m=1
	mnm12 (net13 net56 vssa vssa) nmos1 l=180n w=1u m=1
	mnm11 (net56 net56 vssa vssa) nmos1 l=180n w=1u m=1
	mnb02 (net27 net27 net21 vssa) nmos1 l=1.6e-07n w=1.4e-06u m=1
	mnpd1 (net21 xpd vssa vssa) nmos1 l=180n w=1u m=1
	mn001 (out net13 vssa vssa) nmos1 l=180n w=1u m=1
	mnpd2 (net13 pd vssa vssa) nmos1 l=180n w=1u m=1
	mnc01 (net13 net69 net12 vssa) nmos1 l=180n w=1u m=1
	mpb02 (net27 net51 net158 vdda) pmos1 l=180n w=1u m=1
	mppd1 (net158 xpd vdda vdda) pmos1 l=180n w=1u m=1
	mps11 (net31 net158 vdda vdda) pmos1 l=180n w=1u m=1
	mpd11 (net56 inn net31 net31) pmos1 l=180n w=1u m=1
	mp001 (out net158 vdda vdda) pmos1 l=180n w=1u m=1
	mpd12 (net13 inp net31 net31) pmos1 l=180n w=1u m=1
	mpb01 (net158 net158 vdda vdda) pmos1 l=180n w=1u m=1
ends OPAMP1_variant744

subckt OPAMP1_variant745 inn inp out pd xpd vdda vssa
	xd1 (vssa vdda) prim_nwd AREA=6.13907e-9 PJ=476.6e-6 m=1
	xi0 (vssa net69) prim_nd AREA=1e-12 PJ=4e-6 m=1
	xi3 (net51 vdda) prim_pd AREA=8.7e-09 PJ=8.5e-06 m=1
	xr0 (vssa vdda net51) prim_rdiffp l=2.1e-6 w=700e-9 m=1
	xr1 (vdda vdda net69) prim_rdiffp l=2.1e-6 w=700e-9 m=1
	xcc01 (net12 out) prim_cpoly c=1p m=1
	mnm12 (net13 net56 vssa vssa) nmos1 l=180n w=1u m=1
	mnm11 (net56 net56 vssa vssa) nmos1 l=1.1e-07n w=8.8e-07u m=1
	mnb02 (net27 net27 net21 vssa) nmos1 l=180n w=1u m=1
	mnpd1 (net21 xpd vssa vssa) nmos1 l=2.5e-07n w=2.0e-06u m=1
	mn001 (out net13 vssa vssa) nmos1 l=180n w=1u m=1
	mnpd2 (net13 pd vssa vssa) nmos1 l=180n w=1u m=1
	mnc01 (net13 net69 net12 vssa) nmos1 l=180n w=1u m=1
	mpb02 (net27 net51 net158 vdda) pmos1 l=180n w=1u m=1
	mppd1 (net158 xpd vdda vdda) pmos1 l=180n w=1u m=1
	mps11 (net31 net158 vdda vdda) pmos1 l=1.1e-07n w=1.0e-06u m=1
	mpd11 (net56 inn net31 net31) pmos1 l=180n w=1u m=1
	mp001 (out net158 vdda vdda) pmos1 l=180n w=1u m=1
	mpd12 (net13 inp net31 net31) pmos1 l=180n w=1u m=1
	mpb01 (net158 net158 vdda vdda) pmos1 l=180n w=1u m=1
ends OPAMP1_variant745

subckt OPAMP1_variant746 inn inp out pd xpd vdda vssa
	xd1 (vssa vdda) prim_nwd AREA=6.13907e-9 PJ=476.6e-6 m=1
	xi0 (vssa net69) prim_nd AREA=2.7e-09 PJ=5.7e-05 m=1
	xi3 (net51 vdda) prim_pd AREA=790e-15 PJ=3.3e-6 m=1
	xr0 (vssa vdda net51) prim_rdiffp l=2.1e-6 w=700e-9 m=1
	xr1 (vdda vdda net69) prim_rdiffp l=2.7e-07 w=7.1e-07 m=1
	xcc01 (net12 out) prim_cpoly c=1p m=1
	mnm12 (net13 net56 vssa vssa) nmos1 l=180n w=1u m=1
	mnm11 (net56 net56 vssa vssa) nmos1 l=180n w=1u m=1
	mnb02 (net27 net27 net21 vssa) nmos1 l=180n w=1u m=1
	mnpd1 (net21 xpd vssa vssa) nmos1 l=180n w=1u m=1
	mn001 (out net13 vssa vssa) nmos1 l=180n w=1u m=1
	mnpd2 (net13 pd vssa vssa) nmos1 l=180n w=1u m=1
	mnc01 (net13 net69 net12 vssa) nmos1 l=180n w=1u m=1
	mpb02 (net27 net51 net158 vdda) pmos1 l=180n w=1u m=1
	mppd1 (net158 xpd vdda vdda) pmos1 l=180n w=1u m=1
	mps11 (net31 net158 vdda vdda) pmos1 l=180n w=1u m=1
	mpd11 (net56 inn net31 net31) pmos1 l=180n w=1u m=1
	mp001 (out net158 vdda vdda) pmos1 l=180n w=1u m=1
	mpd12 (net13 inp net31 net31) pmos1 l=180n w=1u m=1
	mpb01 (net158 net158 vdda vdda) pmos1 l=180n w=1u m=1
ends OPAMP1_variant746

subckt OPAMP1_variant747 inn inp out pd xpd vdda vssa
	xd1 (vssa vdda) prim_nwd AREA=6.13907e-9 PJ=476.6e-6 m=1
	xi0 (vssa net69) prim_nd AREA=1e-12 PJ=4e-6 m=1
	xi3 (net51 vdda) prim_pd AREA=6.7e-09 PJ=9.9e-05 m=1
	xr0 (vssa vdda net51) prim_rdiffp l=2.1e-6 w=700e-9 m=1
	xr1 (vdda vdda net69) prim_rdiffp l=2.1e-6 w=700e-9 m=1
	xcc01 (net12 out) prim_cpoly c=1p m=1
	mnm12 (net13 net56 vssa vssa) nmos1 l=180n w=1u m=1
	mnm11 (net56 net56 vssa vssa) nmos1 l=2.2e-07n w=1.9e-06u m=1
	mnb02 (net27 net27 net21 vssa) nmos1 l=180n w=1u m=1
	mnpd1 (net21 xpd vssa vssa) nmos1 l=180n w=1u m=1
	mn001 (out net13 vssa vssa) nmos1 l=180n w=1u m=1
	mnpd2 (net13 pd vssa vssa) nmos1 l=1.5e-07n w=1.6e-06u m=1
	mnc01 (net13 net69 net12 vssa) nmos1 l=180n w=1u m=1
	mpb02 (net27 net51 net158 vdda) pmos1 l=180n w=1u m=1
	mppd1 (net158 xpd vdda vdda) pmos1 l=1.5e-07n w=1.3e-06u m=1
	mps11 (net31 net158 vdda vdda) pmos1 l=180n w=1u m=1
	mpd11 (net56 inn net31 net31) pmos1 l=180n w=1u m=1
	mp001 (out net158 vdda vdda) pmos1 l=1.4e-07n w=1.3e-06u m=1
	mpd12 (net13 inp net31 net31) pmos1 l=180n w=1u m=1
	mpb01 (net158 net158 vdda vdda) pmos1 l=180n w=1u m=1
ends OPAMP1_variant747

subckt OPAMP1_variant748 inn inp out pd xpd vdda vssa
	xd1 (vssa vdda) prim_nwd AREA=5.5e-09 PJ=7.9e-05 m=1
	xi0 (vssa net69) prim_nd AREA=1e-12 PJ=4e-6 m=1
	xi3 (net51 vdda) prim_pd AREA=790e-15 PJ=3.3e-6 m=1
	xr0 (vssa vdda net51) prim_rdiffp l=2.1e-07 w=1.1e-06 m=1
	xr1 (vdda vdda net69) prim_rdiffp l=2.1e-6 w=700e-9 m=1
	xcc01 (net12 out) prim_cpoly c=1p m=1
	mnm12 (net13 net56 vssa vssa) nmos1 l=180n w=1u m=1
	mnm11 (net56 net56 vssa vssa) nmos1 l=180n w=1u m=1
	mnb02 (net27 net27 net21 vssa) nmos1 l=180n w=1u m=1
	mnpd1 (net21 xpd vssa vssa) nmos1 l=180n w=1u m=1
	mn001 (out net13 vssa vssa) nmos1 l=180n w=1u m=1
	mnpd2 (net13 pd vssa vssa) nmos1 l=180n w=1u m=1
	mnc01 (net13 net69 net12 vssa) nmos1 l=180n w=1u m=1
	mpb02 (net27 net51 net158 vdda) pmos1 l=180n w=1u m=1
	mppd1 (net158 xpd vdda vdda) pmos1 l=180n w=1u m=1
	mps11 (net31 net158 vdda vdda) pmos1 l=180n w=1u m=1
	mpd11 (net56 inn net31 net31) pmos1 l=180n w=1u m=1
	mp001 (out net158 vdda vdda) pmos1 l=180n w=1u m=1
	mpd12 (net13 inp net31 net31) pmos1 l=180n w=1u m=1
	mpb01 (net158 net158 vdda vdda) pmos1 l=180n w=1u m=1
ends OPAMP1_variant748

subckt OPAMP1_variant749 inn inp out pd xpd vdda vssa
	xd1 (vssa vdda) prim_nwd AREA=6.13907e-9 PJ=476.6e-6 m=1
	xi0 (vssa net69) prim_nd AREA=1e-12 PJ=4e-6 m=1
	xi3 (net51 vdda) prim_pd AREA=790e-15 PJ=3.3e-6 m=1
	xr0 (vssa vdda net51) prim_rdiffp l=2.1e-6 w=700e-9 m=1
	xr1 (vdda vdda net69) prim_rdiffp l=1.4e-07 w=5.2e-07 m=1
	xcc01 (net12 out) prim_cpoly c=1.7e-12p m=1
	mnm12 (net13 net56 vssa vssa) nmos1 l=180n w=1u m=1
	mnm11 (net56 net56 vssa vssa) nmos1 l=180n w=1u m=1
	mnb02 (net27 net27 net21 vssa) nmos1 l=180n w=1u m=1
	mnpd1 (net21 xpd vssa vssa) nmos1 l=180n w=1u m=1
	mn001 (out net13 vssa vssa) nmos1 l=180n w=1u m=1
	mnpd2 (net13 pd vssa vssa) nmos1 l=180n w=1u m=1
	mnc01 (net13 net69 net12 vssa) nmos1 l=180n w=1u m=1
	mpb02 (net27 net51 net158 vdda) pmos1 l=180n w=1u m=1
	mppd1 (net158 xpd vdda vdda) pmos1 l=180n w=1u m=1
	mps11 (net31 net158 vdda vdda) pmos1 l=1.3e-07n w=1.2e-06u m=1
	mpd11 (net56 inn net31 net31) pmos1 l=180n w=1u m=1
	mp001 (out net158 vdda vdda) pmos1 l=180n w=1u m=1
	mpd12 (net13 inp net31 net31) pmos1 l=2.1e-07n w=8.9e-07u m=1
	mpb01 (net158 net158 vdda vdda) pmos1 l=180n w=1u m=1
ends OPAMP1_variant749

subckt OPAMP1_variant750 inn inp out pd xpd vdda vssa
	xd1 (vssa vdda) prim_nwd AREA=6.13907e-9 PJ=476.6e-6 m=1
	xi0 (vssa net69) prim_nd AREA=1e-12 PJ=4e-6 m=1
	xi3 (net51 vdda) prim_pd AREA=790e-15 PJ=3.3e-6 m=1
	xr0 (vssa vdda net51) prim_rdiffp l=2.1e-6 w=700e-9 m=1
	xr1 (vdda vdda net69) prim_rdiffp l=2.1e-6 w=700e-9 m=1
	xcc01 (net12 out) prim_cpoly c=1p m=1
	mnm12 (net13 net56 vssa vssa) nmos1 l=180n w=1u m=1
	mnm11 (net56 net56 vssa vssa) nmos1 l=180n w=1u m=1
	mnb02 (net27 net27 net21 vssa) nmos1 l=1.9e-07n w=2.0e-06u m=1
	mnpd1 (net21 xpd vssa vssa) nmos1 l=1.7e-07n w=7.9e-07u m=1
	mn001 (out net13 vssa vssa) nmos1 l=180n w=1u m=1
	mnpd2 (net13 pd vssa vssa) nmos1 l=1.8e-07n w=1.8e-06u m=1
	mnc01 (net13 net69 net12 vssa) nmos1 l=180n w=1u m=1
	mpb02 (net27 net51 net158 vdda) pmos1 l=180n w=1u m=1
	mppd1 (net158 xpd vdda vdda) pmos1 l=180n w=1u m=1
	mps11 (net31 net158 vdda vdda) pmos1 l=180n w=1u m=1
	mpd11 (net56 inn net31 net31) pmos1 l=180n w=1u m=1
	mp001 (out net158 vdda vdda) pmos1 l=180n w=1u m=1
	mpd12 (net13 inp net31 net31) pmos1 l=180n w=1u m=1
	mpb01 (net158 net158 vdda vdda) pmos1 l=180n w=1u m=1
ends OPAMP1_variant750

subckt OPAMP1_variant751 inn inp out pd xpd vdda vssa
	xd1 (vssa vdda) prim_nwd AREA=6.13907e-9 PJ=476.6e-6 m=1
	xi0 (vssa net69) prim_nd AREA=1e-12 PJ=4e-6 m=1
	xi3 (net51 vdda) prim_pd AREA=790e-15 PJ=3.3e-6 m=1
	xr0 (vssa vdda net51) prim_rdiffp l=2.1e-6 w=700e-9 m=1
	xr1 (vdda vdda net69) prim_rdiffp l=2.1e-6 w=700e-9 m=1
	xcc01 (net12 out) prim_cpoly c=1p m=1
	mnm12 (net13 net56 vssa vssa) nmos1 l=180n w=1u m=1
	mnm11 (net56 net56 vssa vssa) nmos1 l=180n w=1u m=1
	mnb02 (net27 net27 net21 vssa) nmos1 l=180n w=1u m=1
	mnpd1 (net21 xpd vssa vssa) nmos1 l=180n w=1u m=1
	mn001 (out net13 vssa vssa) nmos1 l=180n w=1u m=1
	mnpd2 (net13 pd vssa vssa) nmos1 l=180n w=1u m=1
	mnc01 (net13 net69 net12 vssa) nmos1 l=180n w=1u m=1
	mpb02 (net27 net51 net158 vdda) pmos1 l=180n w=1u m=1
	mppd1 (net158 xpd vdda vdda) pmos1 l=180n w=1u m=1
	mps11 (net31 net158 vdda vdda) pmos1 l=1.9e-07n w=6.0e-07u m=1
	mpd11 (net56 inn net31 net31) pmos1 l=180n w=1u m=1
	mp001 (out net158 vdda vdda) pmos1 l=180n w=1u m=1
	mpd12 (net13 inp net31 net31) pmos1 l=1.1e-07n w=1.2e-06u m=1
	mpb01 (net158 net158 vdda vdda) pmos1 l=180n w=1u m=1
ends OPAMP1_variant751

subckt OPAMP1_variant752 inn inp out pd xpd vdda vssa
	xd1 (vssa vdda) prim_nwd AREA=6.13907e-9 PJ=476.6e-6 m=1
	xi0 (vssa net69) prim_nd AREA=1e-12 PJ=4e-6 m=1
	xi3 (net51 vdda) prim_pd AREA=9.2e-09 PJ=1.7e-05 m=1
	xr0 (vssa vdda net51) prim_rdiffp l=2.0e-07 w=6.8e-07 m=1
	xr1 (vdda vdda net69) prim_rdiffp l=2.1e-6 w=700e-9 m=1
	xcc01 (net12 out) prim_cpoly c=1p m=1
	mnm12 (net13 net56 vssa vssa) nmos1 l=180n w=1u m=1
	mnm11 (net56 net56 vssa vssa) nmos1 l=180n w=1u m=1
	mnb02 (net27 net27 net21 vssa) nmos1 l=180n w=1u m=1
	mnpd1 (net21 xpd vssa vssa) nmos1 l=180n w=1u m=1
	mn001 (out net13 vssa vssa) nmos1 l=180n w=1u m=1
	mnpd2 (net13 pd vssa vssa) nmos1 l=1.3e-07n w=1.0e-06u m=1
	mnc01 (net13 net69 net12 vssa) nmos1 l=180n w=1u m=1
	mpb02 (net27 net51 net158 vdda) pmos1 l=180n w=1u m=1
	mppd1 (net158 xpd vdda vdda) pmos1 l=2.9e-07n w=1.7e-06u m=1
	mps11 (net31 net158 vdda vdda) pmos1 l=180n w=1u m=1
	mpd11 (net56 inn net31 net31) pmos1 l=180n w=1u m=1
	mp001 (out net158 vdda vdda) pmos1 l=180n w=1u m=1
	mpd12 (net13 inp net31 net31) pmos1 l=180n w=1u m=1
	mpb01 (net158 net158 vdda vdda) pmos1 l=2.8e-07n w=1.8e-06u m=1
ends OPAMP1_variant752

subckt OPAMP1_variant753 inn inp out pd xpd vdda vssa
	xd1 (vssa vdda) prim_nwd AREA=6.13907e-9 PJ=476.6e-6 m=1
	xi0 (vssa net69) prim_nd AREA=1.1e-09 PJ=1.7e-05 m=1
	xi3 (net51 vdda) prim_pd AREA=790e-15 PJ=3.3e-6 m=1
	xr0 (vssa vdda net51) prim_rdiffp l=2.9e-07 w=6.9e-07 m=1
	xr1 (vdda vdda net69) prim_rdiffp l=2.1e-6 w=700e-9 m=1
	xcc01 (net12 out) prim_cpoly c=1p m=1
	mnm12 (net13 net56 vssa vssa) nmos1 l=1.0e-07n w=8.4e-07u m=1
	mnm11 (net56 net56 vssa vssa) nmos1 l=180n w=1u m=1
	mnb02 (net27 net27 net21 vssa) nmos1 l=180n w=1u m=1
	mnpd1 (net21 xpd vssa vssa) nmos1 l=180n w=1u m=1
	mn001 (out net13 vssa vssa) nmos1 l=180n w=1u m=1
	mnpd2 (net13 pd vssa vssa) nmos1 l=180n w=1u m=1
	mnc01 (net13 net69 net12 vssa) nmos1 l=180n w=1u m=1
	mpb02 (net27 net51 net158 vdda) pmos1 l=180n w=1u m=1
	mppd1 (net158 xpd vdda vdda) pmos1 l=180n w=1u m=1
	mps11 (net31 net158 vdda vdda) pmos1 l=180n w=1u m=1
	mpd11 (net56 inn net31 net31) pmos1 l=180n w=1u m=1
	mp001 (out net158 vdda vdda) pmos1 l=180n w=1u m=1
	mpd12 (net13 inp net31 net31) pmos1 l=180n w=1u m=1
	mpb01 (net158 net158 vdda vdda) pmos1 l=180n w=1u m=1
ends OPAMP1_variant753

subckt OPAMP1_variant754 inn inp out pd xpd vdda vssa
	xd1 (vssa vdda) prim_nwd AREA=2.7e-09 PJ=5.1e-05 m=1
	xi0 (vssa net69) prim_nd AREA=1e-12 PJ=4e-6 m=1
	xi3 (net51 vdda) prim_pd AREA=790e-15 PJ=3.3e-6 m=1
	xr0 (vssa vdda net51) prim_rdiffp l=2.1e-6 w=700e-9 m=1
	xr1 (vdda vdda net69) prim_rdiffp l=1.8e-07 w=7.5e-07 m=1
	xcc01 (net12 out) prim_cpoly c=1p m=1
	mnm12 (net13 net56 vssa vssa) nmos1 l=180n w=1u m=1
	mnm11 (net56 net56 vssa vssa) nmos1 l=180n w=1u m=1
	mnb02 (net27 net27 net21 vssa) nmos1 l=180n w=1u m=1
	mnpd1 (net21 xpd vssa vssa) nmos1 l=180n w=1u m=1
	mn001 (out net13 vssa vssa) nmos1 l=180n w=1u m=1
	mnpd2 (net13 pd vssa vssa) nmos1 l=180n w=1u m=1
	mnc01 (net13 net69 net12 vssa) nmos1 l=180n w=1u m=1
	mpb02 (net27 net51 net158 vdda) pmos1 l=180n w=1u m=1
	mppd1 (net158 xpd vdda vdda) pmos1 l=180n w=1u m=1
	mps11 (net31 net158 vdda vdda) pmos1 l=180n w=1u m=1
	mpd11 (net56 inn net31 net31) pmos1 l=180n w=1u m=1
	mp001 (out net158 vdda vdda) pmos1 l=2.6e-07n w=5.2e-07u m=1
	mpd12 (net13 inp net31 net31) pmos1 l=180n w=1u m=1
	mpb01 (net158 net158 vdda vdda) pmos1 l=180n w=1u m=1
ends OPAMP1_variant754

subckt OPAMP1_variant755 inn inp out pd xpd vdda vssa
	xd1 (vssa vdda) prim_nwd AREA=1.9e-09 PJ=6.1e-06 m=1
	xi0 (vssa net69) prim_nd AREA=1e-12 PJ=4e-6 m=1
	xi3 (net51 vdda) prim_pd AREA=790e-15 PJ=3.3e-6 m=1
	xr0 (vssa vdda net51) prim_rdiffp l=2.1e-07 w=1.3e-06 m=1
	xr1 (vdda vdda net69) prim_rdiffp l=2.1e-6 w=700e-9 m=1
	xcc01 (net12 out) prim_cpoly c=1p m=1
	mnm12 (net13 net56 vssa vssa) nmos1 l=180n w=1u m=1
	mnm11 (net56 net56 vssa vssa) nmos1 l=180n w=1u m=1
	mnb02 (net27 net27 net21 vssa) nmos1 l=180n w=1u m=1
	mnpd1 (net21 xpd vssa vssa) nmos1 l=180n w=1u m=1
	mn001 (out net13 vssa vssa) nmos1 l=180n w=1u m=1
	mnpd2 (net13 pd vssa vssa) nmos1 l=180n w=1u m=1
	mnc01 (net13 net69 net12 vssa) nmos1 l=180n w=1u m=1
	mpb02 (net27 net51 net158 vdda) pmos1 l=1.5e-07n w=1.3e-06u m=1
	mppd1 (net158 xpd vdda vdda) pmos1 l=180n w=1u m=1
	mps11 (net31 net158 vdda vdda) pmos1 l=180n w=1u m=1
	mpd11 (net56 inn net31 net31) pmos1 l=2.3e-07n w=1.4e-06u m=1
	mp001 (out net158 vdda vdda) pmos1 l=180n w=1u m=1
	mpd12 (net13 inp net31 net31) pmos1 l=180n w=1u m=1
	mpb01 (net158 net158 vdda vdda) pmos1 l=180n w=1u m=1
ends OPAMP1_variant755

subckt OPAMP1_variant756 inn inp out pd xpd vdda vssa
	xd1 (vssa vdda) prim_nwd AREA=6.4e-09 PJ=4.9e-05 m=1
	xi0 (vssa net69) prim_nd AREA=1e-12 PJ=4e-6 m=1
	xi3 (net51 vdda) prim_pd AREA=5.0e-09 PJ=3.8e-05 m=1
	xr0 (vssa vdda net51) prim_rdiffp l=2.1e-6 w=700e-9 m=1
	xr1 (vdda vdda net69) prim_rdiffp l=2.1e-6 w=700e-9 m=1
	xcc01 (net12 out) prim_cpoly c=1p m=1
	mnm12 (net13 net56 vssa vssa) nmos1 l=180n w=1u m=1
	mnm11 (net56 net56 vssa vssa) nmos1 l=180n w=1u m=1
	mnb02 (net27 net27 net21 vssa) nmos1 l=180n w=1u m=1
	mnpd1 (net21 xpd vssa vssa) nmos1 l=180n w=1u m=1
	mn001 (out net13 vssa vssa) nmos1 l=180n w=1u m=1
	mnpd2 (net13 pd vssa vssa) nmos1 l=180n w=1u m=1
	mnc01 (net13 net69 net12 vssa) nmos1 l=1.6e-07n w=8.4e-07u m=1
	mpb02 (net27 net51 net158 vdda) pmos1 l=2.3e-07n w=1.6e-06u m=1
	mppd1 (net158 xpd vdda vdda) pmos1 l=180n w=1u m=1
	mps11 (net31 net158 vdda vdda) pmos1 l=180n w=1u m=1
	mpd11 (net56 inn net31 net31) pmos1 l=180n w=1u m=1
	mp001 (out net158 vdda vdda) pmos1 l=180n w=1u m=1
	mpd12 (net13 inp net31 net31) pmos1 l=180n w=1u m=1
	mpb01 (net158 net158 vdda vdda) pmos1 l=180n w=1u m=1
ends OPAMP1_variant756

subckt OPAMP1_variant757 inn inp out pd xpd vdda vssa
	xd1 (vssa vdda) prim_nwd AREA=6.13907e-9 PJ=476.6e-6 m=1
	xi0 (vssa net69) prim_nd AREA=1e-12 PJ=4e-6 m=1
	xi3 (net51 vdda) prim_pd AREA=790e-15 PJ=3.3e-6 m=1
	xr0 (vssa vdda net51) prim_rdiffp l=2.1e-6 w=700e-9 m=1
	xr1 (vdda vdda net69) prim_rdiffp l=2.1e-6 w=700e-9 m=1
	xcc01 (net12 out) prim_cpoly c=1p m=1
	mnm12 (net13 net56 vssa vssa) nmos1 l=180n w=1u m=1
	mnm11 (net56 net56 vssa vssa) nmos1 l=180n w=1u m=1
	mnb02 (net27 net27 net21 vssa) nmos1 l=2.7e-07n w=1.8e-06u m=1
	mnpd1 (net21 xpd vssa vssa) nmos1 l=180n w=1u m=1
	mn001 (out net13 vssa vssa) nmos1 l=180n w=1u m=1
	mnpd2 (net13 pd vssa vssa) nmos1 l=180n w=1u m=1
	mnc01 (net13 net69 net12 vssa) nmos1 l=1.7e-07n w=1.1e-06u m=1
	mpb02 (net27 net51 net158 vdda) pmos1 l=180n w=1u m=1
	mppd1 (net158 xpd vdda vdda) pmos1 l=180n w=1u m=1
	mps11 (net31 net158 vdda vdda) pmos1 l=180n w=1u m=1
	mpd11 (net56 inn net31 net31) pmos1 l=1.0e-07n w=1.9e-06u m=1
	mp001 (out net158 vdda vdda) pmos1 l=180n w=1u m=1
	mpd12 (net13 inp net31 net31) pmos1 l=180n w=1u m=1
	mpb01 (net158 net158 vdda vdda) pmos1 l=1.8e-07n w=6.3e-07u m=1
ends OPAMP1_variant757

subckt OPAMP1_variant758 inn inp out pd xpd vdda vssa
	xd1 (vssa vdda) prim_nwd AREA=6.13907e-9 PJ=476.6e-6 m=1
	xi0 (vssa net69) prim_nd AREA=2.2e-09 PJ=6.8e-05 m=1
	xi3 (net51 vdda) prim_pd AREA=790e-15 PJ=3.3e-6 m=1
	xr0 (vssa vdda net51) prim_rdiffp l=2.1e-6 w=700e-9 m=1
	xr1 (vdda vdda net69) prim_rdiffp l=2.1e-6 w=700e-9 m=1
	xcc01 (net12 out) prim_cpoly c=1p m=1
	mnm12 (net13 net56 vssa vssa) nmos1 l=180n w=1u m=1
	mnm11 (net56 net56 vssa vssa) nmos1 l=2.7e-07n w=1.5e-06u m=1
	mnb02 (net27 net27 net21 vssa) nmos1 l=180n w=1u m=1
	mnpd1 (net21 xpd vssa vssa) nmos1 l=180n w=1u m=1
	mn001 (out net13 vssa vssa) nmos1 l=180n w=1u m=1
	mnpd2 (net13 pd vssa vssa) nmos1 l=180n w=1u m=1
	mnc01 (net13 net69 net12 vssa) nmos1 l=180n w=1u m=1
	mpb02 (net27 net51 net158 vdda) pmos1 l=1.5e-07n w=6.0e-07u m=1
	mppd1 (net158 xpd vdda vdda) pmos1 l=180n w=1u m=1
	mps11 (net31 net158 vdda vdda) pmos1 l=180n w=1u m=1
	mpd11 (net56 inn net31 net31) pmos1 l=180n w=1u m=1
	mp001 (out net158 vdda vdda) pmos1 l=180n w=1u m=1
	mpd12 (net13 inp net31 net31) pmos1 l=3.0e-07n w=9.1e-07u m=1
	mpb01 (net158 net158 vdda vdda) pmos1 l=180n w=1u m=1
ends OPAMP1_variant758

subckt OPAMP1_variant759 inn inp out pd xpd vdda vssa
	xd1 (vssa vdda) prim_nwd AREA=6.13907e-9 PJ=476.6e-6 m=1
	xi0 (vssa net69) prim_nd AREA=4.4e-09 PJ=1.4e-05 m=1
	xi3 (net51 vdda) prim_pd AREA=790e-15 PJ=3.3e-6 m=1
	xr0 (vssa vdda net51) prim_rdiffp l=2.1e-6 w=700e-9 m=1
	xr1 (vdda vdda net69) prim_rdiffp l=2.1e-6 w=700e-9 m=1
	xcc01 (net12 out) prim_cpoly c=1p m=1
	mnm12 (net13 net56 vssa vssa) nmos1 l=180n w=1u m=1
	mnm11 (net56 net56 vssa vssa) nmos1 l=180n w=1u m=1
	mnb02 (net27 net27 net21 vssa) nmos1 l=180n w=1u m=1
	mnpd1 (net21 xpd vssa vssa) nmos1 l=180n w=1u m=1
	mn001 (out net13 vssa vssa) nmos1 l=180n w=1u m=1
	mnpd2 (net13 pd vssa vssa) nmos1 l=180n w=1u m=1
	mnc01 (net13 net69 net12 vssa) nmos1 l=180n w=1u m=1
	mpb02 (net27 net51 net158 vdda) pmos1 l=180n w=1u m=1
	mppd1 (net158 xpd vdda vdda) pmos1 l=180n w=1u m=1
	mps11 (net31 net158 vdda vdda) pmos1 l=180n w=1u m=1
	mpd11 (net56 inn net31 net31) pmos1 l=180n w=1u m=1
	mp001 (out net158 vdda vdda) pmos1 l=180n w=1u m=1
	mpd12 (net13 inp net31 net31) pmos1 l=180n w=1u m=1
	mpb01 (net158 net158 vdda vdda) pmos1 l=1.8e-07n w=1.3e-06u m=1
ends OPAMP1_variant759

subckt OPAMP1_variant760 inn inp out pd xpd vdda vssa
	xd1 (vssa vdda) prim_nwd AREA=4.7e-09 PJ=2.5e-05 m=1
	xi0 (vssa net69) prim_nd AREA=1e-12 PJ=4e-6 m=1
	xi3 (net51 vdda) prim_pd AREA=790e-15 PJ=3.3e-6 m=1
	xr0 (vssa vdda net51) prim_rdiffp l=2.1e-6 w=700e-9 m=1
	xr1 (vdda vdda net69) prim_rdiffp l=2.1e-6 w=700e-9 m=1
	xcc01 (net12 out) prim_cpoly c=6.8e-13p m=1
	mnm12 (net13 net56 vssa vssa) nmos1 l=180n w=1u m=1
	mnm11 (net56 net56 vssa vssa) nmos1 l=1.4e-07n w=1.1e-06u m=1
	mnb02 (net27 net27 net21 vssa) nmos1 l=180n w=1u m=1
	mnpd1 (net21 xpd vssa vssa) nmos1 l=180n w=1u m=1
	mn001 (out net13 vssa vssa) nmos1 l=1.6e-07n w=8.7e-07u m=1
	mnpd2 (net13 pd vssa vssa) nmos1 l=180n w=1u m=1
	mnc01 (net13 net69 net12 vssa) nmos1 l=180n w=1u m=1
	mpb02 (net27 net51 net158 vdda) pmos1 l=180n w=1u m=1
	mppd1 (net158 xpd vdda vdda) pmos1 l=180n w=1u m=1
	mps11 (net31 net158 vdda vdda) pmos1 l=180n w=1u m=1
	mpd11 (net56 inn net31 net31) pmos1 l=180n w=1u m=1
	mp001 (out net158 vdda vdda) pmos1 l=180n w=1u m=1
	mpd12 (net13 inp net31 net31) pmos1 l=180n w=1u m=1
	mpb01 (net158 net158 vdda vdda) pmos1 l=180n w=1u m=1
ends OPAMP1_variant760

subckt OPAMP1_variant761 inn inp out pd xpd vdda vssa
	xd1 (vssa vdda) prim_nwd AREA=6.13907e-9 PJ=476.6e-6 m=1
	xi0 (vssa net69) prim_nd AREA=3.8e-09 PJ=1.6e-06 m=1
	xi3 (net51 vdda) prim_pd AREA=790e-15 PJ=3.3e-6 m=1
	xr0 (vssa vdda net51) prim_rdiffp l=2.1e-6 w=700e-9 m=1
	xr1 (vdda vdda net69) prim_rdiffp l=2.1e-6 w=700e-9 m=1
	xcc01 (net12 out) prim_cpoly c=1p m=1
	mnm12 (net13 net56 vssa vssa) nmos1 l=180n w=1u m=1
	mnm11 (net56 net56 vssa vssa) nmos1 l=180n w=1u m=1
	mnb02 (net27 net27 net21 vssa) nmos1 l=180n w=1u m=1
	mnpd1 (net21 xpd vssa vssa) nmos1 l=180n w=1u m=1
	mn001 (out net13 vssa vssa) nmos1 l=2.2e-07n w=1.8e-06u m=1
	mnpd2 (net13 pd vssa vssa) nmos1 l=180n w=1u m=1
	mnc01 (net13 net69 net12 vssa) nmos1 l=2.5e-07n w=1.9e-06u m=1
	mpb02 (net27 net51 net158 vdda) pmos1 l=180n w=1u m=1
	mppd1 (net158 xpd vdda vdda) pmos1 l=180n w=1u m=1
	mps11 (net31 net158 vdda vdda) pmos1 l=1.0e-07n w=1.4e-06u m=1
	mpd11 (net56 inn net31 net31) pmos1 l=180n w=1u m=1
	mp001 (out net158 vdda vdda) pmos1 l=180n w=1u m=1
	mpd12 (net13 inp net31 net31) pmos1 l=180n w=1u m=1
	mpb01 (net158 net158 vdda vdda) pmos1 l=180n w=1u m=1
ends OPAMP1_variant761

subckt OPAMP1_variant762 inn inp out pd xpd vdda vssa
	xd1 (vssa vdda) prim_nwd AREA=6.13907e-9 PJ=476.6e-6 m=1
	xi0 (vssa net69) prim_nd AREA=1e-12 PJ=4e-6 m=1
	xi3 (net51 vdda) prim_pd AREA=790e-15 PJ=3.3e-6 m=1
	xr0 (vssa vdda net51) prim_rdiffp l=2.1e-6 w=700e-9 m=1
	xr1 (vdda vdda net69) prim_rdiffp l=2.1e-6 w=700e-9 m=1
	xcc01 (net12 out) prim_cpoly c=1p m=1
	mnm12 (net13 net56 vssa vssa) nmos1 l=180n w=1u m=1
	mnm11 (net56 net56 vssa vssa) nmos1 l=180n w=1u m=1
	mnb02 (net27 net27 net21 vssa) nmos1 l=180n w=1u m=1
	mnpd1 (net21 xpd vssa vssa) nmos1 l=180n w=1u m=1
	mn001 (out net13 vssa vssa) nmos1 l=180n w=1u m=1
	mnpd2 (net13 pd vssa vssa) nmos1 l=180n w=1u m=1
	mnc01 (net13 net69 net12 vssa) nmos1 l=180n w=1u m=1
	mpb02 (net27 net51 net158 vdda) pmos1 l=180n w=1u m=1
	mppd1 (net158 xpd vdda vdda) pmos1 l=180n w=1u m=1
	mps11 (net31 net158 vdda vdda) pmos1 l=2.2e-07n w=1.9e-06u m=1
	mpd11 (net56 inn net31 net31) pmos1 l=2.3e-07n w=1.1e-06u m=1
	mp001 (out net158 vdda vdda) pmos1 l=180n w=1u m=1
	mpd12 (net13 inp net31 net31) pmos1 l=180n w=1u m=1
	mpb01 (net158 net158 vdda vdda) pmos1 l=180n w=1u m=1
ends OPAMP1_variant762

subckt OPAMP1_variant763 inn inp out pd xpd vdda vssa
	xd1 (vssa vdda) prim_nwd AREA=6.13907e-9 PJ=476.6e-6 m=1
	xi0 (vssa net69) prim_nd AREA=1e-12 PJ=4e-6 m=1
	xi3 (net51 vdda) prim_pd AREA=790e-15 PJ=3.3e-6 m=1
	xr0 (vssa vdda net51) prim_rdiffp l=2.1e-6 w=700e-9 m=1
	xr1 (vdda vdda net69) prim_rdiffp l=1.5e-07 w=1.8e-06 m=1
	xcc01 (net12 out) prim_cpoly c=1p m=1
	mnm12 (net13 net56 vssa vssa) nmos1 l=180n w=1u m=1
	mnm11 (net56 net56 vssa vssa) nmos1 l=180n w=1u m=1
	mnb02 (net27 net27 net21 vssa) nmos1 l=180n w=1u m=1
	mnpd1 (net21 xpd vssa vssa) nmos1 l=180n w=1u m=1
	mn001 (out net13 vssa vssa) nmos1 l=1.3e-07n w=1.3e-06u m=1
	mnpd2 (net13 pd vssa vssa) nmos1 l=180n w=1u m=1
	mnc01 (net13 net69 net12 vssa) nmos1 l=180n w=1u m=1
	mpb02 (net27 net51 net158 vdda) pmos1 l=180n w=1u m=1
	mppd1 (net158 xpd vdda vdda) pmos1 l=2.1e-07n w=9.6e-07u m=1
	mps11 (net31 net158 vdda vdda) pmos1 l=180n w=1u m=1
	mpd11 (net56 inn net31 net31) pmos1 l=180n w=1u m=1
	mp001 (out net158 vdda vdda) pmos1 l=1.2e-07n w=1.7e-06u m=1
	mpd12 (net13 inp net31 net31) pmos1 l=1.5e-07n w=1.4e-06u m=1
	mpb01 (net158 net158 vdda vdda) pmos1 l=180n w=1u m=1
ends OPAMP1_variant763

subckt OPAMP1_variant764 inn inp out pd xpd vdda vssa
	xd1 (vssa vdda) prim_nwd AREA=6.13907e-9 PJ=476.6e-6 m=1
	xi0 (vssa net69) prim_nd AREA=1e-12 PJ=4e-6 m=1
	xi3 (net51 vdda) prim_pd AREA=790e-15 PJ=3.3e-6 m=1
	xr0 (vssa vdda net51) prim_rdiffp l=2.1e-6 w=700e-9 m=1
	xr1 (vdda vdda net69) prim_rdiffp l=2.7e-07 w=1.5e-06 m=1
	xcc01 (net12 out) prim_cpoly c=1p m=1
	mnm12 (net13 net56 vssa vssa) nmos1 l=180n w=1u m=1
	mnm11 (net56 net56 vssa vssa) nmos1 l=180n w=1u m=1
	mnb02 (net27 net27 net21 vssa) nmos1 l=2.0e-07n w=9.8e-07u m=1
	mnpd1 (net21 xpd vssa vssa) nmos1 l=180n w=1u m=1
	mn001 (out net13 vssa vssa) nmos1 l=180n w=1u m=1
	mnpd2 (net13 pd vssa vssa) nmos1 l=2.7e-07n w=1.2e-06u m=1
	mnc01 (net13 net69 net12 vssa) nmos1 l=1.3e-07n w=8.2e-07u m=1
	mpb02 (net27 net51 net158 vdda) pmos1 l=180n w=1u m=1
	mppd1 (net158 xpd vdda vdda) pmos1 l=180n w=1u m=1
	mps11 (net31 net158 vdda vdda) pmos1 l=180n w=1u m=1
	mpd11 (net56 inn net31 net31) pmos1 l=180n w=1u m=1
	mp001 (out net158 vdda vdda) pmos1 l=180n w=1u m=1
	mpd12 (net13 inp net31 net31) pmos1 l=180n w=1u m=1
	mpb01 (net158 net158 vdda vdda) pmos1 l=2.1e-07n w=2.0e-06u m=1
ends OPAMP1_variant764

subckt OPAMP1_variant765 inn inp out pd xpd vdda vssa
	xd1 (vssa vdda) prim_nwd AREA=6.13907e-9 PJ=476.6e-6 m=1
	xi0 (vssa net69) prim_nd AREA=1e-12 PJ=4e-6 m=1
	xi3 (net51 vdda) prim_pd AREA=5.7e-09 PJ=7.7e-05 m=1
	xr0 (vssa vdda net51) prim_rdiffp l=2.1e-6 w=700e-9 m=1
	xr1 (vdda vdda net69) prim_rdiffp l=2.1e-6 w=700e-9 m=1
	xcc01 (net12 out) prim_cpoly c=1p m=1
	mnm12 (net13 net56 vssa vssa) nmos1 l=180n w=1u m=1
	mnm11 (net56 net56 vssa vssa) nmos1 l=180n w=1u m=1
	mnb02 (net27 net27 net21 vssa) nmos1 l=180n w=1u m=1
	mnpd1 (net21 xpd vssa vssa) nmos1 l=2.7e-07n w=1.1e-06u m=1
	mn001 (out net13 vssa vssa) nmos1 l=180n w=1u m=1
	mnpd2 (net13 pd vssa vssa) nmos1 l=2.4e-07n w=8.0e-07u m=1
	mnc01 (net13 net69 net12 vssa) nmos1 l=180n w=1u m=1
	mpb02 (net27 net51 net158 vdda) pmos1 l=180n w=1u m=1
	mppd1 (net158 xpd vdda vdda) pmos1 l=180n w=1u m=1
	mps11 (net31 net158 vdda vdda) pmos1 l=180n w=1u m=1
	mpd11 (net56 inn net31 net31) pmos1 l=180n w=1u m=1
	mp001 (out net158 vdda vdda) pmos1 l=180n w=1u m=1
	mpd12 (net13 inp net31 net31) pmos1 l=180n w=1u m=1
	mpb01 (net158 net158 vdda vdda) pmos1 l=180n w=1u m=1
ends OPAMP1_variant765

subckt OPAMP1_variant766 inn inp out pd xpd vdda vssa
	xd1 (vssa vdda) prim_nwd AREA=6.13907e-9 PJ=476.6e-6 m=1
	xi0 (vssa net69) prim_nd AREA=1e-12 PJ=4e-6 m=1
	xi3 (net51 vdda) prim_pd AREA=790e-15 PJ=3.3e-6 m=1
	xr0 (vssa vdda net51) prim_rdiffp l=1.5e-07 w=1.9e-06 m=1
	xr1 (vdda vdda net69) prim_rdiffp l=1.1e-07 w=8.3e-07 m=1
	xcc01 (net12 out) prim_cpoly c=1p m=1
	mnm12 (net13 net56 vssa vssa) nmos1 l=2.7e-07n w=1.2e-06u m=1
	mnm11 (net56 net56 vssa vssa) nmos1 l=180n w=1u m=1
	mnb02 (net27 net27 net21 vssa) nmos1 l=180n w=1u m=1
	mnpd1 (net21 xpd vssa vssa) nmos1 l=180n w=1u m=1
	mn001 (out net13 vssa vssa) nmos1 l=180n w=1u m=1
	mnpd2 (net13 pd vssa vssa) nmos1 l=180n w=1u m=1
	mnc01 (net13 net69 net12 vssa) nmos1 l=180n w=1u m=1
	mpb02 (net27 net51 net158 vdda) pmos1 l=180n w=1u m=1
	mppd1 (net158 xpd vdda vdda) pmos1 l=180n w=1u m=1
	mps11 (net31 net158 vdda vdda) pmos1 l=180n w=1u m=1
	mpd11 (net56 inn net31 net31) pmos1 l=1.2e-07n w=1.4e-06u m=1
	mp001 (out net158 vdda vdda) pmos1 l=180n w=1u m=1
	mpd12 (net13 inp net31 net31) pmos1 l=180n w=1u m=1
	mpb01 (net158 net158 vdda vdda) pmos1 l=180n w=1u m=1
ends OPAMP1_variant766

subckt OPAMP1_variant767 inn inp out pd xpd vdda vssa
	xd1 (vssa vdda) prim_nwd AREA=6.13907e-9 PJ=476.6e-6 m=1
	xi0 (vssa net69) prim_nd AREA=1e-12 PJ=4e-6 m=1
	xi3 (net51 vdda) prim_pd AREA=790e-15 PJ=3.3e-6 m=1
	xr0 (vssa vdda net51) prim_rdiffp l=2.1e-6 w=700e-9 m=1
	xr1 (vdda vdda net69) prim_rdiffp l=2.1e-6 w=700e-9 m=1
	xcc01 (net12 out) prim_cpoly c=1p m=1
	mnm12 (net13 net56 vssa vssa) nmos1 l=180n w=1u m=1
	mnm11 (net56 net56 vssa vssa) nmos1 l=180n w=1u m=1
	mnb02 (net27 net27 net21 vssa) nmos1 l=180n w=1u m=1
	mnpd1 (net21 xpd vssa vssa) nmos1 l=180n w=1u m=1
	mn001 (out net13 vssa vssa) nmos1 l=1.3e-07n w=6.4e-07u m=1
	mnpd2 (net13 pd vssa vssa) nmos1 l=180n w=1u m=1
	mnc01 (net13 net69 net12 vssa) nmos1 l=180n w=1u m=1
	mpb02 (net27 net51 net158 vdda) pmos1 l=2.0e-07n w=8.9e-07u m=1
	mppd1 (net158 xpd vdda vdda) pmos1 l=180n w=1u m=1
	mps11 (net31 net158 vdda vdda) pmos1 l=180n w=1u m=1
	mpd11 (net56 inn net31 net31) pmos1 l=180n w=1u m=1
	mp001 (out net158 vdda vdda) pmos1 l=180n w=1u m=1
	mpd12 (net13 inp net31 net31) pmos1 l=180n w=1u m=1
	mpb01 (net158 net158 vdda vdda) pmos1 l=180n w=1u m=1
ends OPAMP1_variant767

subckt OPAMP1_variant768 inn inp out pd xpd vdda vssa
	xd1 (vssa vdda) prim_nwd AREA=6.5e-09 PJ=9.7e-05 m=1
	xi0 (vssa net69) prim_nd AREA=1e-12 PJ=4e-6 m=1
	xi3 (net51 vdda) prim_pd AREA=790e-15 PJ=3.3e-6 m=1
	xr0 (vssa vdda net51) prim_rdiffp l=2.1e-6 w=700e-9 m=1
	xr1 (vdda vdda net69) prim_rdiffp l=2.1e-6 w=700e-9 m=1
	xcc01 (net12 out) prim_cpoly c=1.5e-12p m=1
	mnm12 (net13 net56 vssa vssa) nmos1 l=180n w=1u m=1
	mnm11 (net56 net56 vssa vssa) nmos1 l=180n w=1u m=1
	mnb02 (net27 net27 net21 vssa) nmos1 l=180n w=1u m=1
	mnpd1 (net21 xpd vssa vssa) nmos1 l=180n w=1u m=1
	mn001 (out net13 vssa vssa) nmos1 l=180n w=1u m=1
	mnpd2 (net13 pd vssa vssa) nmos1 l=180n w=1u m=1
	mnc01 (net13 net69 net12 vssa) nmos1 l=180n w=1u m=1
	mpb02 (net27 net51 net158 vdda) pmos1 l=180n w=1u m=1
	mppd1 (net158 xpd vdda vdda) pmos1 l=180n w=1u m=1
	mps11 (net31 net158 vdda vdda) pmos1 l=180n w=1u m=1
	mpd11 (net56 inn net31 net31) pmos1 l=180n w=1u m=1
	mp001 (out net158 vdda vdda) pmos1 l=180n w=1u m=1
	mpd12 (net13 inp net31 net31) pmos1 l=180n w=1u m=1
	mpb01 (net158 net158 vdda vdda) pmos1 l=180n w=1u m=1
ends OPAMP1_variant768

subckt OPAMP1_variant769 inn inp out pd xpd vdda vssa
	xd1 (vssa vdda) prim_nwd AREA=1.4e-09 PJ=3.8e-05 m=1
	xi0 (vssa net69) prim_nd AREA=1e-12 PJ=4e-6 m=1
	xi3 (net51 vdda) prim_pd AREA=790e-15 PJ=3.3e-6 m=1
	xr0 (vssa vdda net51) prim_rdiffp l=2.1e-6 w=700e-9 m=1
	xr1 (vdda vdda net69) prim_rdiffp l=2.1e-6 w=700e-9 m=1
	xcc01 (net12 out) prim_cpoly c=1p m=1
	mnm12 (net13 net56 vssa vssa) nmos1 l=180n w=1u m=1
	mnm11 (net56 net56 vssa vssa) nmos1 l=180n w=1u m=1
	mnb02 (net27 net27 net21 vssa) nmos1 l=2.2e-07n w=6.3e-07u m=1
	mnpd1 (net21 xpd vssa vssa) nmos1 l=180n w=1u m=1
	mn001 (out net13 vssa vssa) nmos1 l=180n w=1u m=1
	mnpd2 (net13 pd vssa vssa) nmos1 l=180n w=1u m=1
	mnc01 (net13 net69 net12 vssa) nmos1 l=180n w=1u m=1
	mpb02 (net27 net51 net158 vdda) pmos1 l=1.7e-07n w=1.4e-06u m=1
	mppd1 (net158 xpd vdda vdda) pmos1 l=180n w=1u m=1
	mps11 (net31 net158 vdda vdda) pmos1 l=180n w=1u m=1
	mpd11 (net56 inn net31 net31) pmos1 l=180n w=1u m=1
	mp001 (out net158 vdda vdda) pmos1 l=180n w=1u m=1
	mpd12 (net13 inp net31 net31) pmos1 l=2.2e-07n w=1.1e-06u m=1
	mpb01 (net158 net158 vdda vdda) pmos1 l=180n w=1u m=1
ends OPAMP1_variant769

subckt OPAMP1_variant770 inn inp out pd xpd vdda vssa
	xd1 (vssa vdda) prim_nwd AREA=6.13907e-9 PJ=476.6e-6 m=1
	xi0 (vssa net69) prim_nd AREA=1e-12 PJ=4e-6 m=1
	xi3 (net51 vdda) prim_pd AREA=790e-15 PJ=3.3e-6 m=1
	xr0 (vssa vdda net51) prim_rdiffp l=2.1e-6 w=700e-9 m=1
	xr1 (vdda vdda net69) prim_rdiffp l=2.1e-6 w=700e-9 m=1
	xcc01 (net12 out) prim_cpoly c=1p m=1
	mnm12 (net13 net56 vssa vssa) nmos1 l=3.0e-07n w=1.9e-06u m=1
	mnm11 (net56 net56 vssa vssa) nmos1 l=1.4e-07n w=9.2e-07u m=1
	mnb02 (net27 net27 net21 vssa) nmos1 l=180n w=1u m=1
	mnpd1 (net21 xpd vssa vssa) nmos1 l=180n w=1u m=1
	mn001 (out net13 vssa vssa) nmos1 l=180n w=1u m=1
	mnpd2 (net13 pd vssa vssa) nmos1 l=180n w=1u m=1
	mnc01 (net13 net69 net12 vssa) nmos1 l=180n w=1u m=1
	mpb02 (net27 net51 net158 vdda) pmos1 l=1.3e-07n w=1.6e-06u m=1
	mppd1 (net158 xpd vdda vdda) pmos1 l=180n w=1u m=1
	mps11 (net31 net158 vdda vdda) pmos1 l=180n w=1u m=1
	mpd11 (net56 inn net31 net31) pmos1 l=180n w=1u m=1
	mp001 (out net158 vdda vdda) pmos1 l=180n w=1u m=1
	mpd12 (net13 inp net31 net31) pmos1 l=180n w=1u m=1
	mpb01 (net158 net158 vdda vdda) pmos1 l=2.1e-07n w=6.2e-07u m=1
ends OPAMP1_variant770

subckt OPAMP1_variant771 inn inp out pd xpd vdda vssa
	xd1 (vssa vdda) prim_nwd AREA=6.13907e-9 PJ=476.6e-6 m=1
	xi0 (vssa net69) prim_nd AREA=1e-12 PJ=4e-6 m=1
	xi3 (net51 vdda) prim_pd AREA=790e-15 PJ=3.3e-6 m=1
	xr0 (vssa vdda net51) prim_rdiffp l=2.1e-6 w=700e-9 m=1
	xr1 (vdda vdda net69) prim_rdiffp l=2.1e-6 w=700e-9 m=1
	xcc01 (net12 out) prim_cpoly c=1.9e-12p m=1
	mnm12 (net13 net56 vssa vssa) nmos1 l=180n w=1u m=1
	mnm11 (net56 net56 vssa vssa) nmos1 l=180n w=1u m=1
	mnb02 (net27 net27 net21 vssa) nmos1 l=180n w=1u m=1
	mnpd1 (net21 xpd vssa vssa) nmos1 l=180n w=1u m=1
	mn001 (out net13 vssa vssa) nmos1 l=180n w=1u m=1
	mnpd2 (net13 pd vssa vssa) nmos1 l=180n w=1u m=1
	mnc01 (net13 net69 net12 vssa) nmos1 l=180n w=1u m=1
	mpb02 (net27 net51 net158 vdda) pmos1 l=180n w=1u m=1
	mppd1 (net158 xpd vdda vdda) pmos1 l=180n w=1u m=1
	mps11 (net31 net158 vdda vdda) pmos1 l=180n w=1u m=1
	mpd11 (net56 inn net31 net31) pmos1 l=180n w=1u m=1
	mp001 (out net158 vdda vdda) pmos1 l=180n w=1u m=1
	mpd12 (net13 inp net31 net31) pmos1 l=180n w=1u m=1
	mpb01 (net158 net158 vdda vdda) pmos1 l=1.6e-07n w=8.7e-07u m=1
ends OPAMP1_variant771

subckt OPAMP1_variant772 inn inp out pd xpd vdda vssa
	xd1 (vssa vdda) prim_nwd AREA=6.13907e-9 PJ=476.6e-6 m=1
	xi0 (vssa net69) prim_nd AREA=1e-12 PJ=4e-6 m=1
	xi3 (net51 vdda) prim_pd AREA=790e-15 PJ=3.3e-6 m=1
	xr0 (vssa vdda net51) prim_rdiffp l=2.1e-6 w=700e-9 m=1
	xr1 (vdda vdda net69) prim_rdiffp l=2.1e-6 w=700e-9 m=1
	xcc01 (net12 out) prim_cpoly c=1p m=1
	mnm12 (net13 net56 vssa vssa) nmos1 l=180n w=1u m=1
	mnm11 (net56 net56 vssa vssa) nmos1 l=180n w=1u m=1
	mnb02 (net27 net27 net21 vssa) nmos1 l=180n w=1u m=1
	mnpd1 (net21 xpd vssa vssa) nmos1 l=180n w=1u m=1
	mn001 (out net13 vssa vssa) nmos1 l=180n w=1u m=1
	mnpd2 (net13 pd vssa vssa) nmos1 l=180n w=1u m=1
	mnc01 (net13 net69 net12 vssa) nmos1 l=180n w=1u m=1
	mpb02 (net27 net51 net158 vdda) pmos1 l=180n w=1u m=1
	mppd1 (net158 xpd vdda vdda) pmos1 l=180n w=1u m=1
	mps11 (net31 net158 vdda vdda) pmos1 l=180n w=1u m=1
	mpd11 (net56 inn net31 net31) pmos1 l=2.0e-07n w=5.2e-07u m=1
	mp001 (out net158 vdda vdda) pmos1 l=180n w=1u m=1
	mpd12 (net13 inp net31 net31) pmos1 l=2.3e-07n w=1.6e-06u m=1
	mpb01 (net158 net158 vdda vdda) pmos1 l=180n w=1u m=1
ends OPAMP1_variant772

subckt OPAMP1_variant773 inn inp out pd xpd vdda vssa
	xd1 (vssa vdda) prim_nwd AREA=1.2e-10 PJ=9.5e-05 m=1
	xi0 (vssa net69) prim_nd AREA=1e-12 PJ=4e-6 m=1
	xi3 (net51 vdda) prim_pd AREA=790e-15 PJ=3.3e-6 m=1
	xr0 (vssa vdda net51) prim_rdiffp l=2.1e-6 w=700e-9 m=1
	xr1 (vdda vdda net69) prim_rdiffp l=2.1e-6 w=700e-9 m=1
	xcc01 (net12 out) prim_cpoly c=1p m=1
	mnm12 (net13 net56 vssa vssa) nmos1 l=180n w=1u m=1
	mnm11 (net56 net56 vssa vssa) nmos1 l=180n w=1u m=1
	mnb02 (net27 net27 net21 vssa) nmos1 l=2.9e-07n w=6.3e-07u m=1
	mnpd1 (net21 xpd vssa vssa) nmos1 l=180n w=1u m=1
	mn001 (out net13 vssa vssa) nmos1 l=2.5e-07n w=1.8e-06u m=1
	mnpd2 (net13 pd vssa vssa) nmos1 l=180n w=1u m=1
	mnc01 (net13 net69 net12 vssa) nmos1 l=2.1e-07n w=2.0e-06u m=1
	mpb02 (net27 net51 net158 vdda) pmos1 l=180n w=1u m=1
	mppd1 (net158 xpd vdda vdda) pmos1 l=180n w=1u m=1
	mps11 (net31 net158 vdda vdda) pmos1 l=180n w=1u m=1
	mpd11 (net56 inn net31 net31) pmos1 l=180n w=1u m=1
	mp001 (out net158 vdda vdda) pmos1 l=180n w=1u m=1
	mpd12 (net13 inp net31 net31) pmos1 l=180n w=1u m=1
	mpb01 (net158 net158 vdda vdda) pmos1 l=180n w=1u m=1
ends OPAMP1_variant773

subckt OPAMP1_variant774 inn inp out pd xpd vdda vssa
	xd1 (vssa vdda) prim_nwd AREA=6.13907e-9 PJ=476.6e-6 m=1
	xi0 (vssa net69) prim_nd AREA=1e-12 PJ=4e-6 m=1
	xi3 (net51 vdda) prim_pd AREA=790e-15 PJ=3.3e-6 m=1
	xr0 (vssa vdda net51) prim_rdiffp l=2.1e-6 w=700e-9 m=1
	xr1 (vdda vdda net69) prim_rdiffp l=2.1e-6 w=700e-9 m=1
	xcc01 (net12 out) prim_cpoly c=1p m=1
	mnm12 (net13 net56 vssa vssa) nmos1 l=180n w=1u m=1
	mnm11 (net56 net56 vssa vssa) nmos1 l=180n w=1u m=1
	mnb02 (net27 net27 net21 vssa) nmos1 l=180n w=1u m=1
	mnpd1 (net21 xpd vssa vssa) nmos1 l=180n w=1u m=1
	mn001 (out net13 vssa vssa) nmos1 l=1.7e-07n w=1.9e-06u m=1
	mnpd2 (net13 pd vssa vssa) nmos1 l=180n w=1u m=1
	mnc01 (net13 net69 net12 vssa) nmos1 l=180n w=1u m=1
	mpb02 (net27 net51 net158 vdda) pmos1 l=1.3e-07n w=1.4e-06u m=1
	mppd1 (net158 xpd vdda vdda) pmos1 l=180n w=1u m=1
	mps11 (net31 net158 vdda vdda) pmos1 l=180n w=1u m=1
	mpd11 (net56 inn net31 net31) pmos1 l=180n w=1u m=1
	mp001 (out net158 vdda vdda) pmos1 l=180n w=1u m=1
	mpd12 (net13 inp net31 net31) pmos1 l=180n w=1u m=1
	mpb01 (net158 net158 vdda vdda) pmos1 l=180n w=1u m=1
ends OPAMP1_variant774

subckt OPAMP1_variant775 inn inp out pd xpd vdda vssa
	xd1 (vssa vdda) prim_nwd AREA=6.13907e-9 PJ=476.6e-6 m=1
	xi0 (vssa net69) prim_nd AREA=1e-12 PJ=4e-6 m=1
	xi3 (net51 vdda) prim_pd AREA=790e-15 PJ=3.3e-6 m=1
	xr0 (vssa vdda net51) prim_rdiffp l=2.1e-6 w=700e-9 m=1
	xr1 (vdda vdda net69) prim_rdiffp l=2.1e-6 w=700e-9 m=1
	xcc01 (net12 out) prim_cpoly c=1p m=1
	mnm12 (net13 net56 vssa vssa) nmos1 l=180n w=1u m=1
	mnm11 (net56 net56 vssa vssa) nmos1 l=180n w=1u m=1
	mnb02 (net27 net27 net21 vssa) nmos1 l=180n w=1u m=1
	mnpd1 (net21 xpd vssa vssa) nmos1 l=180n w=1u m=1
	mn001 (out net13 vssa vssa) nmos1 l=180n w=1u m=1
	mnpd2 (net13 pd vssa vssa) nmos1 l=2.1e-07n w=7.5e-07u m=1
	mnc01 (net13 net69 net12 vssa) nmos1 l=180n w=1u m=1
	mpb02 (net27 net51 net158 vdda) pmos1 l=180n w=1u m=1
	mppd1 (net158 xpd vdda vdda) pmos1 l=180n w=1u m=1
	mps11 (net31 net158 vdda vdda) pmos1 l=180n w=1u m=1
	mpd11 (net56 inn net31 net31) pmos1 l=180n w=1u m=1
	mp001 (out net158 vdda vdda) pmos1 l=2.9e-07n w=1.6e-06u m=1
	mpd12 (net13 inp net31 net31) pmos1 l=180n w=1u m=1
	mpb01 (net158 net158 vdda vdda) pmos1 l=180n w=1u m=1
ends OPAMP1_variant775

subckt OPAMP1_variant776 inn inp out pd xpd vdda vssa
	xd1 (vssa vdda) prim_nwd AREA=9.8e-09 PJ=4.0e-05 m=1
	xi0 (vssa net69) prim_nd AREA=1e-12 PJ=4e-6 m=1
	xi3 (net51 vdda) prim_pd AREA=790e-15 PJ=3.3e-6 m=1
	xr0 (vssa vdda net51) prim_rdiffp l=2.1e-6 w=700e-9 m=1
	xr1 (vdda vdda net69) prim_rdiffp l=2.1e-6 w=700e-9 m=1
	xcc01 (net12 out) prim_cpoly c=1p m=1
	mnm12 (net13 net56 vssa vssa) nmos1 l=180n w=1u m=1
	mnm11 (net56 net56 vssa vssa) nmos1 l=180n w=1u m=1
	mnb02 (net27 net27 net21 vssa) nmos1 l=180n w=1u m=1
	mnpd1 (net21 xpd vssa vssa) nmos1 l=180n w=1u m=1
	mn001 (out net13 vssa vssa) nmos1 l=180n w=1u m=1
	mnpd2 (net13 pd vssa vssa) nmos1 l=180n w=1u m=1
	mnc01 (net13 net69 net12 vssa) nmos1 l=180n w=1u m=1
	mpb02 (net27 net51 net158 vdda) pmos1 l=2.8e-07n w=1.9e-06u m=1
	mppd1 (net158 xpd vdda vdda) pmos1 l=180n w=1u m=1
	mps11 (net31 net158 vdda vdda) pmos1 l=180n w=1u m=1
	mpd11 (net56 inn net31 net31) pmos1 l=180n w=1u m=1
	mp001 (out net158 vdda vdda) pmos1 l=180n w=1u m=1
	mpd12 (net13 inp net31 net31) pmos1 l=180n w=1u m=1
	mpb01 (net158 net158 vdda vdda) pmos1 l=180n w=1u m=1
ends OPAMP1_variant776

subckt OPAMP1_variant777 inn inp out pd xpd vdda vssa
	xd1 (vssa vdda) prim_nwd AREA=6.13907e-9 PJ=476.6e-6 m=1
	xi0 (vssa net69) prim_nd AREA=1e-12 PJ=4e-6 m=1
	xi3 (net51 vdda) prim_pd AREA=790e-15 PJ=3.3e-6 m=1
	xr0 (vssa vdda net51) prim_rdiffp l=2.1e-6 w=700e-9 m=1
	xr1 (vdda vdda net69) prim_rdiffp l=2.1e-6 w=700e-9 m=1
	xcc01 (net12 out) prim_cpoly c=8.2e-13p m=1
	mnm12 (net13 net56 vssa vssa) nmos1 l=180n w=1u m=1
	mnm11 (net56 net56 vssa vssa) nmos1 l=1.5e-07n w=1.4e-06u m=1
	mnb02 (net27 net27 net21 vssa) nmos1 l=180n w=1u m=1
	mnpd1 (net21 xpd vssa vssa) nmos1 l=180n w=1u m=1
	mn001 (out net13 vssa vssa) nmos1 l=180n w=1u m=1
	mnpd2 (net13 pd vssa vssa) nmos1 l=180n w=1u m=1
	mnc01 (net13 net69 net12 vssa) nmos1 l=180n w=1u m=1
	mpb02 (net27 net51 net158 vdda) pmos1 l=180n w=1u m=1
	mppd1 (net158 xpd vdda vdda) pmos1 l=180n w=1u m=1
	mps11 (net31 net158 vdda vdda) pmos1 l=1.0e-07n w=5.6e-07u m=1
	mpd11 (net56 inn net31 net31) pmos1 l=180n w=1u m=1
	mp001 (out net158 vdda vdda) pmos1 l=180n w=1u m=1
	mpd12 (net13 inp net31 net31) pmos1 l=180n w=1u m=1
	mpb01 (net158 net158 vdda vdda) pmos1 l=2.2e-07n w=1.1e-06u m=1
ends OPAMP1_variant777

subckt OPAMP1_variant778 inn inp out pd xpd vdda vssa
	xd1 (vssa vdda) prim_nwd AREA=6.13907e-9 PJ=476.6e-6 m=1
	xi0 (vssa net69) prim_nd AREA=1e-12 PJ=4e-6 m=1
	xi3 (net51 vdda) prim_pd AREA=7.7e-09 PJ=6.7e-05 m=1
	xr0 (vssa vdda net51) prim_rdiffp l=1.6e-07 w=1.1e-06 m=1
	xr1 (vdda vdda net69) prim_rdiffp l=2.1e-6 w=700e-9 m=1
	xcc01 (net12 out) prim_cpoly c=1p m=1
	mnm12 (net13 net56 vssa vssa) nmos1 l=180n w=1u m=1
	mnm11 (net56 net56 vssa vssa) nmos1 l=180n w=1u m=1
	mnb02 (net27 net27 net21 vssa) nmos1 l=180n w=1u m=1
	mnpd1 (net21 xpd vssa vssa) nmos1 l=180n w=1u m=1
	mn001 (out net13 vssa vssa) nmos1 l=180n w=1u m=1
	mnpd2 (net13 pd vssa vssa) nmos1 l=180n w=1u m=1
	mnc01 (net13 net69 net12 vssa) nmos1 l=180n w=1u m=1
	mpb02 (net27 net51 net158 vdda) pmos1 l=180n w=1u m=1
	mppd1 (net158 xpd vdda vdda) pmos1 l=180n w=1u m=1
	mps11 (net31 net158 vdda vdda) pmos1 l=180n w=1u m=1
	mpd11 (net56 inn net31 net31) pmos1 l=180n w=1u m=1
	mp001 (out net158 vdda vdda) pmos1 l=3.0e-07n w=1.5e-06u m=1
	mpd12 (net13 inp net31 net31) pmos1 l=2.7e-07n w=9.0e-07u m=1
	mpb01 (net158 net158 vdda vdda) pmos1 l=180n w=1u m=1
ends OPAMP1_variant778

subckt OPAMP1_variant779 inn inp out pd xpd vdda vssa
	xd1 (vssa vdda) prim_nwd AREA=6.13907e-9 PJ=476.6e-6 m=1
	xi0 (vssa net69) prim_nd AREA=1e-12 PJ=4e-6 m=1
	xi3 (net51 vdda) prim_pd AREA=790e-15 PJ=3.3e-6 m=1
	xr0 (vssa vdda net51) prim_rdiffp l=1.0e-07 w=7.9e-07 m=1
	xr1 (vdda vdda net69) prim_rdiffp l=2.1e-6 w=700e-9 m=1
	xcc01 (net12 out) prim_cpoly c=1.1e-12p m=1
	mnm12 (net13 net56 vssa vssa) nmos1 l=2.8e-07n w=1.2e-06u m=1
	mnm11 (net56 net56 vssa vssa) nmos1 l=180n w=1u m=1
	mnb02 (net27 net27 net21 vssa) nmos1 l=180n w=1u m=1
	mnpd1 (net21 xpd vssa vssa) nmos1 l=180n w=1u m=1
	mn001 (out net13 vssa vssa) nmos1 l=180n w=1u m=1
	mnpd2 (net13 pd vssa vssa) nmos1 l=180n w=1u m=1
	mnc01 (net13 net69 net12 vssa) nmos1 l=180n w=1u m=1
	mpb02 (net27 net51 net158 vdda) pmos1 l=1.3e-07n w=1.5e-06u m=1
	mppd1 (net158 xpd vdda vdda) pmos1 l=1.9e-07n w=1.8e-06u m=1
	mps11 (net31 net158 vdda vdda) pmos1 l=180n w=1u m=1
	mpd11 (net56 inn net31 net31) pmos1 l=180n w=1u m=1
	mp001 (out net158 vdda vdda) pmos1 l=180n w=1u m=1
	mpd12 (net13 inp net31 net31) pmos1 l=180n w=1u m=1
	mpb01 (net158 net158 vdda vdda) pmos1 l=180n w=1u m=1
ends OPAMP1_variant779

subckt OPAMP1_variant780 inn inp out pd xpd vdda vssa
	xd1 (vssa vdda) prim_nwd AREA=4.1e-09 PJ=7.1e-05 m=1
	xi0 (vssa net69) prim_nd AREA=5.5e-09 PJ=3.5e-05 m=1
	xi3 (net51 vdda) prim_pd AREA=790e-15 PJ=3.3e-6 m=1
	xr0 (vssa vdda net51) prim_rdiffp l=2.1e-6 w=700e-9 m=1
	xr1 (vdda vdda net69) prim_rdiffp l=2.1e-6 w=700e-9 m=1
	xcc01 (net12 out) prim_cpoly c=1p m=1
	mnm12 (net13 net56 vssa vssa) nmos1 l=2.5e-07n w=2.0e-06u m=1
	mnm11 (net56 net56 vssa vssa) nmos1 l=2.4e-07n w=6.3e-07u m=1
	mnb02 (net27 net27 net21 vssa) nmos1 l=180n w=1u m=1
	mnpd1 (net21 xpd vssa vssa) nmos1 l=180n w=1u m=1
	mn001 (out net13 vssa vssa) nmos1 l=180n w=1u m=1
	mnpd2 (net13 pd vssa vssa) nmos1 l=1.4e-07n w=9.3e-07u m=1
	mnc01 (net13 net69 net12 vssa) nmos1 l=180n w=1u m=1
	mpb02 (net27 net51 net158 vdda) pmos1 l=180n w=1u m=1
	mppd1 (net158 xpd vdda vdda) pmos1 l=180n w=1u m=1
	mps11 (net31 net158 vdda vdda) pmos1 l=180n w=1u m=1
	mpd11 (net56 inn net31 net31) pmos1 l=180n w=1u m=1
	mp001 (out net158 vdda vdda) pmos1 l=180n w=1u m=1
	mpd12 (net13 inp net31 net31) pmos1 l=180n w=1u m=1
	mpb01 (net158 net158 vdda vdda) pmos1 l=180n w=1u m=1
ends OPAMP1_variant780

subckt OPAMP1_variant781 inn inp out pd xpd vdda vssa
	xd1 (vssa vdda) prim_nwd AREA=6.13907e-9 PJ=476.6e-6 m=1
	xi0 (vssa net69) prim_nd AREA=1e-12 PJ=4e-6 m=1
	xi3 (net51 vdda) prim_pd AREA=6.9e-09 PJ=1.3e-05 m=1
	xr0 (vssa vdda net51) prim_rdiffp l=2.1e-6 w=700e-9 m=1
	xr1 (vdda vdda net69) prim_rdiffp l=1.6e-07 w=1.7e-06 m=1
	xcc01 (net12 out) prim_cpoly c=1p m=1
	mnm12 (net13 net56 vssa vssa) nmos1 l=180n w=1u m=1
	mnm11 (net56 net56 vssa vssa) nmos1 l=180n w=1u m=1
	mnb02 (net27 net27 net21 vssa) nmos1 l=180n w=1u m=1
	mnpd1 (net21 xpd vssa vssa) nmos1 l=180n w=1u m=1
	mn001 (out net13 vssa vssa) nmos1 l=180n w=1u m=1
	mnpd2 (net13 pd vssa vssa) nmos1 l=180n w=1u m=1
	mnc01 (net13 net69 net12 vssa) nmos1 l=1.2e-07n w=5.0e-07u m=1
	mpb02 (net27 net51 net158 vdda) pmos1 l=180n w=1u m=1
	mppd1 (net158 xpd vdda vdda) pmos1 l=180n w=1u m=1
	mps11 (net31 net158 vdda vdda) pmos1 l=180n w=1u m=1
	mpd11 (net56 inn net31 net31) pmos1 l=180n w=1u m=1
	mp001 (out net158 vdda vdda) pmos1 l=180n w=1u m=1
	mpd12 (net13 inp net31 net31) pmos1 l=180n w=1u m=1
	mpb01 (net158 net158 vdda vdda) pmos1 l=180n w=1u m=1
ends OPAMP1_variant781

subckt OPAMP1_variant782 inn inp out pd xpd vdda vssa
	xd1 (vssa vdda) prim_nwd AREA=6.13907e-9 PJ=476.6e-6 m=1
	xi0 (vssa net69) prim_nd AREA=1e-12 PJ=4e-6 m=1
	xi3 (net51 vdda) prim_pd AREA=790e-15 PJ=3.3e-6 m=1
	xr0 (vssa vdda net51) prim_rdiffp l=2.1e-6 w=700e-9 m=1
	xr1 (vdda vdda net69) prim_rdiffp l=2.1e-6 w=700e-9 m=1
	xcc01 (net12 out) prim_cpoly c=1p m=1
	mnm12 (net13 net56 vssa vssa) nmos1 l=180n w=1u m=1
	mnm11 (net56 net56 vssa vssa) nmos1 l=180n w=1u m=1
	mnb02 (net27 net27 net21 vssa) nmos1 l=1.3e-07n w=1.0e-06u m=1
	mnpd1 (net21 xpd vssa vssa) nmos1 l=180n w=1u m=1
	mn001 (out net13 vssa vssa) nmos1 l=1.5e-07n w=2.0e-06u m=1
	mnpd2 (net13 pd vssa vssa) nmos1 l=180n w=1u m=1
	mnc01 (net13 net69 net12 vssa) nmos1 l=180n w=1u m=1
	mpb02 (net27 net51 net158 vdda) pmos1 l=180n w=1u m=1
	mppd1 (net158 xpd vdda vdda) pmos1 l=2.9e-07n w=1.0e-06u m=1
	mps11 (net31 net158 vdda vdda) pmos1 l=2.6e-07n w=7.4e-07u m=1
	mpd11 (net56 inn net31 net31) pmos1 l=180n w=1u m=1
	mp001 (out net158 vdda vdda) pmos1 l=180n w=1u m=1
	mpd12 (net13 inp net31 net31) pmos1 l=180n w=1u m=1
	mpb01 (net158 net158 vdda vdda) pmos1 l=180n w=1u m=1
ends OPAMP1_variant782

subckt OPAMP1_variant783 inn inp out pd xpd vdda vssa
	xd1 (vssa vdda) prim_nwd AREA=6.13907e-9 PJ=476.6e-6 m=1
	xi0 (vssa net69) prim_nd AREA=2.4e-09 PJ=1.6e-05 m=1
	xi3 (net51 vdda) prim_pd AREA=790e-15 PJ=3.3e-6 m=1
	xr0 (vssa vdda net51) prim_rdiffp l=2.1e-6 w=700e-9 m=1
	xr1 (vdda vdda net69) prim_rdiffp l=2.8e-07 w=7.1e-07 m=1
	xcc01 (net12 out) prim_cpoly c=1p m=1
	mnm12 (net13 net56 vssa vssa) nmos1 l=180n w=1u m=1
	mnm11 (net56 net56 vssa vssa) nmos1 l=180n w=1u m=1
	mnb02 (net27 net27 net21 vssa) nmos1 l=180n w=1u m=1
	mnpd1 (net21 xpd vssa vssa) nmos1 l=2.8e-07n w=2.0e-06u m=1
	mn001 (out net13 vssa vssa) nmos1 l=180n w=1u m=1
	mnpd2 (net13 pd vssa vssa) nmos1 l=180n w=1u m=1
	mnc01 (net13 net69 net12 vssa) nmos1 l=180n w=1u m=1
	mpb02 (net27 net51 net158 vdda) pmos1 l=180n w=1u m=1
	mppd1 (net158 xpd vdda vdda) pmos1 l=180n w=1u m=1
	mps11 (net31 net158 vdda vdda) pmos1 l=180n w=1u m=1
	mpd11 (net56 inn net31 net31) pmos1 l=1.7e-07n w=1.6e-06u m=1
	mp001 (out net158 vdda vdda) pmos1 l=180n w=1u m=1
	mpd12 (net13 inp net31 net31) pmos1 l=180n w=1u m=1
	mpb01 (net158 net158 vdda vdda) pmos1 l=180n w=1u m=1
ends OPAMP1_variant783

subckt OPAMP1_variant784 inn inp out pd xpd vdda vssa
	xd1 (vssa vdda) prim_nwd AREA=6.13907e-9 PJ=476.6e-6 m=1
	xi0 (vssa net69) prim_nd AREA=8.6e-09 PJ=3.6e-05 m=1
	xi3 (net51 vdda) prim_pd AREA=4.0e-09 PJ=6.2e-05 m=1
	xr0 (vssa vdda net51) prim_rdiffp l=2.6e-07 w=1.4e-06 m=1
	xr1 (vdda vdda net69) prim_rdiffp l=1.5e-07 w=2.0e-06 m=1
	xcc01 (net12 out) prim_cpoly c=1p m=1
	mnm12 (net13 net56 vssa vssa) nmos1 l=180n w=1u m=1
	mnm11 (net56 net56 vssa vssa) nmos1 l=180n w=1u m=1
	mnb02 (net27 net27 net21 vssa) nmos1 l=180n w=1u m=1
	mnpd1 (net21 xpd vssa vssa) nmos1 l=1.7e-07n w=7.2e-07u m=1
	mn001 (out net13 vssa vssa) nmos1 l=180n w=1u m=1
	mnpd2 (net13 pd vssa vssa) nmos1 l=180n w=1u m=1
	mnc01 (net13 net69 net12 vssa) nmos1 l=180n w=1u m=1
	mpb02 (net27 net51 net158 vdda) pmos1 l=180n w=1u m=1
	mppd1 (net158 xpd vdda vdda) pmos1 l=180n w=1u m=1
	mps11 (net31 net158 vdda vdda) pmos1 l=180n w=1u m=1
	mpd11 (net56 inn net31 net31) pmos1 l=180n w=1u m=1
	mp001 (out net158 vdda vdda) pmos1 l=180n w=1u m=1
	mpd12 (net13 inp net31 net31) pmos1 l=180n w=1u m=1
	mpb01 (net158 net158 vdda vdda) pmos1 l=180n w=1u m=1
ends OPAMP1_variant784

subckt OPAMP1_variant785 inn inp out pd xpd vdda vssa
	xd1 (vssa vdda) prim_nwd AREA=6.13907e-9 PJ=476.6e-6 m=1
	xi0 (vssa net69) prim_nd AREA=1e-12 PJ=4e-6 m=1
	xi3 (net51 vdda) prim_pd AREA=790e-15 PJ=3.3e-6 m=1
	xr0 (vssa vdda net51) prim_rdiffp l=1.4e-07 w=1.7e-06 m=1
	xr1 (vdda vdda net69) prim_rdiffp l=2.1e-6 w=700e-9 m=1
	xcc01 (net12 out) prim_cpoly c=1p m=1
	mnm12 (net13 net56 vssa vssa) nmos1 l=180n w=1u m=1
	mnm11 (net56 net56 vssa vssa) nmos1 l=180n w=1u m=1
	mnb02 (net27 net27 net21 vssa) nmos1 l=180n w=1u m=1
	mnpd1 (net21 xpd vssa vssa) nmos1 l=180n w=1u m=1
	mn001 (out net13 vssa vssa) nmos1 l=180n w=1u m=1
	mnpd2 (net13 pd vssa vssa) nmos1 l=180n w=1u m=1
	mnc01 (net13 net69 net12 vssa) nmos1 l=180n w=1u m=1
	mpb02 (net27 net51 net158 vdda) pmos1 l=180n w=1u m=1
	mppd1 (net158 xpd vdda vdda) pmos1 l=180n w=1u m=1
	mps11 (net31 net158 vdda vdda) pmos1 l=180n w=1u m=1
	mpd11 (net56 inn net31 net31) pmos1 l=180n w=1u m=1
	mp001 (out net158 vdda vdda) pmos1 l=180n w=1u m=1
	mpd12 (net13 inp net31 net31) pmos1 l=1.9e-07n w=9.5e-07u m=1
	mpb01 (net158 net158 vdda vdda) pmos1 l=180n w=1u m=1
ends OPAMP1_variant785

subckt OPAMP1_variant786 inn inp out pd xpd vdda vssa
	xd1 (vssa vdda) prim_nwd AREA=6.13907e-9 PJ=476.6e-6 m=1
	xi0 (vssa net69) prim_nd AREA=9.5e-10 PJ=1.8e-06 m=1
	xi3 (net51 vdda) prim_pd AREA=790e-15 PJ=3.3e-6 m=1
	xr0 (vssa vdda net51) prim_rdiffp l=1.3e-07 w=5.8e-07 m=1
	xr1 (vdda vdda net69) prim_rdiffp l=2.1e-6 w=700e-9 m=1
	xcc01 (net12 out) prim_cpoly c=1p m=1
	mnm12 (net13 net56 vssa vssa) nmos1 l=180n w=1u m=1
	mnm11 (net56 net56 vssa vssa) nmos1 l=180n w=1u m=1
	mnb02 (net27 net27 net21 vssa) nmos1 l=180n w=1u m=1
	mnpd1 (net21 xpd vssa vssa) nmos1 l=2.2e-07n w=1.7e-06u m=1
	mn001 (out net13 vssa vssa) nmos1 l=180n w=1u m=1
	mnpd2 (net13 pd vssa vssa) nmos1 l=180n w=1u m=1
	mnc01 (net13 net69 net12 vssa) nmos1 l=180n w=1u m=1
	mpb02 (net27 net51 net158 vdda) pmos1 l=180n w=1u m=1
	mppd1 (net158 xpd vdda vdda) pmos1 l=180n w=1u m=1
	mps11 (net31 net158 vdda vdda) pmos1 l=180n w=1u m=1
	mpd11 (net56 inn net31 net31) pmos1 l=1.5e-07n w=1.9e-06u m=1
	mp001 (out net158 vdda vdda) pmos1 l=180n w=1u m=1
	mpd12 (net13 inp net31 net31) pmos1 l=2.3e-07n w=1.4e-06u m=1
	mpb01 (net158 net158 vdda vdda) pmos1 l=180n w=1u m=1
ends OPAMP1_variant786

subckt OPAMP1_variant787 inn inp out pd xpd vdda vssa
	xd1 (vssa vdda) prim_nwd AREA=6.13907e-9 PJ=476.6e-6 m=1
	xi0 (vssa net69) prim_nd AREA=1e-12 PJ=4e-6 m=1
	xi3 (net51 vdda) prim_pd AREA=790e-15 PJ=3.3e-6 m=1
	xr0 (vssa vdda net51) prim_rdiffp l=2.1e-6 w=700e-9 m=1
	xr1 (vdda vdda net69) prim_rdiffp l=2.1e-6 w=700e-9 m=1
	xcc01 (net12 out) prim_cpoly c=5.7e-13p m=1
	mnm12 (net13 net56 vssa vssa) nmos1 l=2.4e-07n w=1.9e-06u m=1
	mnm11 (net56 net56 vssa vssa) nmos1 l=180n w=1u m=1
	mnb02 (net27 net27 net21 vssa) nmos1 l=180n w=1u m=1
	mnpd1 (net21 xpd vssa vssa) nmos1 l=180n w=1u m=1
	mn001 (out net13 vssa vssa) nmos1 l=180n w=1u m=1
	mnpd2 (net13 pd vssa vssa) nmos1 l=2.2e-07n w=1.5e-06u m=1
	mnc01 (net13 net69 net12 vssa) nmos1 l=180n w=1u m=1
	mpb02 (net27 net51 net158 vdda) pmos1 l=180n w=1u m=1
	mppd1 (net158 xpd vdda vdda) pmos1 l=180n w=1u m=1
	mps11 (net31 net158 vdda vdda) pmos1 l=180n w=1u m=1
	mpd11 (net56 inn net31 net31) pmos1 l=180n w=1u m=1
	mp001 (out net158 vdda vdda) pmos1 l=180n w=1u m=1
	mpd12 (net13 inp net31 net31) pmos1 l=2.3e-07n w=1.9e-06u m=1
	mpb01 (net158 net158 vdda vdda) pmos1 l=180n w=1u m=1
ends OPAMP1_variant787

subckt OPAMP1_variant788 inn inp out pd xpd vdda vssa
	xd1 (vssa vdda) prim_nwd AREA=6.13907e-9 PJ=476.6e-6 m=1
	xi0 (vssa net69) prim_nd AREA=1e-12 PJ=4e-6 m=1
	xi3 (net51 vdda) prim_pd AREA=790e-15 PJ=3.3e-6 m=1
	xr0 (vssa vdda net51) prim_rdiffp l=2.1e-6 w=700e-9 m=1
	xr1 (vdda vdda net69) prim_rdiffp l=2.1e-6 w=700e-9 m=1
	xcc01 (net12 out) prim_cpoly c=1p m=1
	mnm12 (net13 net56 vssa vssa) nmos1 l=1.6e-07n w=1.4e-06u m=1
	mnm11 (net56 net56 vssa vssa) nmos1 l=180n w=1u m=1
	mnb02 (net27 net27 net21 vssa) nmos1 l=180n w=1u m=1
	mnpd1 (net21 xpd vssa vssa) nmos1 l=180n w=1u m=1
	mn001 (out net13 vssa vssa) nmos1 l=180n w=1u m=1
	mnpd2 (net13 pd vssa vssa) nmos1 l=180n w=1u m=1
	mnc01 (net13 net69 net12 vssa) nmos1 l=180n w=1u m=1
	mpb02 (net27 net51 net158 vdda) pmos1 l=180n w=1u m=1
	mppd1 (net158 xpd vdda vdda) pmos1 l=180n w=1u m=1
	mps11 (net31 net158 vdda vdda) pmos1 l=180n w=1u m=1
	mpd11 (net56 inn net31 net31) pmos1 l=2.4e-07n w=9.5e-07u m=1
	mp001 (out net158 vdda vdda) pmos1 l=180n w=1u m=1
	mpd12 (net13 inp net31 net31) pmos1 l=180n w=1u m=1
	mpb01 (net158 net158 vdda vdda) pmos1 l=180n w=1u m=1
ends OPAMP1_variant788

subckt OPAMP1_variant789 inn inp out pd xpd vdda vssa
	xd1 (vssa vdda) prim_nwd AREA=2.1e-09 PJ=7.7e-06 m=1
	xi0 (vssa net69) prim_nd AREA=1e-12 PJ=4e-6 m=1
	xi3 (net51 vdda) prim_pd AREA=790e-15 PJ=3.3e-6 m=1
	xr0 (vssa vdda net51) prim_rdiffp l=2.1e-6 w=700e-9 m=1
	xr1 (vdda vdda net69) prim_rdiffp l=2.1e-6 w=700e-9 m=1
	xcc01 (net12 out) prim_cpoly c=1.7e-12p m=1
	mnm12 (net13 net56 vssa vssa) nmos1 l=180n w=1u m=1
	mnm11 (net56 net56 vssa vssa) nmos1 l=180n w=1u m=1
	mnb02 (net27 net27 net21 vssa) nmos1 l=180n w=1u m=1
	mnpd1 (net21 xpd vssa vssa) nmos1 l=180n w=1u m=1
	mn001 (out net13 vssa vssa) nmos1 l=2.6e-07n w=6.4e-07u m=1
	mnpd2 (net13 pd vssa vssa) nmos1 l=180n w=1u m=1
	mnc01 (net13 net69 net12 vssa) nmos1 l=180n w=1u m=1
	mpb02 (net27 net51 net158 vdda) pmos1 l=180n w=1u m=1
	mppd1 (net158 xpd vdda vdda) pmos1 l=1.0e-07n w=6.4e-07u m=1
	mps11 (net31 net158 vdda vdda) pmos1 l=180n w=1u m=1
	mpd11 (net56 inn net31 net31) pmos1 l=180n w=1u m=1
	mp001 (out net158 vdda vdda) pmos1 l=180n w=1u m=1
	mpd12 (net13 inp net31 net31) pmos1 l=180n w=1u m=1
	mpb01 (net158 net158 vdda vdda) pmos1 l=180n w=1u m=1
ends OPAMP1_variant789

subckt OPAMP1_variant790 inn inp out pd xpd vdda vssa
	xd1 (vssa vdda) prim_nwd AREA=9.6e-09 PJ=2.4e-05 m=1
	xi0 (vssa net69) prim_nd AREA=1e-12 PJ=4e-6 m=1
	xi3 (net51 vdda) prim_pd AREA=9.4e-09 PJ=6.5e-05 m=1
	xr0 (vssa vdda net51) prim_rdiffp l=2.1e-6 w=700e-9 m=1
	xr1 (vdda vdda net69) prim_rdiffp l=2.1e-6 w=700e-9 m=1
	xcc01 (net12 out) prim_cpoly c=1p m=1
	mnm12 (net13 net56 vssa vssa) nmos1 l=180n w=1u m=1
	mnm11 (net56 net56 vssa vssa) nmos1 l=180n w=1u m=1
	mnb02 (net27 net27 net21 vssa) nmos1 l=180n w=1u m=1
	mnpd1 (net21 xpd vssa vssa) nmos1 l=180n w=1u m=1
	mn001 (out net13 vssa vssa) nmos1 l=180n w=1u m=1
	mnpd2 (net13 pd vssa vssa) nmos1 l=180n w=1u m=1
	mnc01 (net13 net69 net12 vssa) nmos1 l=180n w=1u m=1
	mpb02 (net27 net51 net158 vdda) pmos1 l=180n w=1u m=1
	mppd1 (net158 xpd vdda vdda) pmos1 l=180n w=1u m=1
	mps11 (net31 net158 vdda vdda) pmos1 l=180n w=1u m=1
	mpd11 (net56 inn net31 net31) pmos1 l=180n w=1u m=1
	mp001 (out net158 vdda vdda) pmos1 l=180n w=1u m=1
	mpd12 (net13 inp net31 net31) pmos1 l=180n w=1u m=1
	mpb01 (net158 net158 vdda vdda) pmos1 l=180n w=1u m=1
ends OPAMP1_variant790

subckt OPAMP1_variant791 inn inp out pd xpd vdda vssa
	xd1 (vssa vdda) prim_nwd AREA=6.13907e-9 PJ=476.6e-6 m=1
	xi0 (vssa net69) prim_nd AREA=1e-12 PJ=4e-6 m=1
	xi3 (net51 vdda) prim_pd AREA=790e-15 PJ=3.3e-6 m=1
	xr0 (vssa vdda net51) prim_rdiffp l=2.1e-6 w=700e-9 m=1
	xr1 (vdda vdda net69) prim_rdiffp l=1.4e-07 w=7.0e-07 m=1
	xcc01 (net12 out) prim_cpoly c=9.1e-13p m=1
	mnm12 (net13 net56 vssa vssa) nmos1 l=180n w=1u m=1
	mnm11 (net56 net56 vssa vssa) nmos1 l=2.1e-07n w=5.5e-07u m=1
	mnb02 (net27 net27 net21 vssa) nmos1 l=2.1e-07n w=6.3e-07u m=1
	mnpd1 (net21 xpd vssa vssa) nmos1 l=180n w=1u m=1
	mn001 (out net13 vssa vssa) nmos1 l=180n w=1u m=1
	mnpd2 (net13 pd vssa vssa) nmos1 l=180n w=1u m=1
	mnc01 (net13 net69 net12 vssa) nmos1 l=180n w=1u m=1
	mpb02 (net27 net51 net158 vdda) pmos1 l=180n w=1u m=1
	mppd1 (net158 xpd vdda vdda) pmos1 l=180n w=1u m=1
	mps11 (net31 net158 vdda vdda) pmos1 l=180n w=1u m=1
	mpd11 (net56 inn net31 net31) pmos1 l=180n w=1u m=1
	mp001 (out net158 vdda vdda) pmos1 l=180n w=1u m=1
	mpd12 (net13 inp net31 net31) pmos1 l=180n w=1u m=1
	mpb01 (net158 net158 vdda vdda) pmos1 l=180n w=1u m=1
ends OPAMP1_variant791

subckt OPAMP1_variant792 inn inp out pd xpd vdda vssa
	xd1 (vssa vdda) prim_nwd AREA=6.13907e-9 PJ=476.6e-6 m=1
	xi0 (vssa net69) prim_nd AREA=1e-12 PJ=4e-6 m=1
	xi3 (net51 vdda) prim_pd AREA=790e-15 PJ=3.3e-6 m=1
	xr0 (vssa vdda net51) prim_rdiffp l=2.1e-6 w=700e-9 m=1
	xr1 (vdda vdda net69) prim_rdiffp l=2.1e-6 w=700e-9 m=1
	xcc01 (net12 out) prim_cpoly c=1p m=1
	mnm12 (net13 net56 vssa vssa) nmos1 l=180n w=1u m=1
	mnm11 (net56 net56 vssa vssa) nmos1 l=180n w=1u m=1
	mnb02 (net27 net27 net21 vssa) nmos1 l=180n w=1u m=1
	mnpd1 (net21 xpd vssa vssa) nmos1 l=180n w=1u m=1
	mn001 (out net13 vssa vssa) nmos1 l=180n w=1u m=1
	mnpd2 (net13 pd vssa vssa) nmos1 l=1.8e-07n w=1.2e-06u m=1
	mnc01 (net13 net69 net12 vssa) nmos1 l=180n w=1u m=1
	mpb02 (net27 net51 net158 vdda) pmos1 l=2.1e-07n w=1.1e-06u m=1
	mppd1 (net158 xpd vdda vdda) pmos1 l=180n w=1u m=1
	mps11 (net31 net158 vdda vdda) pmos1 l=180n w=1u m=1
	mpd11 (net56 inn net31 net31) pmos1 l=180n w=1u m=1
	mp001 (out net158 vdda vdda) pmos1 l=180n w=1u m=1
	mpd12 (net13 inp net31 net31) pmos1 l=180n w=1u m=1
	mpb01 (net158 net158 vdda vdda) pmos1 l=180n w=1u m=1
ends OPAMP1_variant792

subckt OPAMP1_variant793 inn inp out pd xpd vdda vssa
	xd1 (vssa vdda) prim_nwd AREA=6.13907e-9 PJ=476.6e-6 m=1
	xi0 (vssa net69) prim_nd AREA=1e-12 PJ=4e-6 m=1
	xi3 (net51 vdda) prim_pd AREA=790e-15 PJ=3.3e-6 m=1
	xr0 (vssa vdda net51) prim_rdiffp l=2.1e-6 w=700e-9 m=1
	xr1 (vdda vdda net69) prim_rdiffp l=2.1e-6 w=700e-9 m=1
	xcc01 (net12 out) prim_cpoly c=1p m=1
	mnm12 (net13 net56 vssa vssa) nmos1 l=180n w=1u m=1
	mnm11 (net56 net56 vssa vssa) nmos1 l=180n w=1u m=1
	mnb02 (net27 net27 net21 vssa) nmos1 l=180n w=1u m=1
	mnpd1 (net21 xpd vssa vssa) nmos1 l=180n w=1u m=1
	mn001 (out net13 vssa vssa) nmos1 l=180n w=1u m=1
	mnpd2 (net13 pd vssa vssa) nmos1 l=180n w=1u m=1
	mnc01 (net13 net69 net12 vssa) nmos1 l=2.5e-07n w=1.2e-06u m=1
	mpb02 (net27 net51 net158 vdda) pmos1 l=180n w=1u m=1
	mppd1 (net158 xpd vdda vdda) pmos1 l=2.0e-07n w=1.5e-06u m=1
	mps11 (net31 net158 vdda vdda) pmos1 l=2.7e-07n w=6.8e-07u m=1
	mpd11 (net56 inn net31 net31) pmos1 l=180n w=1u m=1
	mp001 (out net158 vdda vdda) pmos1 l=180n w=1u m=1
	mpd12 (net13 inp net31 net31) pmos1 l=180n w=1u m=1
	mpb01 (net158 net158 vdda vdda) pmos1 l=3.0e-07n w=5.8e-07u m=1
ends OPAMP1_variant793

subckt OPAMP1_variant794 inn inp out pd xpd vdda vssa
	xd1 (vssa vdda) prim_nwd AREA=3.0e-09 PJ=3.5e-05 m=1
	xi0 (vssa net69) prim_nd AREA=1e-12 PJ=4e-6 m=1
	xi3 (net51 vdda) prim_pd AREA=790e-15 PJ=3.3e-6 m=1
	xr0 (vssa vdda net51) prim_rdiffp l=2.1e-6 w=700e-9 m=1
	xr1 (vdda vdda net69) prim_rdiffp l=2.1e-6 w=700e-9 m=1
	xcc01 (net12 out) prim_cpoly c=1p m=1
	mnm12 (net13 net56 vssa vssa) nmos1 l=180n w=1u m=1
	mnm11 (net56 net56 vssa vssa) nmos1 l=180n w=1u m=1
	mnb02 (net27 net27 net21 vssa) nmos1 l=180n w=1u m=1
	mnpd1 (net21 xpd vssa vssa) nmos1 l=180n w=1u m=1
	mn001 (out net13 vssa vssa) nmos1 l=180n w=1u m=1
	mnpd2 (net13 pd vssa vssa) nmos1 l=180n w=1u m=1
	mnc01 (net13 net69 net12 vssa) nmos1 l=2.1e-07n w=1.4e-06u m=1
	mpb02 (net27 net51 net158 vdda) pmos1 l=180n w=1u m=1
	mppd1 (net158 xpd vdda vdda) pmos1 l=180n w=1u m=1
	mps11 (net31 net158 vdda vdda) pmos1 l=180n w=1u m=1
	mpd11 (net56 inn net31 net31) pmos1 l=180n w=1u m=1
	mp001 (out net158 vdda vdda) pmos1 l=180n w=1u m=1
	mpd12 (net13 inp net31 net31) pmos1 l=180n w=1u m=1
	mpb01 (net158 net158 vdda vdda) pmos1 l=180n w=1u m=1
ends OPAMP1_variant794

subckt OPAMP1_variant795 inn inp out pd xpd vdda vssa
	xd1 (vssa vdda) prim_nwd AREA=6.13907e-9 PJ=476.6e-6 m=1
	xi0 (vssa net69) prim_nd AREA=6.4e-10 PJ=9.4e-05 m=1
	xi3 (net51 vdda) prim_pd AREA=790e-15 PJ=3.3e-6 m=1
	xr0 (vssa vdda net51) prim_rdiffp l=2.1e-6 w=700e-9 m=1
	xr1 (vdda vdda net69) prim_rdiffp l=2.1e-6 w=700e-9 m=1
	xcc01 (net12 out) prim_cpoly c=1.8e-12p m=1
	mnm12 (net13 net56 vssa vssa) nmos1 l=180n w=1u m=1
	mnm11 (net56 net56 vssa vssa) nmos1 l=180n w=1u m=1
	mnb02 (net27 net27 net21 vssa) nmos1 l=1.3e-07n w=1.2e-06u m=1
	mnpd1 (net21 xpd vssa vssa) nmos1 l=2.5e-07n w=1.7e-06u m=1
	mn001 (out net13 vssa vssa) nmos1 l=180n w=1u m=1
	mnpd2 (net13 pd vssa vssa) nmos1 l=1.3e-07n w=1.1e-06u m=1
	mnc01 (net13 net69 net12 vssa) nmos1 l=180n w=1u m=1
	mpb02 (net27 net51 net158 vdda) pmos1 l=180n w=1u m=1
	mppd1 (net158 xpd vdda vdda) pmos1 l=180n w=1u m=1
	mps11 (net31 net158 vdda vdda) pmos1 l=180n w=1u m=1
	mpd11 (net56 inn net31 net31) pmos1 l=180n w=1u m=1
	mp001 (out net158 vdda vdda) pmos1 l=180n w=1u m=1
	mpd12 (net13 inp net31 net31) pmos1 l=180n w=1u m=1
	mpb01 (net158 net158 vdda vdda) pmos1 l=180n w=1u m=1
ends OPAMP1_variant795

subckt OPAMP1_variant796 inn inp out pd xpd vdda vssa
	xd1 (vssa vdda) prim_nwd AREA=6.13907e-9 PJ=476.6e-6 m=1
	xi0 (vssa net69) prim_nd AREA=1e-12 PJ=4e-6 m=1
	xi3 (net51 vdda) prim_pd AREA=790e-15 PJ=3.3e-6 m=1
	xr0 (vssa vdda net51) prim_rdiffp l=2.1e-6 w=700e-9 m=1
	xr1 (vdda vdda net69) prim_rdiffp l=2.2e-07 w=1.7e-06 m=1
	xcc01 (net12 out) prim_cpoly c=1p m=1
	mnm12 (net13 net56 vssa vssa) nmos1 l=180n w=1u m=1
	mnm11 (net56 net56 vssa vssa) nmos1 l=180n w=1u m=1
	mnb02 (net27 net27 net21 vssa) nmos1 l=180n w=1u m=1
	mnpd1 (net21 xpd vssa vssa) nmos1 l=1.7e-07n w=2.0e-06u m=1
	mn001 (out net13 vssa vssa) nmos1 l=180n w=1u m=1
	mnpd2 (net13 pd vssa vssa) nmos1 l=180n w=1u m=1
	mnc01 (net13 net69 net12 vssa) nmos1 l=180n w=1u m=1
	mpb02 (net27 net51 net158 vdda) pmos1 l=180n w=1u m=1
	mppd1 (net158 xpd vdda vdda) pmos1 l=180n w=1u m=1
	mps11 (net31 net158 vdda vdda) pmos1 l=180n w=1u m=1
	mpd11 (net56 inn net31 net31) pmos1 l=180n w=1u m=1
	mp001 (out net158 vdda vdda) pmos1 l=180n w=1u m=1
	mpd12 (net13 inp net31 net31) pmos1 l=1.0e-07n w=1.4e-06u m=1
	mpb01 (net158 net158 vdda vdda) pmos1 l=180n w=1u m=1
ends OPAMP1_variant796

subckt OPAMP1_variant797 inn inp out pd xpd vdda vssa
	xd1 (vssa vdda) prim_nwd AREA=6.13907e-9 PJ=476.6e-6 m=1
	xi0 (vssa net69) prim_nd AREA=1e-12 PJ=4e-6 m=1
	xi3 (net51 vdda) prim_pd AREA=790e-15 PJ=3.3e-6 m=1
	xr0 (vssa vdda net51) prim_rdiffp l=2.1e-6 w=700e-9 m=1
	xr1 (vdda vdda net69) prim_rdiffp l=2.1e-6 w=700e-9 m=1
	xcc01 (net12 out) prim_cpoly c=1p m=1
	mnm12 (net13 net56 vssa vssa) nmos1 l=1.4e-07n w=1.6e-06u m=1
	mnm11 (net56 net56 vssa vssa) nmos1 l=180n w=1u m=1
	mnb02 (net27 net27 net21 vssa) nmos1 l=180n w=1u m=1
	mnpd1 (net21 xpd vssa vssa) nmos1 l=180n w=1u m=1
	mn001 (out net13 vssa vssa) nmos1 l=180n w=1u m=1
	mnpd2 (net13 pd vssa vssa) nmos1 l=180n w=1u m=1
	mnc01 (net13 net69 net12 vssa) nmos1 l=180n w=1u m=1
	mpb02 (net27 net51 net158 vdda) pmos1 l=180n w=1u m=1
	mppd1 (net158 xpd vdda vdda) pmos1 l=180n w=1u m=1
	mps11 (net31 net158 vdda vdda) pmos1 l=180n w=1u m=1
	mpd11 (net56 inn net31 net31) pmos1 l=180n w=1u m=1
	mp001 (out net158 vdda vdda) pmos1 l=180n w=1u m=1
	mpd12 (net13 inp net31 net31) pmos1 l=180n w=1u m=1
	mpb01 (net158 net158 vdda vdda) pmos1 l=1.2e-07n w=1.1e-06u m=1
ends OPAMP1_variant797

subckt OPAMP1_variant798 inn inp out pd xpd vdda vssa
	xd1 (vssa vdda) prim_nwd AREA=1.5e-09 PJ=1.7e-06 m=1
	xi0 (vssa net69) prim_nd AREA=1e-12 PJ=4e-6 m=1
	xi3 (net51 vdda) prim_pd AREA=790e-15 PJ=3.3e-6 m=1
	xr0 (vssa vdda net51) prim_rdiffp l=2.1e-6 w=700e-9 m=1
	xr1 (vdda vdda net69) prim_rdiffp l=2.1e-6 w=700e-9 m=1
	xcc01 (net12 out) prim_cpoly c=1p m=1
	mnm12 (net13 net56 vssa vssa) nmos1 l=180n w=1u m=1
	mnm11 (net56 net56 vssa vssa) nmos1 l=180n w=1u m=1
	mnb02 (net27 net27 net21 vssa) nmos1 l=180n w=1u m=1
	mnpd1 (net21 xpd vssa vssa) nmos1 l=1.4e-07n w=1.9e-06u m=1
	mn001 (out net13 vssa vssa) nmos1 l=180n w=1u m=1
	mnpd2 (net13 pd vssa vssa) nmos1 l=2.4e-07n w=1.6e-06u m=1
	mnc01 (net13 net69 net12 vssa) nmos1 l=180n w=1u m=1
	mpb02 (net27 net51 net158 vdda) pmos1 l=180n w=1u m=1
	mppd1 (net158 xpd vdda vdda) pmos1 l=180n w=1u m=1
	mps11 (net31 net158 vdda vdda) pmos1 l=180n w=1u m=1
	mpd11 (net56 inn net31 net31) pmos1 l=180n w=1u m=1
	mp001 (out net158 vdda vdda) pmos1 l=180n w=1u m=1
	mpd12 (net13 inp net31 net31) pmos1 l=180n w=1u m=1
	mpb01 (net158 net158 vdda vdda) pmos1 l=180n w=1u m=1
ends OPAMP1_variant798

subckt OPAMP1_variant799 inn inp out pd xpd vdda vssa
	xd1 (vssa vdda) prim_nwd AREA=6.13907e-9 PJ=476.6e-6 m=1
	xi0 (vssa net69) prim_nd AREA=6.0e-09 PJ=4.9e-05 m=1
	xi3 (net51 vdda) prim_pd AREA=790e-15 PJ=3.3e-6 m=1
	xr0 (vssa vdda net51) prim_rdiffp l=2.1e-6 w=700e-9 m=1
	xr1 (vdda vdda net69) prim_rdiffp l=2.1e-6 w=700e-9 m=1
	xcc01 (net12 out) prim_cpoly c=1p m=1
	mnm12 (net13 net56 vssa vssa) nmos1 l=180n w=1u m=1
	mnm11 (net56 net56 vssa vssa) nmos1 l=180n w=1u m=1
	mnb02 (net27 net27 net21 vssa) nmos1 l=180n w=1u m=1
	mnpd1 (net21 xpd vssa vssa) nmos1 l=180n w=1u m=1
	mn001 (out net13 vssa vssa) nmos1 l=180n w=1u m=1
	mnpd2 (net13 pd vssa vssa) nmos1 l=180n w=1u m=1
	mnc01 (net13 net69 net12 vssa) nmos1 l=180n w=1u m=1
	mpb02 (net27 net51 net158 vdda) pmos1 l=180n w=1u m=1
	mppd1 (net158 xpd vdda vdda) pmos1 l=2.5e-07n w=1.6e-06u m=1
	mps11 (net31 net158 vdda vdda) pmos1 l=180n w=1u m=1
	mpd11 (net56 inn net31 net31) pmos1 l=2.0e-07n w=6.0e-07u m=1
	mp001 (out net158 vdda vdda) pmos1 l=180n w=1u m=1
	mpd12 (net13 inp net31 net31) pmos1 l=180n w=1u m=1
	mpb01 (net158 net158 vdda vdda) pmos1 l=180n w=1u m=1
ends OPAMP1_variant799

subckt OPAMP1_variant800 inn inp out pd xpd vdda vssa
	xd1 (vssa vdda) prim_nwd AREA=6.13907e-9 PJ=476.6e-6 m=1
	xi0 (vssa net69) prim_nd AREA=1e-12 PJ=4e-6 m=1
	xi3 (net51 vdda) prim_pd AREA=790e-15 PJ=3.3e-6 m=1
	xr0 (vssa vdda net51) prim_rdiffp l=2.1e-6 w=700e-9 m=1
	xr1 (vdda vdda net69) prim_rdiffp l=2.1e-6 w=700e-9 m=1
	xcc01 (net12 out) prim_cpoly c=1p m=1
	mnm12 (net13 net56 vssa vssa) nmos1 l=180n w=1u m=1
	mnm11 (net56 net56 vssa vssa) nmos1 l=180n w=1u m=1
	mnb02 (net27 net27 net21 vssa) nmos1 l=1.5e-07n w=1.9e-06u m=1
	mnpd1 (net21 xpd vssa vssa) nmos1 l=180n w=1u m=1
	mn001 (out net13 vssa vssa) nmos1 l=180n w=1u m=1
	mnpd2 (net13 pd vssa vssa) nmos1 l=180n w=1u m=1
	mnc01 (net13 net69 net12 vssa) nmos1 l=180n w=1u m=1
	mpb02 (net27 net51 net158 vdda) pmos1 l=2.2e-07n w=7.8e-07u m=1
	mppd1 (net158 xpd vdda vdda) pmos1 l=180n w=1u m=1
	mps11 (net31 net158 vdda vdda) pmos1 l=180n w=1u m=1
	mpd11 (net56 inn net31 net31) pmos1 l=180n w=1u m=1
	mp001 (out net158 vdda vdda) pmos1 l=1.5e-07n w=1.9e-06u m=1
	mpd12 (net13 inp net31 net31) pmos1 l=180n w=1u m=1
	mpb01 (net158 net158 vdda vdda) pmos1 l=180n w=1u m=1
ends OPAMP1_variant800

subckt OPAMP1_variant801 inn inp out pd xpd vdda vssa
	xd1 (vssa vdda) prim_nwd AREA=6.13907e-9 PJ=476.6e-6 m=1
	xi0 (vssa net69) prim_nd AREA=1e-12 PJ=4e-6 m=1
	xi3 (net51 vdda) prim_pd AREA=8.7e-09 PJ=9.7e-05 m=1
	xr0 (vssa vdda net51) prim_rdiffp l=2.1e-6 w=700e-9 m=1
	xr1 (vdda vdda net69) prim_rdiffp l=2.1e-6 w=700e-9 m=1
	xcc01 (net12 out) prim_cpoly c=6.3e-13p m=1
	mnm12 (net13 net56 vssa vssa) nmos1 l=2.1e-07n w=7.2e-07u m=1
	mnm11 (net56 net56 vssa vssa) nmos1 l=180n w=1u m=1
	mnb02 (net27 net27 net21 vssa) nmos1 l=180n w=1u m=1
	mnpd1 (net21 xpd vssa vssa) nmos1 l=180n w=1u m=1
	mn001 (out net13 vssa vssa) nmos1 l=1.4e-07n w=1.0e-06u m=1
	mnpd2 (net13 pd vssa vssa) nmos1 l=180n w=1u m=1
	mnc01 (net13 net69 net12 vssa) nmos1 l=180n w=1u m=1
	mpb02 (net27 net51 net158 vdda) pmos1 l=180n w=1u m=1
	mppd1 (net158 xpd vdda vdda) pmos1 l=180n w=1u m=1
	mps11 (net31 net158 vdda vdda) pmos1 l=180n w=1u m=1
	mpd11 (net56 inn net31 net31) pmos1 l=180n w=1u m=1
	mp001 (out net158 vdda vdda) pmos1 l=180n w=1u m=1
	mpd12 (net13 inp net31 net31) pmos1 l=180n w=1u m=1
	mpb01 (net158 net158 vdda vdda) pmos1 l=180n w=1u m=1
ends OPAMP1_variant801

subckt OPAMP1_variant802 inn inp out pd xpd vdda vssa
	xd1 (vssa vdda) prim_nwd AREA=4.8e-09 PJ=8.7e-05 m=1
	xi0 (vssa net69) prim_nd AREA=1e-12 PJ=4e-6 m=1
	xi3 (net51 vdda) prim_pd AREA=790e-15 PJ=3.3e-6 m=1
	xr0 (vssa vdda net51) prim_rdiffp l=2.1e-6 w=700e-9 m=1
	xr1 (vdda vdda net69) prim_rdiffp l=2.1e-6 w=700e-9 m=1
	xcc01 (net12 out) prim_cpoly c=1.8e-12p m=1
	mnm12 (net13 net56 vssa vssa) nmos1 l=180n w=1u m=1
	mnm11 (net56 net56 vssa vssa) nmos1 l=180n w=1u m=1
	mnb02 (net27 net27 net21 vssa) nmos1 l=180n w=1u m=1
	mnpd1 (net21 xpd vssa vssa) nmos1 l=180n w=1u m=1
	mn001 (out net13 vssa vssa) nmos1 l=180n w=1u m=1
	mnpd2 (net13 pd vssa vssa) nmos1 l=180n w=1u m=1
	mnc01 (net13 net69 net12 vssa) nmos1 l=180n w=1u m=1
	mpb02 (net27 net51 net158 vdda) pmos1 l=180n w=1u m=1
	mppd1 (net158 xpd vdda vdda) pmos1 l=180n w=1u m=1
	mps11 (net31 net158 vdda vdda) pmos1 l=180n w=1u m=1
	mpd11 (net56 inn net31 net31) pmos1 l=180n w=1u m=1
	mp001 (out net158 vdda vdda) pmos1 l=180n w=1u m=1
	mpd12 (net13 inp net31 net31) pmos1 l=180n w=1u m=1
	mpb01 (net158 net158 vdda vdda) pmos1 l=180n w=1u m=1
ends OPAMP1_variant802

subckt OPAMP1_variant803 inn inp out pd xpd vdda vssa
	xd1 (vssa vdda) prim_nwd AREA=6.13907e-9 PJ=476.6e-6 m=1
	xi0 (vssa net69) prim_nd AREA=7.1e-09 PJ=4.3e-05 m=1
	xi3 (net51 vdda) prim_pd AREA=790e-15 PJ=3.3e-6 m=1
	xr0 (vssa vdda net51) prim_rdiffp l=2.1e-6 w=700e-9 m=1
	xr1 (vdda vdda net69) prim_rdiffp l=2.1e-6 w=700e-9 m=1
	xcc01 (net12 out) prim_cpoly c=1p m=1
	mnm12 (net13 net56 vssa vssa) nmos1 l=2.8e-07n w=1.6e-06u m=1
	mnm11 (net56 net56 vssa vssa) nmos1 l=180n w=1u m=1
	mnb02 (net27 net27 net21 vssa) nmos1 l=180n w=1u m=1
	mnpd1 (net21 xpd vssa vssa) nmos1 l=180n w=1u m=1
	mn001 (out net13 vssa vssa) nmos1 l=180n w=1u m=1
	mnpd2 (net13 pd vssa vssa) nmos1 l=180n w=1u m=1
	mnc01 (net13 net69 net12 vssa) nmos1 l=180n w=1u m=1
	mpb02 (net27 net51 net158 vdda) pmos1 l=2.5e-07n w=1.1e-06u m=1
	mppd1 (net158 xpd vdda vdda) pmos1 l=180n w=1u m=1
	mps11 (net31 net158 vdda vdda) pmos1 l=180n w=1u m=1
	mpd11 (net56 inn net31 net31) pmos1 l=180n w=1u m=1
	mp001 (out net158 vdda vdda) pmos1 l=180n w=1u m=1
	mpd12 (net13 inp net31 net31) pmos1 l=180n w=1u m=1
	mpb01 (net158 net158 vdda vdda) pmos1 l=180n w=1u m=1
ends OPAMP1_variant803

subckt OPAMP1_variant804 inn inp out pd xpd vdda vssa
	xd1 (vssa vdda) prim_nwd AREA=6.13907e-9 PJ=476.6e-6 m=1
	xi0 (vssa net69) prim_nd AREA=1e-12 PJ=4e-6 m=1
	xi3 (net51 vdda) prim_pd AREA=790e-15 PJ=3.3e-6 m=1
	xr0 (vssa vdda net51) prim_rdiffp l=1.3e-07 w=1.5e-06 m=1
	xr1 (vdda vdda net69) prim_rdiffp l=2.1e-6 w=700e-9 m=1
	xcc01 (net12 out) prim_cpoly c=1p m=1
	mnm12 (net13 net56 vssa vssa) nmos1 l=1.0e-07n w=1.4e-06u m=1
	mnm11 (net56 net56 vssa vssa) nmos1 l=180n w=1u m=1
	mnb02 (net27 net27 net21 vssa) nmos1 l=180n w=1u m=1
	mnpd1 (net21 xpd vssa vssa) nmos1 l=180n w=1u m=1
	mn001 (out net13 vssa vssa) nmos1 l=180n w=1u m=1
	mnpd2 (net13 pd vssa vssa) nmos1 l=180n w=1u m=1
	mnc01 (net13 net69 net12 vssa) nmos1 l=180n w=1u m=1
	mpb02 (net27 net51 net158 vdda) pmos1 l=2.7e-07n w=6.0e-07u m=1
	mppd1 (net158 xpd vdda vdda) pmos1 l=180n w=1u m=1
	mps11 (net31 net158 vdda vdda) pmos1 l=180n w=1u m=1
	mpd11 (net56 inn net31 net31) pmos1 l=180n w=1u m=1
	mp001 (out net158 vdda vdda) pmos1 l=180n w=1u m=1
	mpd12 (net13 inp net31 net31) pmos1 l=2.2e-07n w=1.5e-06u m=1
	mpb01 (net158 net158 vdda vdda) pmos1 l=2.0e-07n w=8.5e-07u m=1
ends OPAMP1_variant804

subckt OPAMP1_variant805 inn inp out pd xpd vdda vssa
	xd1 (vssa vdda) prim_nwd AREA=6.13907e-9 PJ=476.6e-6 m=1
	xi0 (vssa net69) prim_nd AREA=1e-12 PJ=4e-6 m=1
	xi3 (net51 vdda) prim_pd AREA=790e-15 PJ=3.3e-6 m=1
	xr0 (vssa vdda net51) prim_rdiffp l=2.1e-6 w=700e-9 m=1
	xr1 (vdda vdda net69) prim_rdiffp l=2.1e-6 w=700e-9 m=1
	xcc01 (net12 out) prim_cpoly c=1p m=1
	mnm12 (net13 net56 vssa vssa) nmos1 l=180n w=1u m=1
	mnm11 (net56 net56 vssa vssa) nmos1 l=1.6e-07n w=1.3e-06u m=1
	mnb02 (net27 net27 net21 vssa) nmos1 l=180n w=1u m=1
	mnpd1 (net21 xpd vssa vssa) nmos1 l=180n w=1u m=1
	mn001 (out net13 vssa vssa) nmos1 l=1.6e-07n w=1.5e-06u m=1
	mnpd2 (net13 pd vssa vssa) nmos1 l=1.5e-07n w=5.5e-07u m=1
	mnc01 (net13 net69 net12 vssa) nmos1 l=180n w=1u m=1
	mpb02 (net27 net51 net158 vdda) pmos1 l=2.9e-07n w=7.3e-07u m=1
	mppd1 (net158 xpd vdda vdda) pmos1 l=180n w=1u m=1
	mps11 (net31 net158 vdda vdda) pmos1 l=180n w=1u m=1
	mpd11 (net56 inn net31 net31) pmos1 l=180n w=1u m=1
	mp001 (out net158 vdda vdda) pmos1 l=2.9e-07n w=8.6e-07u m=1
	mpd12 (net13 inp net31 net31) pmos1 l=180n w=1u m=1
	mpb01 (net158 net158 vdda vdda) pmos1 l=180n w=1u m=1
ends OPAMP1_variant805

subckt OPAMP1_variant806 inn inp out pd xpd vdda vssa
	xd1 (vssa vdda) prim_nwd AREA=6.13907e-9 PJ=476.6e-6 m=1
	xi0 (vssa net69) prim_nd AREA=1e-12 PJ=4e-6 m=1
	xi3 (net51 vdda) prim_pd AREA=5.3e-09 PJ=1.8e-05 m=1
	xr0 (vssa vdda net51) prim_rdiffp l=2.1e-6 w=700e-9 m=1
	xr1 (vdda vdda net69) prim_rdiffp l=2.1e-6 w=700e-9 m=1
	xcc01 (net12 out) prim_cpoly c=1p m=1
	mnm12 (net13 net56 vssa vssa) nmos1 l=180n w=1u m=1
	mnm11 (net56 net56 vssa vssa) nmos1 l=180n w=1u m=1
	mnb02 (net27 net27 net21 vssa) nmos1 l=180n w=1u m=1
	mnpd1 (net21 xpd vssa vssa) nmos1 l=180n w=1u m=1
	mn001 (out net13 vssa vssa) nmos1 l=180n w=1u m=1
	mnpd2 (net13 pd vssa vssa) nmos1 l=180n w=1u m=1
	mnc01 (net13 net69 net12 vssa) nmos1 l=180n w=1u m=1
	mpb02 (net27 net51 net158 vdda) pmos1 l=180n w=1u m=1
	mppd1 (net158 xpd vdda vdda) pmos1 l=180n w=1u m=1
	mps11 (net31 net158 vdda vdda) pmos1 l=180n w=1u m=1
	mpd11 (net56 inn net31 net31) pmos1 l=180n w=1u m=1
	mp001 (out net158 vdda vdda) pmos1 l=1.4e-07n w=5.9e-07u m=1
	mpd12 (net13 inp net31 net31) pmos1 l=180n w=1u m=1
	mpb01 (net158 net158 vdda vdda) pmos1 l=180n w=1u m=1
ends OPAMP1_variant806

subckt OPAMP1_variant807 inn inp out pd xpd vdda vssa
	xd1 (vssa vdda) prim_nwd AREA=6.13907e-9 PJ=476.6e-6 m=1
	xi0 (vssa net69) prim_nd AREA=1e-12 PJ=4e-6 m=1
	xi3 (net51 vdda) prim_pd AREA=2.6e-09 PJ=8.4e-05 m=1
	xr0 (vssa vdda net51) prim_rdiffp l=1.2e-07 w=1.4e-06 m=1
	xr1 (vdda vdda net69) prim_rdiffp l=2.1e-6 w=700e-9 m=1
	xcc01 (net12 out) prim_cpoly c=1p m=1
	mnm12 (net13 net56 vssa vssa) nmos1 l=180n w=1u m=1
	mnm11 (net56 net56 vssa vssa) nmos1 l=180n w=1u m=1
	mnb02 (net27 net27 net21 vssa) nmos1 l=180n w=1u m=1
	mnpd1 (net21 xpd vssa vssa) nmos1 l=1.8e-07n w=1.2e-06u m=1
	mn001 (out net13 vssa vssa) nmos1 l=180n w=1u m=1
	mnpd2 (net13 pd vssa vssa) nmos1 l=180n w=1u m=1
	mnc01 (net13 net69 net12 vssa) nmos1 l=180n w=1u m=1
	mpb02 (net27 net51 net158 vdda) pmos1 l=1.8e-07n w=5.5e-07u m=1
	mppd1 (net158 xpd vdda vdda) pmos1 l=180n w=1u m=1
	mps11 (net31 net158 vdda vdda) pmos1 l=180n w=1u m=1
	mpd11 (net56 inn net31 net31) pmos1 l=180n w=1u m=1
	mp001 (out net158 vdda vdda) pmos1 l=180n w=1u m=1
	mpd12 (net13 inp net31 net31) pmos1 l=180n w=1u m=1
	mpb01 (net158 net158 vdda vdda) pmos1 l=180n w=1u m=1
ends OPAMP1_variant807

subckt OPAMP1_variant808 inn inp out pd xpd vdda vssa
	xd1 (vssa vdda) prim_nwd AREA=6.13907e-9 PJ=476.6e-6 m=1
	xi0 (vssa net69) prim_nd AREA=7.8e-10 PJ=9.7e-05 m=1
	xi3 (net51 vdda) prim_pd AREA=790e-15 PJ=3.3e-6 m=1
	xr0 (vssa vdda net51) prim_rdiffp l=2.1e-6 w=700e-9 m=1
	xr1 (vdda vdda net69) prim_rdiffp l=2.1e-6 w=700e-9 m=1
	xcc01 (net12 out) prim_cpoly c=1p m=1
	mnm12 (net13 net56 vssa vssa) nmos1 l=180n w=1u m=1
	mnm11 (net56 net56 vssa vssa) nmos1 l=2.5e-07n w=6.0e-07u m=1
	mnb02 (net27 net27 net21 vssa) nmos1 l=180n w=1u m=1
	mnpd1 (net21 xpd vssa vssa) nmos1 l=180n w=1u m=1
	mn001 (out net13 vssa vssa) nmos1 l=180n w=1u m=1
	mnpd2 (net13 pd vssa vssa) nmos1 l=180n w=1u m=1
	mnc01 (net13 net69 net12 vssa) nmos1 l=180n w=1u m=1
	mpb02 (net27 net51 net158 vdda) pmos1 l=180n w=1u m=1
	mppd1 (net158 xpd vdda vdda) pmos1 l=180n w=1u m=1
	mps11 (net31 net158 vdda vdda) pmos1 l=1.7e-07n w=1.7e-06u m=1
	mpd11 (net56 inn net31 net31) pmos1 l=180n w=1u m=1
	mp001 (out net158 vdda vdda) pmos1 l=180n w=1u m=1
	mpd12 (net13 inp net31 net31) pmos1 l=1.5e-07n w=1.6e-06u m=1
	mpb01 (net158 net158 vdda vdda) pmos1 l=180n w=1u m=1
ends OPAMP1_variant808

subckt OPAMP1_variant809 inn inp out pd xpd vdda vssa
	xd1 (vssa vdda) prim_nwd AREA=6.13907e-9 PJ=476.6e-6 m=1
	xi0 (vssa net69) prim_nd AREA=1e-12 PJ=4e-6 m=1
	xi3 (net51 vdda) prim_pd AREA=790e-15 PJ=3.3e-6 m=1
	xr0 (vssa vdda net51) prim_rdiffp l=2.1e-6 w=700e-9 m=1
	xr1 (vdda vdda net69) prim_rdiffp l=2.1e-6 w=700e-9 m=1
	xcc01 (net12 out) prim_cpoly c=1p m=1
	mnm12 (net13 net56 vssa vssa) nmos1 l=180n w=1u m=1
	mnm11 (net56 net56 vssa vssa) nmos1 l=180n w=1u m=1
	mnb02 (net27 net27 net21 vssa) nmos1 l=180n w=1u m=1
	mnpd1 (net21 xpd vssa vssa) nmos1 l=180n w=1u m=1
	mn001 (out net13 vssa vssa) nmos1 l=180n w=1u m=1
	mnpd2 (net13 pd vssa vssa) nmos1 l=2.7e-07n w=1.1e-06u m=1
	mnc01 (net13 net69 net12 vssa) nmos1 l=2.5e-07n w=5.4e-07u m=1
	mpb02 (net27 net51 net158 vdda) pmos1 l=180n w=1u m=1
	mppd1 (net158 xpd vdda vdda) pmos1 l=180n w=1u m=1
	mps11 (net31 net158 vdda vdda) pmos1 l=180n w=1u m=1
	mpd11 (net56 inn net31 net31) pmos1 l=180n w=1u m=1
	mp001 (out net158 vdda vdda) pmos1 l=180n w=1u m=1
	mpd12 (net13 inp net31 net31) pmos1 l=180n w=1u m=1
	mpb01 (net158 net158 vdda vdda) pmos1 l=180n w=1u m=1
ends OPAMP1_variant809

subckt OPAMP1_variant810 inn inp out pd xpd vdda vssa
	xd1 (vssa vdda) prim_nwd AREA=6.13907e-9 PJ=476.6e-6 m=1
	xi0 (vssa net69) prim_nd AREA=1e-12 PJ=4e-6 m=1
	xi3 (net51 vdda) prim_pd AREA=790e-15 PJ=3.3e-6 m=1
	xr0 (vssa vdda net51) prim_rdiffp l=2.1e-6 w=700e-9 m=1
	xr1 (vdda vdda net69) prim_rdiffp l=2.1e-6 w=700e-9 m=1
	xcc01 (net12 out) prim_cpoly c=1p m=1
	mnm12 (net13 net56 vssa vssa) nmos1 l=180n w=1u m=1
	mnm11 (net56 net56 vssa vssa) nmos1 l=180n w=1u m=1
	mnb02 (net27 net27 net21 vssa) nmos1 l=180n w=1u m=1
	mnpd1 (net21 xpd vssa vssa) nmos1 l=2.6e-07n w=1.8e-06u m=1
	mn001 (out net13 vssa vssa) nmos1 l=180n w=1u m=1
	mnpd2 (net13 pd vssa vssa) nmos1 l=180n w=1u m=1
	mnc01 (net13 net69 net12 vssa) nmos1 l=180n w=1u m=1
	mpb02 (net27 net51 net158 vdda) pmos1 l=180n w=1u m=1
	mppd1 (net158 xpd vdda vdda) pmos1 l=180n w=1u m=1
	mps11 (net31 net158 vdda vdda) pmos1 l=180n w=1u m=1
	mpd11 (net56 inn net31 net31) pmos1 l=180n w=1u m=1
	mp001 (out net158 vdda vdda) pmos1 l=180n w=1u m=1
	mpd12 (net13 inp net31 net31) pmos1 l=180n w=1u m=1
	mpb01 (net158 net158 vdda vdda) pmos1 l=2.7e-07n w=1.8e-06u m=1
ends OPAMP1_variant810

subckt OPAMP1_variant811 inn inp out pd xpd vdda vssa
	xd1 (vssa vdda) prim_nwd AREA=6.13907e-9 PJ=476.6e-6 m=1
	xi0 (vssa net69) prim_nd AREA=1e-12 PJ=4e-6 m=1
	xi3 (net51 vdda) prim_pd AREA=790e-15 PJ=3.3e-6 m=1
	xr0 (vssa vdda net51) prim_rdiffp l=2.1e-6 w=700e-9 m=1
	xr1 (vdda vdda net69) prim_rdiffp l=2.1e-6 w=700e-9 m=1
	xcc01 (net12 out) prim_cpoly c=1p m=1
	mnm12 (net13 net56 vssa vssa) nmos1 l=1.9e-07n w=7.3e-07u m=1
	mnm11 (net56 net56 vssa vssa) nmos1 l=1.4e-07n w=1.6e-06u m=1
	mnb02 (net27 net27 net21 vssa) nmos1 l=2.9e-07n w=1.8e-06u m=1
	mnpd1 (net21 xpd vssa vssa) nmos1 l=180n w=1u m=1
	mn001 (out net13 vssa vssa) nmos1 l=2.1e-07n w=6.2e-07u m=1
	mnpd2 (net13 pd vssa vssa) nmos1 l=180n w=1u m=1
	mnc01 (net13 net69 net12 vssa) nmos1 l=180n w=1u m=1
	mpb02 (net27 net51 net158 vdda) pmos1 l=180n w=1u m=1
	mppd1 (net158 xpd vdda vdda) pmos1 l=180n w=1u m=1
	mps11 (net31 net158 vdda vdda) pmos1 l=180n w=1u m=1
	mpd11 (net56 inn net31 net31) pmos1 l=180n w=1u m=1
	mp001 (out net158 vdda vdda) pmos1 l=180n w=1u m=1
	mpd12 (net13 inp net31 net31) pmos1 l=180n w=1u m=1
	mpb01 (net158 net158 vdda vdda) pmos1 l=180n w=1u m=1
ends OPAMP1_variant811

subckt OPAMP1_variant812 inn inp out pd xpd vdda vssa
	xd1 (vssa vdda) prim_nwd AREA=6.13907e-9 PJ=476.6e-6 m=1
	xi0 (vssa net69) prim_nd AREA=6.5e-09 PJ=1.8e-05 m=1
	xi3 (net51 vdda) prim_pd AREA=790e-15 PJ=3.3e-6 m=1
	xr0 (vssa vdda net51) prim_rdiffp l=2.6e-07 w=1.7e-06 m=1
	xr1 (vdda vdda net69) prim_rdiffp l=2.1e-6 w=700e-9 m=1
	xcc01 (net12 out) prim_cpoly c=1p m=1
	mnm12 (net13 net56 vssa vssa) nmos1 l=180n w=1u m=1
	mnm11 (net56 net56 vssa vssa) nmos1 l=180n w=1u m=1
	mnb02 (net27 net27 net21 vssa) nmos1 l=180n w=1u m=1
	mnpd1 (net21 xpd vssa vssa) nmos1 l=180n w=1u m=1
	mn001 (out net13 vssa vssa) nmos1 l=180n w=1u m=1
	mnpd2 (net13 pd vssa vssa) nmos1 l=180n w=1u m=1
	mnc01 (net13 net69 net12 vssa) nmos1 l=180n w=1u m=1
	mpb02 (net27 net51 net158 vdda) pmos1 l=180n w=1u m=1
	mppd1 (net158 xpd vdda vdda) pmos1 l=180n w=1u m=1
	mps11 (net31 net158 vdda vdda) pmos1 l=180n w=1u m=1
	mpd11 (net56 inn net31 net31) pmos1 l=180n w=1u m=1
	mp001 (out net158 vdda vdda) pmos1 l=180n w=1u m=1
	mpd12 (net13 inp net31 net31) pmos1 l=180n w=1u m=1
	mpb01 (net158 net158 vdda vdda) pmos1 l=180n w=1u m=1
ends OPAMP1_variant812

subckt OPAMP1_variant813 inn inp out pd xpd vdda vssa
	xd1 (vssa vdda) prim_nwd AREA=6.0e-09 PJ=3.8e-05 m=1
	xi0 (vssa net69) prim_nd AREA=1e-12 PJ=4e-6 m=1
	xi3 (net51 vdda) prim_pd AREA=790e-15 PJ=3.3e-6 m=1
	xr0 (vssa vdda net51) prim_rdiffp l=1.5e-07 w=1.2e-06 m=1
	xr1 (vdda vdda net69) prim_rdiffp l=2.1e-6 w=700e-9 m=1
	xcc01 (net12 out) prim_cpoly c=1p m=1
	mnm12 (net13 net56 vssa vssa) nmos1 l=180n w=1u m=1
	mnm11 (net56 net56 vssa vssa) nmos1 l=180n w=1u m=1
	mnb02 (net27 net27 net21 vssa) nmos1 l=1.7e-07n w=7.6e-07u m=1
	mnpd1 (net21 xpd vssa vssa) nmos1 l=180n w=1u m=1
	mn001 (out net13 vssa vssa) nmos1 l=180n w=1u m=1
	mnpd2 (net13 pd vssa vssa) nmos1 l=180n w=1u m=1
	mnc01 (net13 net69 net12 vssa) nmos1 l=180n w=1u m=1
	mpb02 (net27 net51 net158 vdda) pmos1 l=180n w=1u m=1
	mppd1 (net158 xpd vdda vdda) pmos1 l=180n w=1u m=1
	mps11 (net31 net158 vdda vdda) pmos1 l=180n w=1u m=1
	mpd11 (net56 inn net31 net31) pmos1 l=180n w=1u m=1
	mp001 (out net158 vdda vdda) pmos1 l=180n w=1u m=1
	mpd12 (net13 inp net31 net31) pmos1 l=180n w=1u m=1
	mpb01 (net158 net158 vdda vdda) pmos1 l=180n w=1u m=1
ends OPAMP1_variant813

subckt OPAMP1_variant814 inn inp out pd xpd vdda vssa
	xd1 (vssa vdda) prim_nwd AREA=6.13907e-9 PJ=476.6e-6 m=1
	xi0 (vssa net69) prim_nd AREA=1e-12 PJ=4e-6 m=1
	xi3 (net51 vdda) prim_pd AREA=790e-15 PJ=3.3e-6 m=1
	xr0 (vssa vdda net51) prim_rdiffp l=2.1e-6 w=700e-9 m=1
	xr1 (vdda vdda net69) prim_rdiffp l=2.6e-07 w=1.4e-06 m=1
	xcc01 (net12 out) prim_cpoly c=1p m=1
	mnm12 (net13 net56 vssa vssa) nmos1 l=180n w=1u m=1
	mnm11 (net56 net56 vssa vssa) nmos1 l=180n w=1u m=1
	mnb02 (net27 net27 net21 vssa) nmos1 l=180n w=1u m=1
	mnpd1 (net21 xpd vssa vssa) nmos1 l=1.2e-07n w=1.6e-06u m=1
	mn001 (out net13 vssa vssa) nmos1 l=180n w=1u m=1
	mnpd2 (net13 pd vssa vssa) nmos1 l=180n w=1u m=1
	mnc01 (net13 net69 net12 vssa) nmos1 l=180n w=1u m=1
	mpb02 (net27 net51 net158 vdda) pmos1 l=180n w=1u m=1
	mppd1 (net158 xpd vdda vdda) pmos1 l=180n w=1u m=1
	mps11 (net31 net158 vdda vdda) pmos1 l=180n w=1u m=1
	mpd11 (net56 inn net31 net31) pmos1 l=180n w=1u m=1
	mp001 (out net158 vdda vdda) pmos1 l=180n w=1u m=1
	mpd12 (net13 inp net31 net31) pmos1 l=180n w=1u m=1
	mpb01 (net158 net158 vdda vdda) pmos1 l=180n w=1u m=1
ends OPAMP1_variant814

subckt OPAMP1_variant815 inn inp out pd xpd vdda vssa
	xd1 (vssa vdda) prim_nwd AREA=6.13907e-9 PJ=476.6e-6 m=1
	xi0 (vssa net69) prim_nd AREA=1e-12 PJ=4e-6 m=1
	xi3 (net51 vdda) prim_pd AREA=790e-15 PJ=3.3e-6 m=1
	xr0 (vssa vdda net51) prim_rdiffp l=2.1e-6 w=700e-9 m=1
	xr1 (vdda vdda net69) prim_rdiffp l=2.1e-6 w=700e-9 m=1
	xcc01 (net12 out) prim_cpoly c=1p m=1
	mnm12 (net13 net56 vssa vssa) nmos1 l=180n w=1u m=1
	mnm11 (net56 net56 vssa vssa) nmos1 l=180n w=1u m=1
	mnb02 (net27 net27 net21 vssa) nmos1 l=2.4e-07n w=7.9e-07u m=1
	mnpd1 (net21 xpd vssa vssa) nmos1 l=180n w=1u m=1
	mn001 (out net13 vssa vssa) nmos1 l=3.0e-07n w=2.0e-06u m=1
	mnpd2 (net13 pd vssa vssa) nmos1 l=180n w=1u m=1
	mnc01 (net13 net69 net12 vssa) nmos1 l=180n w=1u m=1
	mpb02 (net27 net51 net158 vdda) pmos1 l=180n w=1u m=1
	mppd1 (net158 xpd vdda vdda) pmos1 l=180n w=1u m=1
	mps11 (net31 net158 vdda vdda) pmos1 l=180n w=1u m=1
	mpd11 (net56 inn net31 net31) pmos1 l=180n w=1u m=1
	mp001 (out net158 vdda vdda) pmos1 l=180n w=1u m=1
	mpd12 (net13 inp net31 net31) pmos1 l=180n w=1u m=1
	mpb01 (net158 net158 vdda vdda) pmos1 l=180n w=1u m=1
ends OPAMP1_variant815

subckt OPAMP1_variant816 inn inp out pd xpd vdda vssa
	xd1 (vssa vdda) prim_nwd AREA=6.13907e-9 PJ=476.6e-6 m=1
	xi0 (vssa net69) prim_nd AREA=1e-12 PJ=4e-6 m=1
	xi3 (net51 vdda) prim_pd AREA=790e-15 PJ=3.3e-6 m=1
	xr0 (vssa vdda net51) prim_rdiffp l=2.1e-6 w=700e-9 m=1
	xr1 (vdda vdda net69) prim_rdiffp l=2.1e-6 w=700e-9 m=1
	xcc01 (net12 out) prim_cpoly c=1p m=1
	mnm12 (net13 net56 vssa vssa) nmos1 l=180n w=1u m=1
	mnm11 (net56 net56 vssa vssa) nmos1 l=180n w=1u m=1
	mnb02 (net27 net27 net21 vssa) nmos1 l=1.7e-07n w=1.1e-06u m=1
	mnpd1 (net21 xpd vssa vssa) nmos1 l=180n w=1u m=1
	mn001 (out net13 vssa vssa) nmos1 l=180n w=1u m=1
	mnpd2 (net13 pd vssa vssa) nmos1 l=2.8e-07n w=6.1e-07u m=1
	mnc01 (net13 net69 net12 vssa) nmos1 l=1.3e-07n w=5.7e-07u m=1
	mpb02 (net27 net51 net158 vdda) pmos1 l=180n w=1u m=1
	mppd1 (net158 xpd vdda vdda) pmos1 l=180n w=1u m=1
	mps11 (net31 net158 vdda vdda) pmos1 l=180n w=1u m=1
	mpd11 (net56 inn net31 net31) pmos1 l=180n w=1u m=1
	mp001 (out net158 vdda vdda) pmos1 l=180n w=1u m=1
	mpd12 (net13 inp net31 net31) pmos1 l=180n w=1u m=1
	mpb01 (net158 net158 vdda vdda) pmos1 l=2.5e-07n w=2.0e-06u m=1
ends OPAMP1_variant816

subckt OPAMP1_variant817 inn inp out pd xpd vdda vssa
	xd1 (vssa vdda) prim_nwd AREA=6.13907e-9 PJ=476.6e-6 m=1
	xi0 (vssa net69) prim_nd AREA=1e-12 PJ=4e-6 m=1
	xi3 (net51 vdda) prim_pd AREA=1.2e-09 PJ=3.9e-06 m=1
	xr0 (vssa vdda net51) prim_rdiffp l=2.1e-6 w=700e-9 m=1
	xr1 (vdda vdda net69) prim_rdiffp l=2.1e-6 w=700e-9 m=1
	xcc01 (net12 out) prim_cpoly c=1p m=1
	mnm12 (net13 net56 vssa vssa) nmos1 l=180n w=1u m=1
	mnm11 (net56 net56 vssa vssa) nmos1 l=180n w=1u m=1
	mnb02 (net27 net27 net21 vssa) nmos1 l=180n w=1u m=1
	mnpd1 (net21 xpd vssa vssa) nmos1 l=180n w=1u m=1
	mn001 (out net13 vssa vssa) nmos1 l=180n w=1u m=1
	mnpd2 (net13 pd vssa vssa) nmos1 l=3.0e-07n w=7.4e-07u m=1
	mnc01 (net13 net69 net12 vssa) nmos1 l=2.4e-07n w=5.3e-07u m=1
	mpb02 (net27 net51 net158 vdda) pmos1 l=180n w=1u m=1
	mppd1 (net158 xpd vdda vdda) pmos1 l=180n w=1u m=1
	mps11 (net31 net158 vdda vdda) pmos1 l=180n w=1u m=1
	mpd11 (net56 inn net31 net31) pmos1 l=180n w=1u m=1
	mp001 (out net158 vdda vdda) pmos1 l=180n w=1u m=1
	mpd12 (net13 inp net31 net31) pmos1 l=180n w=1u m=1
	mpb01 (net158 net158 vdda vdda) pmos1 l=180n w=1u m=1
ends OPAMP1_variant817

subckt OPAMP1_variant818 inn inp out pd xpd vdda vssa
	xd1 (vssa vdda) prim_nwd AREA=6.13907e-9 PJ=476.6e-6 m=1
	xi0 (vssa net69) prim_nd AREA=1e-12 PJ=4e-6 m=1
	xi3 (net51 vdda) prim_pd AREA=790e-15 PJ=3.3e-6 m=1
	xr0 (vssa vdda net51) prim_rdiffp l=2.1e-6 w=700e-9 m=1
	xr1 (vdda vdda net69) prim_rdiffp l=2.1e-6 w=700e-9 m=1
	xcc01 (net12 out) prim_cpoly c=1.8e-12p m=1
	mnm12 (net13 net56 vssa vssa) nmos1 l=180n w=1u m=1
	mnm11 (net56 net56 vssa vssa) nmos1 l=2.9e-07n w=1.8e-06u m=1
	mnb02 (net27 net27 net21 vssa) nmos1 l=180n w=1u m=1
	mnpd1 (net21 xpd vssa vssa) nmos1 l=180n w=1u m=1
	mn001 (out net13 vssa vssa) nmos1 l=180n w=1u m=1
	mnpd2 (net13 pd vssa vssa) nmos1 l=180n w=1u m=1
	mnc01 (net13 net69 net12 vssa) nmos1 l=180n w=1u m=1
	mpb02 (net27 net51 net158 vdda) pmos1 l=180n w=1u m=1
	mppd1 (net158 xpd vdda vdda) pmos1 l=1.6e-07n w=6.5e-07u m=1
	mps11 (net31 net158 vdda vdda) pmos1 l=2.3e-07n w=1.0e-06u m=1
	mpd11 (net56 inn net31 net31) pmos1 l=180n w=1u m=1
	mp001 (out net158 vdda vdda) pmos1 l=180n w=1u m=1
	mpd12 (net13 inp net31 net31) pmos1 l=1.6e-07n w=1.8e-06u m=1
	mpb01 (net158 net158 vdda vdda) pmos1 l=180n w=1u m=1
ends OPAMP1_variant818

subckt OPAMP1_variant819 inn inp out pd xpd vdda vssa
	xd1 (vssa vdda) prim_nwd AREA=6.13907e-9 PJ=476.6e-6 m=1
	xi0 (vssa net69) prim_nd AREA=1e-12 PJ=4e-6 m=1
	xi3 (net51 vdda) prim_pd AREA=790e-15 PJ=3.3e-6 m=1
	xr0 (vssa vdda net51) prim_rdiffp l=2.1e-6 w=700e-9 m=1
	xr1 (vdda vdda net69) prim_rdiffp l=1.5e-07 w=1.6e-06 m=1
	xcc01 (net12 out) prim_cpoly c=1p m=1
	mnm12 (net13 net56 vssa vssa) nmos1 l=180n w=1u m=1
	mnm11 (net56 net56 vssa vssa) nmos1 l=180n w=1u m=1
	mnb02 (net27 net27 net21 vssa) nmos1 l=180n w=1u m=1
	mnpd1 (net21 xpd vssa vssa) nmos1 l=180n w=1u m=1
	mn001 (out net13 vssa vssa) nmos1 l=180n w=1u m=1
	mnpd2 (net13 pd vssa vssa) nmos1 l=180n w=1u m=1
	mnc01 (net13 net69 net12 vssa) nmos1 l=180n w=1u m=1
	mpb02 (net27 net51 net158 vdda) pmos1 l=180n w=1u m=1
	mppd1 (net158 xpd vdda vdda) pmos1 l=180n w=1u m=1
	mps11 (net31 net158 vdda vdda) pmos1 l=180n w=1u m=1
	mpd11 (net56 inn net31 net31) pmos1 l=1.4e-07n w=6.3e-07u m=1
	mp001 (out net158 vdda vdda) pmos1 l=1.8e-07n w=1.5e-06u m=1
	mpd12 (net13 inp net31 net31) pmos1 l=1.0e-07n w=1.2e-06u m=1
	mpb01 (net158 net158 vdda vdda) pmos1 l=180n w=1u m=1
ends OPAMP1_variant819

subckt OPAMP1_variant820 inn inp out pd xpd vdda vssa
	xd1 (vssa vdda) prim_nwd AREA=4.5e-09 PJ=1.1e-05 m=1
	xi0 (vssa net69) prim_nd AREA=1e-12 PJ=4e-6 m=1
	xi3 (net51 vdda) prim_pd AREA=790e-15 PJ=3.3e-6 m=1
	xr0 (vssa vdda net51) prim_rdiffp l=2.1e-6 w=700e-9 m=1
	xr1 (vdda vdda net69) prim_rdiffp l=2.1e-6 w=700e-9 m=1
	xcc01 (net12 out) prim_cpoly c=1p m=1
	mnm12 (net13 net56 vssa vssa) nmos1 l=180n w=1u m=1
	mnm11 (net56 net56 vssa vssa) nmos1 l=2.7e-07n w=1.5e-06u m=1
	mnb02 (net27 net27 net21 vssa) nmos1 l=180n w=1u m=1
	mnpd1 (net21 xpd vssa vssa) nmos1 l=180n w=1u m=1
	mn001 (out net13 vssa vssa) nmos1 l=180n w=1u m=1
	mnpd2 (net13 pd vssa vssa) nmos1 l=180n w=1u m=1
	mnc01 (net13 net69 net12 vssa) nmos1 l=180n w=1u m=1
	mpb02 (net27 net51 net158 vdda) pmos1 l=180n w=1u m=1
	mppd1 (net158 xpd vdda vdda) pmos1 l=180n w=1u m=1
	mps11 (net31 net158 vdda vdda) pmos1 l=180n w=1u m=1
	mpd11 (net56 inn net31 net31) pmos1 l=180n w=1u m=1
	mp001 (out net158 vdda vdda) pmos1 l=2.7e-07n w=1.8e-06u m=1
	mpd12 (net13 inp net31 net31) pmos1 l=180n w=1u m=1
	mpb01 (net158 net158 vdda vdda) pmos1 l=180n w=1u m=1
ends OPAMP1_variant820

subckt OPAMP1_variant821 inn inp out pd xpd vdda vssa
	xd1 (vssa vdda) prim_nwd AREA=6.13907e-9 PJ=476.6e-6 m=1
	xi0 (vssa net69) prim_nd AREA=1e-12 PJ=4e-6 m=1
	xi3 (net51 vdda) prim_pd AREA=7.6e-09 PJ=6.1e-05 m=1
	xr0 (vssa vdda net51) prim_rdiffp l=2.1e-6 w=700e-9 m=1
	xr1 (vdda vdda net69) prim_rdiffp l=2.1e-6 w=700e-9 m=1
	xcc01 (net12 out) prim_cpoly c=1p m=1
	mnm12 (net13 net56 vssa vssa) nmos1 l=1.8e-07n w=7.2e-07u m=1
	mnm11 (net56 net56 vssa vssa) nmos1 l=180n w=1u m=1
	mnb02 (net27 net27 net21 vssa) nmos1 l=180n w=1u m=1
	mnpd1 (net21 xpd vssa vssa) nmos1 l=180n w=1u m=1
	mn001 (out net13 vssa vssa) nmos1 l=180n w=1u m=1
	mnpd2 (net13 pd vssa vssa) nmos1 l=1.0e-07n w=1.1e-06u m=1
	mnc01 (net13 net69 net12 vssa) nmos1 l=180n w=1u m=1
	mpb02 (net27 net51 net158 vdda) pmos1 l=1.0e-07n w=6.8e-07u m=1
	mppd1 (net158 xpd vdda vdda) pmos1 l=180n w=1u m=1
	mps11 (net31 net158 vdda vdda) pmos1 l=180n w=1u m=1
	mpd11 (net56 inn net31 net31) pmos1 l=180n w=1u m=1
	mp001 (out net158 vdda vdda) pmos1 l=1.7e-07n w=8.1e-07u m=1
	mpd12 (net13 inp net31 net31) pmos1 l=180n w=1u m=1
	mpb01 (net158 net158 vdda vdda) pmos1 l=180n w=1u m=1
ends OPAMP1_variant821

subckt OPAMP1_variant822 inn inp out pd xpd vdda vssa
	xd1 (vssa vdda) prim_nwd AREA=6.13907e-9 PJ=476.6e-6 m=1
	xi0 (vssa net69) prim_nd AREA=1e-12 PJ=4e-6 m=1
	xi3 (net51 vdda) prim_pd AREA=790e-15 PJ=3.3e-6 m=1
	xr0 (vssa vdda net51) prim_rdiffp l=2.1e-6 w=700e-9 m=1
	xr1 (vdda vdda net69) prim_rdiffp l=2.1e-6 w=700e-9 m=1
	xcc01 (net12 out) prim_cpoly c=1p m=1
	mnm12 (net13 net56 vssa vssa) nmos1 l=180n w=1u m=1
	mnm11 (net56 net56 vssa vssa) nmos1 l=180n w=1u m=1
	mnb02 (net27 net27 net21 vssa) nmos1 l=180n w=1u m=1
	mnpd1 (net21 xpd vssa vssa) nmos1 l=180n w=1u m=1
	mn001 (out net13 vssa vssa) nmos1 l=180n w=1u m=1
	mnpd2 (net13 pd vssa vssa) nmos1 l=180n w=1u m=1
	mnc01 (net13 net69 net12 vssa) nmos1 l=1.2e-07n w=8.3e-07u m=1
	mpb02 (net27 net51 net158 vdda) pmos1 l=180n w=1u m=1
	mppd1 (net158 xpd vdda vdda) pmos1 l=180n w=1u m=1
	mps11 (net31 net158 vdda vdda) pmos1 l=180n w=1u m=1
	mpd11 (net56 inn net31 net31) pmos1 l=180n w=1u m=1
	mp001 (out net158 vdda vdda) pmos1 l=2.8e-07n w=1.3e-06u m=1
	mpd12 (net13 inp net31 net31) pmos1 l=180n w=1u m=1
	mpb01 (net158 net158 vdda vdda) pmos1 l=180n w=1u m=1
ends OPAMP1_variant822

subckt OPAMP1_variant823 inn inp out pd xpd vdda vssa
	xd1 (vssa vdda) prim_nwd AREA=6.13907e-9 PJ=476.6e-6 m=1
	xi0 (vssa net69) prim_nd AREA=1.0e-09 PJ=8.1e-05 m=1
	xi3 (net51 vdda) prim_pd AREA=790e-15 PJ=3.3e-6 m=1
	xr0 (vssa vdda net51) prim_rdiffp l=2.1e-6 w=700e-9 m=1
	xr1 (vdda vdda net69) prim_rdiffp l=2.3e-07 w=5.1e-07 m=1
	xcc01 (net12 out) prim_cpoly c=1p m=1
	mnm12 (net13 net56 vssa vssa) nmos1 l=180n w=1u m=1
	mnm11 (net56 net56 vssa vssa) nmos1 l=180n w=1u m=1
	mnb02 (net27 net27 net21 vssa) nmos1 l=180n w=1u m=1
	mnpd1 (net21 xpd vssa vssa) nmos1 l=1.4e-07n w=7.1e-07u m=1
	mn001 (out net13 vssa vssa) nmos1 l=180n w=1u m=1
	mnpd2 (net13 pd vssa vssa) nmos1 l=180n w=1u m=1
	mnc01 (net13 net69 net12 vssa) nmos1 l=180n w=1u m=1
	mpb02 (net27 net51 net158 vdda) pmos1 l=180n w=1u m=1
	mppd1 (net158 xpd vdda vdda) pmos1 l=180n w=1u m=1
	mps11 (net31 net158 vdda vdda) pmos1 l=180n w=1u m=1
	mpd11 (net56 inn net31 net31) pmos1 l=180n w=1u m=1
	mp001 (out net158 vdda vdda) pmos1 l=2.2e-07n w=1.5e-06u m=1
	mpd12 (net13 inp net31 net31) pmos1 l=180n w=1u m=1
	mpb01 (net158 net158 vdda vdda) pmos1 l=180n w=1u m=1
ends OPAMP1_variant823

subckt OPAMP1_variant824 inn inp out pd xpd vdda vssa
	xd1 (vssa vdda) prim_nwd AREA=6.13907e-9 PJ=476.6e-6 m=1
	xi0 (vssa net69) prim_nd AREA=1e-12 PJ=4e-6 m=1
	xi3 (net51 vdda) prim_pd AREA=790e-15 PJ=3.3e-6 m=1
	xr0 (vssa vdda net51) prim_rdiffp l=2.2e-07 w=6.2e-07 m=1
	xr1 (vdda vdda net69) prim_rdiffp l=2.1e-6 w=700e-9 m=1
	xcc01 (net12 out) prim_cpoly c=1p m=1
	mnm12 (net13 net56 vssa vssa) nmos1 l=180n w=1u m=1
	mnm11 (net56 net56 vssa vssa) nmos1 l=180n w=1u m=1
	mnb02 (net27 net27 net21 vssa) nmos1 l=180n w=1u m=1
	mnpd1 (net21 xpd vssa vssa) nmos1 l=180n w=1u m=1
	mn001 (out net13 vssa vssa) nmos1 l=180n w=1u m=1
	mnpd2 (net13 pd vssa vssa) nmos1 l=180n w=1u m=1
	mnc01 (net13 net69 net12 vssa) nmos1 l=180n w=1u m=1
	mpb02 (net27 net51 net158 vdda) pmos1 l=1.3e-07n w=1.2e-06u m=1
	mppd1 (net158 xpd vdda vdda) pmos1 l=180n w=1u m=1
	mps11 (net31 net158 vdda vdda) pmos1 l=180n w=1u m=1
	mpd11 (net56 inn net31 net31) pmos1 l=180n w=1u m=1
	mp001 (out net158 vdda vdda) pmos1 l=180n w=1u m=1
	mpd12 (net13 inp net31 net31) pmos1 l=180n w=1u m=1
	mpb01 (net158 net158 vdda vdda) pmos1 l=1.3e-07n w=1.6e-06u m=1
ends OPAMP1_variant824

subckt OPAMP1_variant825 inn inp out pd xpd vdda vssa
	xd1 (vssa vdda) prim_nwd AREA=6.13907e-9 PJ=476.6e-6 m=1
	xi0 (vssa net69) prim_nd AREA=1e-12 PJ=4e-6 m=1
	xi3 (net51 vdda) prim_pd AREA=1.2e-09 PJ=1.6e-05 m=1
	xr0 (vssa vdda net51) prim_rdiffp l=2.1e-6 w=700e-9 m=1
	xr1 (vdda vdda net69) prim_rdiffp l=2.1e-6 w=700e-9 m=1
	xcc01 (net12 out) prim_cpoly c=1p m=1
	mnm12 (net13 net56 vssa vssa) nmos1 l=180n w=1u m=1
	mnm11 (net56 net56 vssa vssa) nmos1 l=180n w=1u m=1
	mnb02 (net27 net27 net21 vssa) nmos1 l=180n w=1u m=1
	mnpd1 (net21 xpd vssa vssa) nmos1 l=180n w=1u m=1
	mn001 (out net13 vssa vssa) nmos1 l=2.9e-07n w=1.1e-06u m=1
	mnpd2 (net13 pd vssa vssa) nmos1 l=180n w=1u m=1
	mnc01 (net13 net69 net12 vssa) nmos1 l=180n w=1u m=1
	mpb02 (net27 net51 net158 vdda) pmos1 l=2.0e-07n w=8.3e-07u m=1
	mppd1 (net158 xpd vdda vdda) pmos1 l=180n w=1u m=1
	mps11 (net31 net158 vdda vdda) pmos1 l=180n w=1u m=1
	mpd11 (net56 inn net31 net31) pmos1 l=180n w=1u m=1
	mp001 (out net158 vdda vdda) pmos1 l=180n w=1u m=1
	mpd12 (net13 inp net31 net31) pmos1 l=2.7e-07n w=6.6e-07u m=1
	mpb01 (net158 net158 vdda vdda) pmos1 l=180n w=1u m=1
ends OPAMP1_variant825

subckt OPAMP1_variant826 inn inp out pd xpd vdda vssa
	xd1 (vssa vdda) prim_nwd AREA=6.13907e-9 PJ=476.6e-6 m=1
	xi0 (vssa net69) prim_nd AREA=1e-12 PJ=4e-6 m=1
	xi3 (net51 vdda) prim_pd AREA=790e-15 PJ=3.3e-6 m=1
	xr0 (vssa vdda net51) prim_rdiffp l=2.1e-6 w=700e-9 m=1
	xr1 (vdda vdda net69) prim_rdiffp l=2.1e-6 w=700e-9 m=1
	xcc01 (net12 out) prim_cpoly c=1p m=1
	mnm12 (net13 net56 vssa vssa) nmos1 l=180n w=1u m=1
	mnm11 (net56 net56 vssa vssa) nmos1 l=180n w=1u m=1
	mnb02 (net27 net27 net21 vssa) nmos1 l=180n w=1u m=1
	mnpd1 (net21 xpd vssa vssa) nmos1 l=2.6e-07n w=5.4e-07u m=1
	mn001 (out net13 vssa vssa) nmos1 l=2.5e-07n w=7.4e-07u m=1
	mnpd2 (net13 pd vssa vssa) nmos1 l=180n w=1u m=1
	mnc01 (net13 net69 net12 vssa) nmos1 l=1.2e-07n w=1.9e-06u m=1
	mpb02 (net27 net51 net158 vdda) pmos1 l=180n w=1u m=1
	mppd1 (net158 xpd vdda vdda) pmos1 l=180n w=1u m=1
	mps11 (net31 net158 vdda vdda) pmos1 l=180n w=1u m=1
	mpd11 (net56 inn net31 net31) pmos1 l=180n w=1u m=1
	mp001 (out net158 vdda vdda) pmos1 l=180n w=1u m=1
	mpd12 (net13 inp net31 net31) pmos1 l=180n w=1u m=1
	mpb01 (net158 net158 vdda vdda) pmos1 l=180n w=1u m=1
ends OPAMP1_variant826

subckt OPAMP1_variant827 inn inp out pd xpd vdda vssa
	xd1 (vssa vdda) prim_nwd AREA=6.13907e-9 PJ=476.6e-6 m=1
	xi0 (vssa net69) prim_nd AREA=1e-12 PJ=4e-6 m=1
	xi3 (net51 vdda) prim_pd AREA=790e-15 PJ=3.3e-6 m=1
	xr0 (vssa vdda net51) prim_rdiffp l=2.1e-6 w=700e-9 m=1
	xr1 (vdda vdda net69) prim_rdiffp l=2.1e-6 w=700e-9 m=1
	xcc01 (net12 out) prim_cpoly c=1p m=1
	mnm12 (net13 net56 vssa vssa) nmos1 l=180n w=1u m=1
	mnm11 (net56 net56 vssa vssa) nmos1 l=180n w=1u m=1
	mnb02 (net27 net27 net21 vssa) nmos1 l=180n w=1u m=1
	mnpd1 (net21 xpd vssa vssa) nmos1 l=180n w=1u m=1
	mn001 (out net13 vssa vssa) nmos1 l=180n w=1u m=1
	mnpd2 (net13 pd vssa vssa) nmos1 l=180n w=1u m=1
	mnc01 (net13 net69 net12 vssa) nmos1 l=180n w=1u m=1
	mpb02 (net27 net51 net158 vdda) pmos1 l=180n w=1u m=1
	mppd1 (net158 xpd vdda vdda) pmos1 l=2.8e-07n w=7.8e-07u m=1
	mps11 (net31 net158 vdda vdda) pmos1 l=180n w=1u m=1
	mpd11 (net56 inn net31 net31) pmos1 l=2.4e-07n w=8.2e-07u m=1
	mp001 (out net158 vdda vdda) pmos1 l=180n w=1u m=1
	mpd12 (net13 inp net31 net31) pmos1 l=180n w=1u m=1
	mpb01 (net158 net158 vdda vdda) pmos1 l=2.0e-07n w=1.7e-06u m=1
ends OPAMP1_variant827

subckt OPAMP1_variant828 inn inp out pd xpd vdda vssa
	xd1 (vssa vdda) prim_nwd AREA=2.7e-09 PJ=5.9e-06 m=1
	xi0 (vssa net69) prim_nd AREA=1e-12 PJ=4e-6 m=1
	xi3 (net51 vdda) prim_pd AREA=790e-15 PJ=3.3e-6 m=1
	xr0 (vssa vdda net51) prim_rdiffp l=2.1e-6 w=700e-9 m=1
	xr1 (vdda vdda net69) prim_rdiffp l=2.1e-6 w=700e-9 m=1
	xcc01 (net12 out) prim_cpoly c=1p m=1
	mnm12 (net13 net56 vssa vssa) nmos1 l=180n w=1u m=1
	mnm11 (net56 net56 vssa vssa) nmos1 l=180n w=1u m=1
	mnb02 (net27 net27 net21 vssa) nmos1 l=180n w=1u m=1
	mnpd1 (net21 xpd vssa vssa) nmos1 l=180n w=1u m=1
	mn001 (out net13 vssa vssa) nmos1 l=180n w=1u m=1
	mnpd2 (net13 pd vssa vssa) nmos1 l=180n w=1u m=1
	mnc01 (net13 net69 net12 vssa) nmos1 l=180n w=1u m=1
	mpb02 (net27 net51 net158 vdda) pmos1 l=1.0e-07n w=5.4e-07u m=1
	mppd1 (net158 xpd vdda vdda) pmos1 l=180n w=1u m=1
	mps11 (net31 net158 vdda vdda) pmos1 l=180n w=1u m=1
	mpd11 (net56 inn net31 net31) pmos1 l=180n w=1u m=1
	mp001 (out net158 vdda vdda) pmos1 l=180n w=1u m=1
	mpd12 (net13 inp net31 net31) pmos1 l=180n w=1u m=1
	mpb01 (net158 net158 vdda vdda) pmos1 l=180n w=1u m=1
ends OPAMP1_variant828

subckt OPAMP1_variant829 inn inp out pd xpd vdda vssa
	xd1 (vssa vdda) prim_nwd AREA=6.13907e-9 PJ=476.6e-6 m=1
	xi0 (vssa net69) prim_nd AREA=1e-12 PJ=4e-6 m=1
	xi3 (net51 vdda) prim_pd AREA=790e-15 PJ=3.3e-6 m=1
	xr0 (vssa vdda net51) prim_rdiffp l=2.1e-6 w=700e-9 m=1
	xr1 (vdda vdda net69) prim_rdiffp l=2.8e-07 w=6.6e-07 m=1
	xcc01 (net12 out) prim_cpoly c=1.8e-12p m=1
	mnm12 (net13 net56 vssa vssa) nmos1 l=180n w=1u m=1
	mnm11 (net56 net56 vssa vssa) nmos1 l=180n w=1u m=1
	mnb02 (net27 net27 net21 vssa) nmos1 l=180n w=1u m=1
	mnpd1 (net21 xpd vssa vssa) nmos1 l=180n w=1u m=1
	mn001 (out net13 vssa vssa) nmos1 l=180n w=1u m=1
	mnpd2 (net13 pd vssa vssa) nmos1 l=180n w=1u m=1
	mnc01 (net13 net69 net12 vssa) nmos1 l=180n w=1u m=1
	mpb02 (net27 net51 net158 vdda) pmos1 l=180n w=1u m=1
	mppd1 (net158 xpd vdda vdda) pmos1 l=180n w=1u m=1
	mps11 (net31 net158 vdda vdda) pmos1 l=180n w=1u m=1
	mpd11 (net56 inn net31 net31) pmos1 l=180n w=1u m=1
	mp001 (out net158 vdda vdda) pmos1 l=180n w=1u m=1
	mpd12 (net13 inp net31 net31) pmos1 l=1.2e-07n w=1.3e-06u m=1
	mpb01 (net158 net158 vdda vdda) pmos1 l=180n w=1u m=1
ends OPAMP1_variant829

subckt OPAMP1_variant830 inn inp out pd xpd vdda vssa
	xd1 (vssa vdda) prim_nwd AREA=6.13907e-9 PJ=476.6e-6 m=1
	xi0 (vssa net69) prim_nd AREA=1e-12 PJ=4e-6 m=1
	xi3 (net51 vdda) prim_pd AREA=790e-15 PJ=3.3e-6 m=1
	xr0 (vssa vdda net51) prim_rdiffp l=2.1e-6 w=700e-9 m=1
	xr1 (vdda vdda net69) prim_rdiffp l=2.1e-6 w=700e-9 m=1
	xcc01 (net12 out) prim_cpoly c=1p m=1
	mnm12 (net13 net56 vssa vssa) nmos1 l=1.3e-07n w=1.0e-06u m=1
	mnm11 (net56 net56 vssa vssa) nmos1 l=180n w=1u m=1
	mnb02 (net27 net27 net21 vssa) nmos1 l=2.2e-07n w=8.1e-07u m=1
	mnpd1 (net21 xpd vssa vssa) nmos1 l=180n w=1u m=1
	mn001 (out net13 vssa vssa) nmos1 l=180n w=1u m=1
	mnpd2 (net13 pd vssa vssa) nmos1 l=180n w=1u m=1
	mnc01 (net13 net69 net12 vssa) nmos1 l=180n w=1u m=1
	mpb02 (net27 net51 net158 vdda) pmos1 l=1.3e-07n w=1.0e-06u m=1
	mppd1 (net158 xpd vdda vdda) pmos1 l=180n w=1u m=1
	mps11 (net31 net158 vdda vdda) pmos1 l=2.7e-07n w=5.6e-07u m=1
	mpd11 (net56 inn net31 net31) pmos1 l=180n w=1u m=1
	mp001 (out net158 vdda vdda) pmos1 l=180n w=1u m=1
	mpd12 (net13 inp net31 net31) pmos1 l=180n w=1u m=1
	mpb01 (net158 net158 vdda vdda) pmos1 l=180n w=1u m=1
ends OPAMP1_variant830

subckt OPAMP1_variant831 inn inp out pd xpd vdda vssa
	xd1 (vssa vdda) prim_nwd AREA=6.13907e-9 PJ=476.6e-6 m=1
	xi0 (vssa net69) prim_nd AREA=1e-12 PJ=4e-6 m=1
	xi3 (net51 vdda) prim_pd AREA=790e-15 PJ=3.3e-6 m=1
	xr0 (vssa vdda net51) prim_rdiffp l=2.2e-07 w=1.1e-06 m=1
	xr1 (vdda vdda net69) prim_rdiffp l=2.1e-6 w=700e-9 m=1
	xcc01 (net12 out) prim_cpoly c=1p m=1
	mnm12 (net13 net56 vssa vssa) nmos1 l=180n w=1u m=1
	mnm11 (net56 net56 vssa vssa) nmos1 l=1.1e-07n w=1.6e-06u m=1
	mnb02 (net27 net27 net21 vssa) nmos1 l=180n w=1u m=1
	mnpd1 (net21 xpd vssa vssa) nmos1 l=180n w=1u m=1
	mn001 (out net13 vssa vssa) nmos1 l=180n w=1u m=1
	mnpd2 (net13 pd vssa vssa) nmos1 l=180n w=1u m=1
	mnc01 (net13 net69 net12 vssa) nmos1 l=180n w=1u m=1
	mpb02 (net27 net51 net158 vdda) pmos1 l=180n w=1u m=1
	mppd1 (net158 xpd vdda vdda) pmos1 l=180n w=1u m=1
	mps11 (net31 net158 vdda vdda) pmos1 l=180n w=1u m=1
	mpd11 (net56 inn net31 net31) pmos1 l=180n w=1u m=1
	mp001 (out net158 vdda vdda) pmos1 l=1.5e-07n w=1.7e-06u m=1
	mpd12 (net13 inp net31 net31) pmos1 l=180n w=1u m=1
	mpb01 (net158 net158 vdda vdda) pmos1 l=180n w=1u m=1
ends OPAMP1_variant831

subckt OPAMP1_variant832 inn inp out pd xpd vdda vssa
	xd1 (vssa vdda) prim_nwd AREA=3.7e-09 PJ=7.8e-05 m=1
	xi0 (vssa net69) prim_nd AREA=1.3e-09 PJ=3.6e-05 m=1
	xi3 (net51 vdda) prim_pd AREA=790e-15 PJ=3.3e-6 m=1
	xr0 (vssa vdda net51) prim_rdiffp l=2.1e-6 w=700e-9 m=1
	xr1 (vdda vdda net69) prim_rdiffp l=2.1e-6 w=700e-9 m=1
	xcc01 (net12 out) prim_cpoly c=1p m=1
	mnm12 (net13 net56 vssa vssa) nmos1 l=180n w=1u m=1
	mnm11 (net56 net56 vssa vssa) nmos1 l=180n w=1u m=1
	mnb02 (net27 net27 net21 vssa) nmos1 l=180n w=1u m=1
	mnpd1 (net21 xpd vssa vssa) nmos1 l=180n w=1u m=1
	mn001 (out net13 vssa vssa) nmos1 l=180n w=1u m=1
	mnpd2 (net13 pd vssa vssa) nmos1 l=180n w=1u m=1
	mnc01 (net13 net69 net12 vssa) nmos1 l=180n w=1u m=1
	mpb02 (net27 net51 net158 vdda) pmos1 l=180n w=1u m=1
	mppd1 (net158 xpd vdda vdda) pmos1 l=180n w=1u m=1
	mps11 (net31 net158 vdda vdda) pmos1 l=1.2e-07n w=1.7e-06u m=1
	mpd11 (net56 inn net31 net31) pmos1 l=2.6e-07n w=1.5e-06u m=1
	mp001 (out net158 vdda vdda) pmos1 l=2.8e-07n w=1.6e-06u m=1
	mpd12 (net13 inp net31 net31) pmos1 l=180n w=1u m=1
	mpb01 (net158 net158 vdda vdda) pmos1 l=180n w=1u m=1
ends OPAMP1_variant832

subckt OPAMP1_variant833 inn inp out pd xpd vdda vssa
	xd1 (vssa vdda) prim_nwd AREA=6.13907e-9 PJ=476.6e-6 m=1
	xi0 (vssa net69) prim_nd AREA=1e-12 PJ=4e-6 m=1
	xi3 (net51 vdda) prim_pd AREA=790e-15 PJ=3.3e-6 m=1
	xr0 (vssa vdda net51) prim_rdiffp l=2.4e-07 w=1.8e-06 m=1
	xr1 (vdda vdda net69) prim_rdiffp l=2.1e-6 w=700e-9 m=1
	xcc01 (net12 out) prim_cpoly c=1p m=1
	mnm12 (net13 net56 vssa vssa) nmos1 l=180n w=1u m=1
	mnm11 (net56 net56 vssa vssa) nmos1 l=180n w=1u m=1
	mnb02 (net27 net27 net21 vssa) nmos1 l=180n w=1u m=1
	mnpd1 (net21 xpd vssa vssa) nmos1 l=180n w=1u m=1
	mn001 (out net13 vssa vssa) nmos1 l=180n w=1u m=1
	mnpd2 (net13 pd vssa vssa) nmos1 l=180n w=1u m=1
	mnc01 (net13 net69 net12 vssa) nmos1 l=180n w=1u m=1
	mpb02 (net27 net51 net158 vdda) pmos1 l=1.8e-07n w=7.5e-07u m=1
	mppd1 (net158 xpd vdda vdda) pmos1 l=180n w=1u m=1
	mps11 (net31 net158 vdda vdda) pmos1 l=1.9e-07n w=9.2e-07u m=1
	mpd11 (net56 inn net31 net31) pmos1 l=180n w=1u m=1
	mp001 (out net158 vdda vdda) pmos1 l=180n w=1u m=1
	mpd12 (net13 inp net31 net31) pmos1 l=180n w=1u m=1
	mpb01 (net158 net158 vdda vdda) pmos1 l=180n w=1u m=1
ends OPAMP1_variant833

subckt OPAMP1_variant834 inn inp out pd xpd vdda vssa
	xd1 (vssa vdda) prim_nwd AREA=6.13907e-9 PJ=476.6e-6 m=1
	xi0 (vssa net69) prim_nd AREA=7.1e-09 PJ=4.3e-06 m=1
	xi3 (net51 vdda) prim_pd AREA=790e-15 PJ=3.3e-6 m=1
	xr0 (vssa vdda net51) prim_rdiffp l=2.7e-07 w=7.9e-07 m=1
	xr1 (vdda vdda net69) prim_rdiffp l=2.1e-6 w=700e-9 m=1
	xcc01 (net12 out) prim_cpoly c=1p m=1
	mnm12 (net13 net56 vssa vssa) nmos1 l=1.8e-07n w=5.4e-07u m=1
	mnm11 (net56 net56 vssa vssa) nmos1 l=180n w=1u m=1
	mnb02 (net27 net27 net21 vssa) nmos1 l=180n w=1u m=1
	mnpd1 (net21 xpd vssa vssa) nmos1 l=180n w=1u m=1
	mn001 (out net13 vssa vssa) nmos1 l=180n w=1u m=1
	mnpd2 (net13 pd vssa vssa) nmos1 l=180n w=1u m=1
	mnc01 (net13 net69 net12 vssa) nmos1 l=180n w=1u m=1
	mpb02 (net27 net51 net158 vdda) pmos1 l=180n w=1u m=1
	mppd1 (net158 xpd vdda vdda) pmos1 l=180n w=1u m=1
	mps11 (net31 net158 vdda vdda) pmos1 l=180n w=1u m=1
	mpd11 (net56 inn net31 net31) pmos1 l=180n w=1u m=1
	mp001 (out net158 vdda vdda) pmos1 l=180n w=1u m=1
	mpd12 (net13 inp net31 net31) pmos1 l=180n w=1u m=1
	mpb01 (net158 net158 vdda vdda) pmos1 l=180n w=1u m=1
ends OPAMP1_variant834

subckt OPAMP1_variant835 inn inp out pd xpd vdda vssa
	xd1 (vssa vdda) prim_nwd AREA=6.13907e-9 PJ=476.6e-6 m=1
	xi0 (vssa net69) prim_nd AREA=1e-12 PJ=4e-6 m=1
	xi3 (net51 vdda) prim_pd AREA=790e-15 PJ=3.3e-6 m=1
	xr0 (vssa vdda net51) prim_rdiffp l=2.1e-6 w=700e-9 m=1
	xr1 (vdda vdda net69) prim_rdiffp l=2.1e-6 w=700e-9 m=1
	xcc01 (net12 out) prim_cpoly c=8.2e-13p m=1
	mnm12 (net13 net56 vssa vssa) nmos1 l=180n w=1u m=1
	mnm11 (net56 net56 vssa vssa) nmos1 l=180n w=1u m=1
	mnb02 (net27 net27 net21 vssa) nmos1 l=180n w=1u m=1
	mnpd1 (net21 xpd vssa vssa) nmos1 l=180n w=1u m=1
	mn001 (out net13 vssa vssa) nmos1 l=180n w=1u m=1
	mnpd2 (net13 pd vssa vssa) nmos1 l=180n w=1u m=1
	mnc01 (net13 net69 net12 vssa) nmos1 l=180n w=1u m=1
	mpb02 (net27 net51 net158 vdda) pmos1 l=180n w=1u m=1
	mppd1 (net158 xpd vdda vdda) pmos1 l=1.3e-07n w=5.3e-07u m=1
	mps11 (net31 net158 vdda vdda) pmos1 l=180n w=1u m=1
	mpd11 (net56 inn net31 net31) pmos1 l=180n w=1u m=1
	mp001 (out net158 vdda vdda) pmos1 l=2.0e-07n w=5.4e-07u m=1
	mpd12 (net13 inp net31 net31) pmos1 l=180n w=1u m=1
	mpb01 (net158 net158 vdda vdda) pmos1 l=1.3e-07n w=1.6e-06u m=1
ends OPAMP1_variant835

subckt OPAMP1_variant836 inn inp out pd xpd vdda vssa
	xd1 (vssa vdda) prim_nwd AREA=6.13907e-9 PJ=476.6e-6 m=1
	xi0 (vssa net69) prim_nd AREA=1e-12 PJ=4e-6 m=1
	xi3 (net51 vdda) prim_pd AREA=790e-15 PJ=3.3e-6 m=1
	xr0 (vssa vdda net51) prim_rdiffp l=2.1e-6 w=700e-9 m=1
	xr1 (vdda vdda net69) prim_rdiffp l=2.1e-6 w=700e-9 m=1
	xcc01 (net12 out) prim_cpoly c=1p m=1
	mnm12 (net13 net56 vssa vssa) nmos1 l=180n w=1u m=1
	mnm11 (net56 net56 vssa vssa) nmos1 l=180n w=1u m=1
	mnb02 (net27 net27 net21 vssa) nmos1 l=180n w=1u m=1
	mnpd1 (net21 xpd vssa vssa) nmos1 l=180n w=1u m=1
	mn001 (out net13 vssa vssa) nmos1 l=180n w=1u m=1
	mnpd2 (net13 pd vssa vssa) nmos1 l=180n w=1u m=1
	mnc01 (net13 net69 net12 vssa) nmos1 l=180n w=1u m=1
	mpb02 (net27 net51 net158 vdda) pmos1 l=180n w=1u m=1
	mppd1 (net158 xpd vdda vdda) pmos1 l=2.3e-07n w=8.5e-07u m=1
	mps11 (net31 net158 vdda vdda) pmos1 l=180n w=1u m=1
	mpd11 (net56 inn net31 net31) pmos1 l=1.2e-07n w=1.0e-06u m=1
	mp001 (out net158 vdda vdda) pmos1 l=180n w=1u m=1
	mpd12 (net13 inp net31 net31) pmos1 l=1.8e-07n w=1.6e-06u m=1
	mpb01 (net158 net158 vdda vdda) pmos1 l=180n w=1u m=1
ends OPAMP1_variant836

subckt OPAMP1_variant837 inn inp out pd xpd vdda vssa
	xd1 (vssa vdda) prim_nwd AREA=6.13907e-9 PJ=476.6e-6 m=1
	xi0 (vssa net69) prim_nd AREA=1e-12 PJ=4e-6 m=1
	xi3 (net51 vdda) prim_pd AREA=4.7e-09 PJ=6.4e-05 m=1
	xr0 (vssa vdda net51) prim_rdiffp l=2.1e-6 w=700e-9 m=1
	xr1 (vdda vdda net69) prim_rdiffp l=2.1e-6 w=700e-9 m=1
	xcc01 (net12 out) prim_cpoly c=1p m=1
	mnm12 (net13 net56 vssa vssa) nmos1 l=2.0e-07n w=1.2e-06u m=1
	mnm11 (net56 net56 vssa vssa) nmos1 l=180n w=1u m=1
	mnb02 (net27 net27 net21 vssa) nmos1 l=180n w=1u m=1
	mnpd1 (net21 xpd vssa vssa) nmos1 l=180n w=1u m=1
	mn001 (out net13 vssa vssa) nmos1 l=180n w=1u m=1
	mnpd2 (net13 pd vssa vssa) nmos1 l=2.1e-07n w=1.6e-06u m=1
	mnc01 (net13 net69 net12 vssa) nmos1 l=2.9e-07n w=1.8e-06u m=1
	mpb02 (net27 net51 net158 vdda) pmos1 l=180n w=1u m=1
	mppd1 (net158 xpd vdda vdda) pmos1 l=180n w=1u m=1
	mps11 (net31 net158 vdda vdda) pmos1 l=180n w=1u m=1
	mpd11 (net56 inn net31 net31) pmos1 l=180n w=1u m=1
	mp001 (out net158 vdda vdda) pmos1 l=180n w=1u m=1
	mpd12 (net13 inp net31 net31) pmos1 l=180n w=1u m=1
	mpb01 (net158 net158 vdda vdda) pmos1 l=180n w=1u m=1
ends OPAMP1_variant837

subckt OPAMP1_variant838 inn inp out pd xpd vdda vssa
	xd1 (vssa vdda) prim_nwd AREA=6.13907e-9 PJ=476.6e-6 m=1
	xi0 (vssa net69) prim_nd AREA=5.8e-09 PJ=9.0e-05 m=1
	xi3 (net51 vdda) prim_pd AREA=790e-15 PJ=3.3e-6 m=1
	xr0 (vssa vdda net51) prim_rdiffp l=1.2e-07 w=8.2e-07 m=1
	xr1 (vdda vdda net69) prim_rdiffp l=2.1e-6 w=700e-9 m=1
	xcc01 (net12 out) prim_cpoly c=1p m=1
	mnm12 (net13 net56 vssa vssa) nmos1 l=180n w=1u m=1
	mnm11 (net56 net56 vssa vssa) nmos1 l=180n w=1u m=1
	mnb02 (net27 net27 net21 vssa) nmos1 l=3.0e-07n w=5.8e-07u m=1
	mnpd1 (net21 xpd vssa vssa) nmos1 l=1.1e-07n w=1.7e-06u m=1
	mn001 (out net13 vssa vssa) nmos1 l=180n w=1u m=1
	mnpd2 (net13 pd vssa vssa) nmos1 l=2.5e-07n w=1.1e-06u m=1
	mnc01 (net13 net69 net12 vssa) nmos1 l=180n w=1u m=1
	mpb02 (net27 net51 net158 vdda) pmos1 l=180n w=1u m=1
	mppd1 (net158 xpd vdda vdda) pmos1 l=180n w=1u m=1
	mps11 (net31 net158 vdda vdda) pmos1 l=180n w=1u m=1
	mpd11 (net56 inn net31 net31) pmos1 l=180n w=1u m=1
	mp001 (out net158 vdda vdda) pmos1 l=180n w=1u m=1
	mpd12 (net13 inp net31 net31) pmos1 l=180n w=1u m=1
	mpb01 (net158 net158 vdda vdda) pmos1 l=180n w=1u m=1
ends OPAMP1_variant838

subckt OPAMP1_variant839 inn inp out pd xpd vdda vssa
	xd1 (vssa vdda) prim_nwd AREA=6.13907e-9 PJ=476.6e-6 m=1
	xi0 (vssa net69) prim_nd AREA=8.4e-09 PJ=7.1e-05 m=1
	xi3 (net51 vdda) prim_pd AREA=790e-15 PJ=3.3e-6 m=1
	xr0 (vssa vdda net51) prim_rdiffp l=2.1e-6 w=700e-9 m=1
	xr1 (vdda vdda net69) prim_rdiffp l=2.3e-07 w=1.5e-06 m=1
	xcc01 (net12 out) prim_cpoly c=1p m=1
	mnm12 (net13 net56 vssa vssa) nmos1 l=180n w=1u m=1
	mnm11 (net56 net56 vssa vssa) nmos1 l=180n w=1u m=1
	mnb02 (net27 net27 net21 vssa) nmos1 l=180n w=1u m=1
	mnpd1 (net21 xpd vssa vssa) nmos1 l=180n w=1u m=1
	mn001 (out net13 vssa vssa) nmos1 l=180n w=1u m=1
	mnpd2 (net13 pd vssa vssa) nmos1 l=180n w=1u m=1
	mnc01 (net13 net69 net12 vssa) nmos1 l=180n w=1u m=1
	mpb02 (net27 net51 net158 vdda) pmos1 l=180n w=1u m=1
	mppd1 (net158 xpd vdda vdda) pmos1 l=180n w=1u m=1
	mps11 (net31 net158 vdda vdda) pmos1 l=180n w=1u m=1
	mpd11 (net56 inn net31 net31) pmos1 l=1.7e-07n w=1.8e-06u m=1
	mp001 (out net158 vdda vdda) pmos1 l=180n w=1u m=1
	mpd12 (net13 inp net31 net31) pmos1 l=2.9e-07n w=1.4e-06u m=1
	mpb01 (net158 net158 vdda vdda) pmos1 l=180n w=1u m=1
ends OPAMP1_variant839

subckt OPAMP1_variant840 inn inp out pd xpd vdda vssa
	xd1 (vssa vdda) prim_nwd AREA=6.13907e-9 PJ=476.6e-6 m=1
	xi0 (vssa net69) prim_nd AREA=3.6e-09 PJ=7.3e-05 m=1
	xi3 (net51 vdda) prim_pd AREA=790e-15 PJ=3.3e-6 m=1
	xr0 (vssa vdda net51) prim_rdiffp l=1.9e-07 w=6.5e-07 m=1
	xr1 (vdda vdda net69) prim_rdiffp l=2.5e-07 w=1.7e-06 m=1
	xcc01 (net12 out) prim_cpoly c=1p m=1
	mnm12 (net13 net56 vssa vssa) nmos1 l=180n w=1u m=1
	mnm11 (net56 net56 vssa vssa) nmos1 l=180n w=1u m=1
	mnb02 (net27 net27 net21 vssa) nmos1 l=180n w=1u m=1
	mnpd1 (net21 xpd vssa vssa) nmos1 l=180n w=1u m=1
	mn001 (out net13 vssa vssa) nmos1 l=3.0e-07n w=1.8e-06u m=1
	mnpd2 (net13 pd vssa vssa) nmos1 l=180n w=1u m=1
	mnc01 (net13 net69 net12 vssa) nmos1 l=180n w=1u m=1
	mpb02 (net27 net51 net158 vdda) pmos1 l=180n w=1u m=1
	mppd1 (net158 xpd vdda vdda) pmos1 l=180n w=1u m=1
	mps11 (net31 net158 vdda vdda) pmos1 l=180n w=1u m=1
	mpd11 (net56 inn net31 net31) pmos1 l=2.4e-07n w=8.9e-07u m=1
	mp001 (out net158 vdda vdda) pmos1 l=180n w=1u m=1
	mpd12 (net13 inp net31 net31) pmos1 l=180n w=1u m=1
	mpb01 (net158 net158 vdda vdda) pmos1 l=180n w=1u m=1
ends OPAMP1_variant840

subckt OPAMP1_variant841 inn inp out pd xpd vdda vssa
	xd1 (vssa vdda) prim_nwd AREA=6.13907e-9 PJ=476.6e-6 m=1
	xi0 (vssa net69) prim_nd AREA=1e-12 PJ=4e-6 m=1
	xi3 (net51 vdda) prim_pd AREA=790e-15 PJ=3.3e-6 m=1
	xr0 (vssa vdda net51) prim_rdiffp l=2.1e-6 w=700e-9 m=1
	xr1 (vdda vdda net69) prim_rdiffp l=2.1e-6 w=700e-9 m=1
	xcc01 (net12 out) prim_cpoly c=8.7e-13p m=1
	mnm12 (net13 net56 vssa vssa) nmos1 l=180n w=1u m=1
	mnm11 (net56 net56 vssa vssa) nmos1 l=1.4e-07n w=1.1e-06u m=1
	mnb02 (net27 net27 net21 vssa) nmos1 l=180n w=1u m=1
	mnpd1 (net21 xpd vssa vssa) nmos1 l=1.8e-07n w=9.8e-07u m=1
	mn001 (out net13 vssa vssa) nmos1 l=180n w=1u m=1
	mnpd2 (net13 pd vssa vssa) nmos1 l=180n w=1u m=1
	mnc01 (net13 net69 net12 vssa) nmos1 l=180n w=1u m=1
	mpb02 (net27 net51 net158 vdda) pmos1 l=180n w=1u m=1
	mppd1 (net158 xpd vdda vdda) pmos1 l=180n w=1u m=1
	mps11 (net31 net158 vdda vdda) pmos1 l=180n w=1u m=1
	mpd11 (net56 inn net31 net31) pmos1 l=180n w=1u m=1
	mp001 (out net158 vdda vdda) pmos1 l=180n w=1u m=1
	mpd12 (net13 inp net31 net31) pmos1 l=180n w=1u m=1
	mpb01 (net158 net158 vdda vdda) pmos1 l=180n w=1u m=1
ends OPAMP1_variant841

subckt OPAMP1_variant842 inn inp out pd xpd vdda vssa
	xd1 (vssa vdda) prim_nwd AREA=8.9e-09 PJ=9.7e-05 m=1
	xi0 (vssa net69) prim_nd AREA=2.8e-10 PJ=2.8e-05 m=1
	xi3 (net51 vdda) prim_pd AREA=790e-15 PJ=3.3e-6 m=1
	xr0 (vssa vdda net51) prim_rdiffp l=2.1e-6 w=700e-9 m=1
	xr1 (vdda vdda net69) prim_rdiffp l=2.1e-6 w=700e-9 m=1
	xcc01 (net12 out) prim_cpoly c=1p m=1
	mnm12 (net13 net56 vssa vssa) nmos1 l=180n w=1u m=1
	mnm11 (net56 net56 vssa vssa) nmos1 l=180n w=1u m=1
	mnb02 (net27 net27 net21 vssa) nmos1 l=180n w=1u m=1
	mnpd1 (net21 xpd vssa vssa) nmos1 l=180n w=1u m=1
	mn001 (out net13 vssa vssa) nmos1 l=180n w=1u m=1
	mnpd2 (net13 pd vssa vssa) nmos1 l=3.0e-07n w=1.4e-06u m=1
	mnc01 (net13 net69 net12 vssa) nmos1 l=180n w=1u m=1
	mpb02 (net27 net51 net158 vdda) pmos1 l=180n w=1u m=1
	mppd1 (net158 xpd vdda vdda) pmos1 l=1.5e-07n w=5.7e-07u m=1
	mps11 (net31 net158 vdda vdda) pmos1 l=180n w=1u m=1
	mpd11 (net56 inn net31 net31) pmos1 l=180n w=1u m=1
	mp001 (out net158 vdda vdda) pmos1 l=180n w=1u m=1
	mpd12 (net13 inp net31 net31) pmos1 l=180n w=1u m=1
	mpb01 (net158 net158 vdda vdda) pmos1 l=2.9e-07n w=5.1e-07u m=1
ends OPAMP1_variant842

subckt OPAMP1_variant843 inn inp out pd xpd vdda vssa
	xd1 (vssa vdda) prim_nwd AREA=6.13907e-9 PJ=476.6e-6 m=1
	xi0 (vssa net69) prim_nd AREA=1e-12 PJ=4e-6 m=1
	xi3 (net51 vdda) prim_pd AREA=790e-15 PJ=3.3e-6 m=1
	xr0 (vssa vdda net51) prim_rdiffp l=2.1e-6 w=700e-9 m=1
	xr1 (vdda vdda net69) prim_rdiffp l=2.1e-6 w=700e-9 m=1
	xcc01 (net12 out) prim_cpoly c=1p m=1
	mnm12 (net13 net56 vssa vssa) nmos1 l=180n w=1u m=1
	mnm11 (net56 net56 vssa vssa) nmos1 l=1.7e-07n w=1.9e-06u m=1
	mnb02 (net27 net27 net21 vssa) nmos1 l=2.9e-07n w=7.8e-07u m=1
	mnpd1 (net21 xpd vssa vssa) nmos1 l=180n w=1u m=1
	mn001 (out net13 vssa vssa) nmos1 l=180n w=1u m=1
	mnpd2 (net13 pd vssa vssa) nmos1 l=180n w=1u m=1
	mnc01 (net13 net69 net12 vssa) nmos1 l=180n w=1u m=1
	mpb02 (net27 net51 net158 vdda) pmos1 l=1.2e-07n w=5.7e-07u m=1
	mppd1 (net158 xpd vdda vdda) pmos1 l=180n w=1u m=1
	mps11 (net31 net158 vdda vdda) pmos1 l=180n w=1u m=1
	mpd11 (net56 inn net31 net31) pmos1 l=180n w=1u m=1
	mp001 (out net158 vdda vdda) pmos1 l=180n w=1u m=1
	mpd12 (net13 inp net31 net31) pmos1 l=180n w=1u m=1
	mpb01 (net158 net158 vdda vdda) pmos1 l=2.4e-07n w=1.8e-06u m=1
ends OPAMP1_variant843

subckt OPAMP1_variant844 inn inp out pd xpd vdda vssa
	xd1 (vssa vdda) prim_nwd AREA=6.13907e-9 PJ=476.6e-6 m=1
	xi0 (vssa net69) prim_nd AREA=1e-12 PJ=4e-6 m=1
	xi3 (net51 vdda) prim_pd AREA=790e-15 PJ=3.3e-6 m=1
	xr0 (vssa vdda net51) prim_rdiffp l=3.0e-07 w=8.2e-07 m=1
	xr1 (vdda vdda net69) prim_rdiffp l=2.1e-6 w=700e-9 m=1
	xcc01 (net12 out) prim_cpoly c=1p m=1
	mnm12 (net13 net56 vssa vssa) nmos1 l=180n w=1u m=1
	mnm11 (net56 net56 vssa vssa) nmos1 l=180n w=1u m=1
	mnb02 (net27 net27 net21 vssa) nmos1 l=180n w=1u m=1
	mnpd1 (net21 xpd vssa vssa) nmos1 l=180n w=1u m=1
	mn001 (out net13 vssa vssa) nmos1 l=180n w=1u m=1
	mnpd2 (net13 pd vssa vssa) nmos1 l=180n w=1u m=1
	mnc01 (net13 net69 net12 vssa) nmos1 l=1.8e-07n w=1.8e-06u m=1
	mpb02 (net27 net51 net158 vdda) pmos1 l=180n w=1u m=1
	mppd1 (net158 xpd vdda vdda) pmos1 l=180n w=1u m=1
	mps11 (net31 net158 vdda vdda) pmos1 l=1.3e-07n w=1.3e-06u m=1
	mpd11 (net56 inn net31 net31) pmos1 l=180n w=1u m=1
	mp001 (out net158 vdda vdda) pmos1 l=180n w=1u m=1
	mpd12 (net13 inp net31 net31) pmos1 l=180n w=1u m=1
	mpb01 (net158 net158 vdda vdda) pmos1 l=180n w=1u m=1
ends OPAMP1_variant844

subckt OPAMP1_variant845 inn inp out pd xpd vdda vssa
	xd1 (vssa vdda) prim_nwd AREA=6.13907e-9 PJ=476.6e-6 m=1
	xi0 (vssa net69) prim_nd AREA=2.6e-09 PJ=5.8e-05 m=1
	xi3 (net51 vdda) prim_pd AREA=790e-15 PJ=3.3e-6 m=1
	xr0 (vssa vdda net51) prim_rdiffp l=2.2e-07 w=8.4e-07 m=1
	xr1 (vdda vdda net69) prim_rdiffp l=2.1e-6 w=700e-9 m=1
	xcc01 (net12 out) prim_cpoly c=1p m=1
	mnm12 (net13 net56 vssa vssa) nmos1 l=180n w=1u m=1
	mnm11 (net56 net56 vssa vssa) nmos1 l=180n w=1u m=1
	mnb02 (net27 net27 net21 vssa) nmos1 l=180n w=1u m=1
	mnpd1 (net21 xpd vssa vssa) nmos1 l=180n w=1u m=1
	mn001 (out net13 vssa vssa) nmos1 l=180n w=1u m=1
	mnpd2 (net13 pd vssa vssa) nmos1 l=180n w=1u m=1
	mnc01 (net13 net69 net12 vssa) nmos1 l=1.1e-07n w=8.4e-07u m=1
	mpb02 (net27 net51 net158 vdda) pmos1 l=180n w=1u m=1
	mppd1 (net158 xpd vdda vdda) pmos1 l=1.5e-07n w=1.0e-06u m=1
	mps11 (net31 net158 vdda vdda) pmos1 l=180n w=1u m=1
	mpd11 (net56 inn net31 net31) pmos1 l=180n w=1u m=1
	mp001 (out net158 vdda vdda) pmos1 l=180n w=1u m=1
	mpd12 (net13 inp net31 net31) pmos1 l=180n w=1u m=1
	mpb01 (net158 net158 vdda vdda) pmos1 l=180n w=1u m=1
ends OPAMP1_variant845

subckt OPAMP1_variant846 inn inp out pd xpd vdda vssa
	xd1 (vssa vdda) prim_nwd AREA=3.4e-09 PJ=1.5e-05 m=1
	xi0 (vssa net69) prim_nd AREA=1e-12 PJ=4e-6 m=1
	xi3 (net51 vdda) prim_pd AREA=790e-15 PJ=3.3e-6 m=1
	xr0 (vssa vdda net51) prim_rdiffp l=1.9e-07 w=1.1e-06 m=1
	xr1 (vdda vdda net69) prim_rdiffp l=2.1e-6 w=700e-9 m=1
	xcc01 (net12 out) prim_cpoly c=1p m=1
	mnm12 (net13 net56 vssa vssa) nmos1 l=1.3e-07n w=1.5e-06u m=1
	mnm11 (net56 net56 vssa vssa) nmos1 l=180n w=1u m=1
	mnb02 (net27 net27 net21 vssa) nmos1 l=180n w=1u m=1
	mnpd1 (net21 xpd vssa vssa) nmos1 l=180n w=1u m=1
	mn001 (out net13 vssa vssa) nmos1 l=180n w=1u m=1
	mnpd2 (net13 pd vssa vssa) nmos1 l=1.9e-07n w=8.9e-07u m=1
	mnc01 (net13 net69 net12 vssa) nmos1 l=1.9e-07n w=5.2e-07u m=1
	mpb02 (net27 net51 net158 vdda) pmos1 l=180n w=1u m=1
	mppd1 (net158 xpd vdda vdda) pmos1 l=180n w=1u m=1
	mps11 (net31 net158 vdda vdda) pmos1 l=180n w=1u m=1
	mpd11 (net56 inn net31 net31) pmos1 l=180n w=1u m=1
	mp001 (out net158 vdda vdda) pmos1 l=180n w=1u m=1
	mpd12 (net13 inp net31 net31) pmos1 l=180n w=1u m=1
	mpb01 (net158 net158 vdda vdda) pmos1 l=180n w=1u m=1
ends OPAMP1_variant846

subckt OPAMP1_variant847 inn inp out pd xpd vdda vssa
	xd1 (vssa vdda) prim_nwd AREA=6.13907e-9 PJ=476.6e-6 m=1
	xi0 (vssa net69) prim_nd AREA=7.5e-09 PJ=1.4e-05 m=1
	xi3 (net51 vdda) prim_pd AREA=790e-15 PJ=3.3e-6 m=1
	xr0 (vssa vdda net51) prim_rdiffp l=2.1e-6 w=700e-9 m=1
	xr1 (vdda vdda net69) prim_rdiffp l=1.9e-07 w=1.4e-06 m=1
	xcc01 (net12 out) prim_cpoly c=1p m=1
	mnm12 (net13 net56 vssa vssa) nmos1 l=180n w=1u m=1
	mnm11 (net56 net56 vssa vssa) nmos1 l=180n w=1u m=1
	mnb02 (net27 net27 net21 vssa) nmos1 l=180n w=1u m=1
	mnpd1 (net21 xpd vssa vssa) nmos1 l=180n w=1u m=1
	mn001 (out net13 vssa vssa) nmos1 l=180n w=1u m=1
	mnpd2 (net13 pd vssa vssa) nmos1 l=180n w=1u m=1
	mnc01 (net13 net69 net12 vssa) nmos1 l=180n w=1u m=1
	mpb02 (net27 net51 net158 vdda) pmos1 l=180n w=1u m=1
	mppd1 (net158 xpd vdda vdda) pmos1 l=180n w=1u m=1
	mps11 (net31 net158 vdda vdda) pmos1 l=180n w=1u m=1
	mpd11 (net56 inn net31 net31) pmos1 l=1.6e-07n w=7.6e-07u m=1
	mp001 (out net158 vdda vdda) pmos1 l=180n w=1u m=1
	mpd12 (net13 inp net31 net31) pmos1 l=180n w=1u m=1
	mpb01 (net158 net158 vdda vdda) pmos1 l=180n w=1u m=1
ends OPAMP1_variant847

subckt OPAMP1_variant848 inn inp out pd xpd vdda vssa
	xd1 (vssa vdda) prim_nwd AREA=7.6e-09 PJ=8.5e-05 m=1
	xi0 (vssa net69) prim_nd AREA=1e-12 PJ=4e-6 m=1
	xi3 (net51 vdda) prim_pd AREA=790e-15 PJ=3.3e-6 m=1
	xr0 (vssa vdda net51) prim_rdiffp l=2.1e-6 w=700e-9 m=1
	xr1 (vdda vdda net69) prim_rdiffp l=2.1e-6 w=700e-9 m=1
	xcc01 (net12 out) prim_cpoly c=1p m=1
	mnm12 (net13 net56 vssa vssa) nmos1 l=1.0e-07n w=1.2e-06u m=1
	mnm11 (net56 net56 vssa vssa) nmos1 l=180n w=1u m=1
	mnb02 (net27 net27 net21 vssa) nmos1 l=1.6e-07n w=1.8e-06u m=1
	mnpd1 (net21 xpd vssa vssa) nmos1 l=180n w=1u m=1
	mn001 (out net13 vssa vssa) nmos1 l=180n w=1u m=1
	mnpd2 (net13 pd vssa vssa) nmos1 l=180n w=1u m=1
	mnc01 (net13 net69 net12 vssa) nmos1 l=180n w=1u m=1
	mpb02 (net27 net51 net158 vdda) pmos1 l=180n w=1u m=1
	mppd1 (net158 xpd vdda vdda) pmos1 l=180n w=1u m=1
	mps11 (net31 net158 vdda vdda) pmos1 l=180n w=1u m=1
	mpd11 (net56 inn net31 net31) pmos1 l=180n w=1u m=1
	mp001 (out net158 vdda vdda) pmos1 l=180n w=1u m=1
	mpd12 (net13 inp net31 net31) pmos1 l=180n w=1u m=1
	mpb01 (net158 net158 vdda vdda) pmos1 l=180n w=1u m=1
ends OPAMP1_variant848

subckt OPAMP1_variant849 inn inp out pd xpd vdda vssa
	xd1 (vssa vdda) prim_nwd AREA=6.13907e-9 PJ=476.6e-6 m=1
	xi0 (vssa net69) prim_nd AREA=1e-12 PJ=4e-6 m=1
	xi3 (net51 vdda) prim_pd AREA=790e-15 PJ=3.3e-6 m=1
	xr0 (vssa vdda net51) prim_rdiffp l=2.1e-6 w=700e-9 m=1
	xr1 (vdda vdda net69) prim_rdiffp l=2.1e-6 w=700e-9 m=1
	xcc01 (net12 out) prim_cpoly c=1p m=1
	mnm12 (net13 net56 vssa vssa) nmos1 l=2.8e-07n w=9.1e-07u m=1
	mnm11 (net56 net56 vssa vssa) nmos1 l=1.3e-07n w=1.1e-06u m=1
	mnb02 (net27 net27 net21 vssa) nmos1 l=180n w=1u m=1
	mnpd1 (net21 xpd vssa vssa) nmos1 l=180n w=1u m=1
	mn001 (out net13 vssa vssa) nmos1 l=2.7e-07n w=1.1e-06u m=1
	mnpd2 (net13 pd vssa vssa) nmos1 l=180n w=1u m=1
	mnc01 (net13 net69 net12 vssa) nmos1 l=180n w=1u m=1
	mpb02 (net27 net51 net158 vdda) pmos1 l=1.1e-07n w=7.3e-07u m=1
	mppd1 (net158 xpd vdda vdda) pmos1 l=180n w=1u m=1
	mps11 (net31 net158 vdda vdda) pmos1 l=180n w=1u m=1
	mpd11 (net56 inn net31 net31) pmos1 l=180n w=1u m=1
	mp001 (out net158 vdda vdda) pmos1 l=180n w=1u m=1
	mpd12 (net13 inp net31 net31) pmos1 l=180n w=1u m=1
	mpb01 (net158 net158 vdda vdda) pmos1 l=1.2e-07n w=1.9e-06u m=1
ends OPAMP1_variant849

subckt OPAMP1_variant850 inn inp out pd xpd vdda vssa
	xd1 (vssa vdda) prim_nwd AREA=6.13907e-9 PJ=476.6e-6 m=1
	xi0 (vssa net69) prim_nd AREA=1.0e-09 PJ=9.3e-05 m=1
	xi3 (net51 vdda) prim_pd AREA=790e-15 PJ=3.3e-6 m=1
	xr0 (vssa vdda net51) prim_rdiffp l=2.1e-6 w=700e-9 m=1
	xr1 (vdda vdda net69) prim_rdiffp l=2.1e-6 w=700e-9 m=1
	xcc01 (net12 out) prim_cpoly c=1p m=1
	mnm12 (net13 net56 vssa vssa) nmos1 l=1.8e-07n w=1.1e-06u m=1
	mnm11 (net56 net56 vssa vssa) nmos1 l=180n w=1u m=1
	mnb02 (net27 net27 net21 vssa) nmos1 l=180n w=1u m=1
	mnpd1 (net21 xpd vssa vssa) nmos1 l=180n w=1u m=1
	mn001 (out net13 vssa vssa) nmos1 l=180n w=1u m=1
	mnpd2 (net13 pd vssa vssa) nmos1 l=180n w=1u m=1
	mnc01 (net13 net69 net12 vssa) nmos1 l=180n w=1u m=1
	mpb02 (net27 net51 net158 vdda) pmos1 l=180n w=1u m=1
	mppd1 (net158 xpd vdda vdda) pmos1 l=180n w=1u m=1
	mps11 (net31 net158 vdda vdda) pmos1 l=180n w=1u m=1
	mpd11 (net56 inn net31 net31) pmos1 l=180n w=1u m=1
	mp001 (out net158 vdda vdda) pmos1 l=180n w=1u m=1
	mpd12 (net13 inp net31 net31) pmos1 l=180n w=1u m=1
	mpb01 (net158 net158 vdda vdda) pmos1 l=180n w=1u m=1
ends OPAMP1_variant850

subckt OPAMP1_variant851 inn inp out pd xpd vdda vssa
	xd1 (vssa vdda) prim_nwd AREA=6.13907e-9 PJ=476.6e-6 m=1
	xi0 (vssa net69) prim_nd AREA=1e-12 PJ=4e-6 m=1
	xi3 (net51 vdda) prim_pd AREA=790e-15 PJ=3.3e-6 m=1
	xr0 (vssa vdda net51) prim_rdiffp l=2.8e-07 w=1.7e-06 m=1
	xr1 (vdda vdda net69) prim_rdiffp l=1.2e-07 w=6.5e-07 m=1
	xcc01 (net12 out) prim_cpoly c=1p m=1
	mnm12 (net13 net56 vssa vssa) nmos1 l=1.7e-07n w=1.8e-06u m=1
	mnm11 (net56 net56 vssa vssa) nmos1 l=1.3e-07n w=1.0e-06u m=1
	mnb02 (net27 net27 net21 vssa) nmos1 l=180n w=1u m=1
	mnpd1 (net21 xpd vssa vssa) nmos1 l=180n w=1u m=1
	mn001 (out net13 vssa vssa) nmos1 l=180n w=1u m=1
	mnpd2 (net13 pd vssa vssa) nmos1 l=180n w=1u m=1
	mnc01 (net13 net69 net12 vssa) nmos1 l=180n w=1u m=1
	mpb02 (net27 net51 net158 vdda) pmos1 l=180n w=1u m=1
	mppd1 (net158 xpd vdda vdda) pmos1 l=180n w=1u m=1
	mps11 (net31 net158 vdda vdda) pmos1 l=180n w=1u m=1
	mpd11 (net56 inn net31 net31) pmos1 l=3.0e-07n w=7.3e-07u m=1
	mp001 (out net158 vdda vdda) pmos1 l=180n w=1u m=1
	mpd12 (net13 inp net31 net31) pmos1 l=180n w=1u m=1
	mpb01 (net158 net158 vdda vdda) pmos1 l=180n w=1u m=1
ends OPAMP1_variant851

subckt OPAMP1_variant852 inn inp out pd xpd vdda vssa
	xd1 (vssa vdda) prim_nwd AREA=6.13907e-9 PJ=476.6e-6 m=1
	xi0 (vssa net69) prim_nd AREA=1e-12 PJ=4e-6 m=1
	xi3 (net51 vdda) prim_pd AREA=790e-15 PJ=3.3e-6 m=1
	xr0 (vssa vdda net51) prim_rdiffp l=1.6e-07 w=1.9e-06 m=1
	xr1 (vdda vdda net69) prim_rdiffp l=2.1e-6 w=700e-9 m=1
	xcc01 (net12 out) prim_cpoly c=1p m=1
	mnm12 (net13 net56 vssa vssa) nmos1 l=180n w=1u m=1
	mnm11 (net56 net56 vssa vssa) nmos1 l=180n w=1u m=1
	mnb02 (net27 net27 net21 vssa) nmos1 l=180n w=1u m=1
	mnpd1 (net21 xpd vssa vssa) nmos1 l=180n w=1u m=1
	mn001 (out net13 vssa vssa) nmos1 l=180n w=1u m=1
	mnpd2 (net13 pd vssa vssa) nmos1 l=2.1e-07n w=7.3e-07u m=1
	mnc01 (net13 net69 net12 vssa) nmos1 l=180n w=1u m=1
	mpb02 (net27 net51 net158 vdda) pmos1 l=1.3e-07n w=1.7e-06u m=1
	mppd1 (net158 xpd vdda vdda) pmos1 l=1.2e-07n w=1.5e-06u m=1
	mps11 (net31 net158 vdda vdda) pmos1 l=180n w=1u m=1
	mpd11 (net56 inn net31 net31) pmos1 l=180n w=1u m=1
	mp001 (out net158 vdda vdda) pmos1 l=2.4e-07n w=5.5e-07u m=1
	mpd12 (net13 inp net31 net31) pmos1 l=180n w=1u m=1
	mpb01 (net158 net158 vdda vdda) pmos1 l=180n w=1u m=1
ends OPAMP1_variant852

subckt OPAMP1_variant853 inn inp out pd xpd vdda vssa
	xd1 (vssa vdda) prim_nwd AREA=1.3e-09 PJ=3.3e-05 m=1
	xi0 (vssa net69) prim_nd AREA=1e-12 PJ=4e-6 m=1
	xi3 (net51 vdda) prim_pd AREA=790e-15 PJ=3.3e-6 m=1
	xr0 (vssa vdda net51) prim_rdiffp l=2.1e-6 w=700e-9 m=1
	xr1 (vdda vdda net69) prim_rdiffp l=2.1e-6 w=700e-9 m=1
	xcc01 (net12 out) prim_cpoly c=1p m=1
	mnm12 (net13 net56 vssa vssa) nmos1 l=1.7e-07n w=1.5e-06u m=1
	mnm11 (net56 net56 vssa vssa) nmos1 l=180n w=1u m=1
	mnb02 (net27 net27 net21 vssa) nmos1 l=180n w=1u m=1
	mnpd1 (net21 xpd vssa vssa) nmos1 l=180n w=1u m=1
	mn001 (out net13 vssa vssa) nmos1 l=180n w=1u m=1
	mnpd2 (net13 pd vssa vssa) nmos1 l=180n w=1u m=1
	mnc01 (net13 net69 net12 vssa) nmos1 l=180n w=1u m=1
	mpb02 (net27 net51 net158 vdda) pmos1 l=180n w=1u m=1
	mppd1 (net158 xpd vdda vdda) pmos1 l=180n w=1u m=1
	mps11 (net31 net158 vdda vdda) pmos1 l=180n w=1u m=1
	mpd11 (net56 inn net31 net31) pmos1 l=180n w=1u m=1
	mp001 (out net158 vdda vdda) pmos1 l=180n w=1u m=1
	mpd12 (net13 inp net31 net31) pmos1 l=180n w=1u m=1
	mpb01 (net158 net158 vdda vdda) pmos1 l=180n w=1u m=1
ends OPAMP1_variant853

subckt OPAMP1_variant854 inn inp out pd xpd vdda vssa
	xd1 (vssa vdda) prim_nwd AREA=6.13907e-9 PJ=476.6e-6 m=1
	xi0 (vssa net69) prim_nd AREA=1e-12 PJ=4e-6 m=1
	xi3 (net51 vdda) prim_pd AREA=7.4e-09 PJ=7.1e-05 m=1
	xr0 (vssa vdda net51) prim_rdiffp l=2.1e-6 w=700e-9 m=1
	xr1 (vdda vdda net69) prim_rdiffp l=2.1e-6 w=700e-9 m=1
	xcc01 (net12 out) prim_cpoly c=5.2e-13p m=1
	mnm12 (net13 net56 vssa vssa) nmos1 l=180n w=1u m=1
	mnm11 (net56 net56 vssa vssa) nmos1 l=2.8e-07n w=8.7e-07u m=1
	mnb02 (net27 net27 net21 vssa) nmos1 l=180n w=1u m=1
	mnpd1 (net21 xpd vssa vssa) nmos1 l=2.3e-07n w=1.1e-06u m=1
	mn001 (out net13 vssa vssa) nmos1 l=180n w=1u m=1
	mnpd2 (net13 pd vssa vssa) nmos1 l=180n w=1u m=1
	mnc01 (net13 net69 net12 vssa) nmos1 l=180n w=1u m=1
	mpb02 (net27 net51 net158 vdda) pmos1 l=2.9e-07n w=1.7e-06u m=1
	mppd1 (net158 xpd vdda vdda) pmos1 l=180n w=1u m=1
	mps11 (net31 net158 vdda vdda) pmos1 l=180n w=1u m=1
	mpd11 (net56 inn net31 net31) pmos1 l=180n w=1u m=1
	mp001 (out net158 vdda vdda) pmos1 l=180n w=1u m=1
	mpd12 (net13 inp net31 net31) pmos1 l=180n w=1u m=1
	mpb01 (net158 net158 vdda vdda) pmos1 l=180n w=1u m=1
ends OPAMP1_variant854

subckt OPAMP1_variant855 inn inp out pd xpd vdda vssa
	xd1 (vssa vdda) prim_nwd AREA=6.13907e-9 PJ=476.6e-6 m=1
	xi0 (vssa net69) prim_nd AREA=1e-12 PJ=4e-6 m=1
	xi3 (net51 vdda) prim_pd AREA=790e-15 PJ=3.3e-6 m=1
	xr0 (vssa vdda net51) prim_rdiffp l=2.5e-07 w=8.9e-07 m=1
	xr1 (vdda vdda net69) prim_rdiffp l=2.1e-6 w=700e-9 m=1
	xcc01 (net12 out) prim_cpoly c=1.9e-12p m=1
	mnm12 (net13 net56 vssa vssa) nmos1 l=180n w=1u m=1
	mnm11 (net56 net56 vssa vssa) nmos1 l=180n w=1u m=1
	mnb02 (net27 net27 net21 vssa) nmos1 l=180n w=1u m=1
	mnpd1 (net21 xpd vssa vssa) nmos1 l=180n w=1u m=1
	mn001 (out net13 vssa vssa) nmos1 l=1.5e-07n w=2.0e-06u m=1
	mnpd2 (net13 pd vssa vssa) nmos1 l=2.6e-07n w=9.9e-07u m=1
	mnc01 (net13 net69 net12 vssa) nmos1 l=180n w=1u m=1
	mpb02 (net27 net51 net158 vdda) pmos1 l=180n w=1u m=1
	mppd1 (net158 xpd vdda vdda) pmos1 l=180n w=1u m=1
	mps11 (net31 net158 vdda vdda) pmos1 l=180n w=1u m=1
	mpd11 (net56 inn net31 net31) pmos1 l=2.6e-07n w=1.7e-06u m=1
	mp001 (out net158 vdda vdda) pmos1 l=180n w=1u m=1
	mpd12 (net13 inp net31 net31) pmos1 l=180n w=1u m=1
	mpb01 (net158 net158 vdda vdda) pmos1 l=180n w=1u m=1
ends OPAMP1_variant855

subckt OPAMP1_variant856 inn inp out pd xpd vdda vssa
	xd1 (vssa vdda) prim_nwd AREA=6.13907e-9 PJ=476.6e-6 m=1
	xi0 (vssa net69) prim_nd AREA=1e-12 PJ=4e-6 m=1
	xi3 (net51 vdda) prim_pd AREA=790e-15 PJ=3.3e-6 m=1
	xr0 (vssa vdda net51) prim_rdiffp l=1.7e-07 w=1.8e-06 m=1
	xr1 (vdda vdda net69) prim_rdiffp l=2.1e-6 w=700e-9 m=1
	xcc01 (net12 out) prim_cpoly c=1p m=1
	mnm12 (net13 net56 vssa vssa) nmos1 l=180n w=1u m=1
	mnm11 (net56 net56 vssa vssa) nmos1 l=180n w=1u m=1
	mnb02 (net27 net27 net21 vssa) nmos1 l=180n w=1u m=1
	mnpd1 (net21 xpd vssa vssa) nmos1 l=180n w=1u m=1
	mn001 (out net13 vssa vssa) nmos1 l=180n w=1u m=1
	mnpd2 (net13 pd vssa vssa) nmos1 l=180n w=1u m=1
	mnc01 (net13 net69 net12 vssa) nmos1 l=180n w=1u m=1
	mpb02 (net27 net51 net158 vdda) pmos1 l=180n w=1u m=1
	mppd1 (net158 xpd vdda vdda) pmos1 l=180n w=1u m=1
	mps11 (net31 net158 vdda vdda) pmos1 l=1.7e-07n w=1.6e-06u m=1
	mpd11 (net56 inn net31 net31) pmos1 l=1.4e-07n w=1.5e-06u m=1
	mp001 (out net158 vdda vdda) pmos1 l=180n w=1u m=1
	mpd12 (net13 inp net31 net31) pmos1 l=180n w=1u m=1
	mpb01 (net158 net158 vdda vdda) pmos1 l=180n w=1u m=1
ends OPAMP1_variant856

subckt OPAMP1_variant857 inn inp out pd xpd vdda vssa
	xd1 (vssa vdda) prim_nwd AREA=6.13907e-9 PJ=476.6e-6 m=1
	xi0 (vssa net69) prim_nd AREA=1e-12 PJ=4e-6 m=1
	xi3 (net51 vdda) prim_pd AREA=790e-15 PJ=3.3e-6 m=1
	xr0 (vssa vdda net51) prim_rdiffp l=2.8e-07 w=2.0e-06 m=1
	xr1 (vdda vdda net69) prim_rdiffp l=2.1e-6 w=700e-9 m=1
	xcc01 (net12 out) prim_cpoly c=1p m=1
	mnm12 (net13 net56 vssa vssa) nmos1 l=180n w=1u m=1
	mnm11 (net56 net56 vssa vssa) nmos1 l=180n w=1u m=1
	mnb02 (net27 net27 net21 vssa) nmos1 l=180n w=1u m=1
	mnpd1 (net21 xpd vssa vssa) nmos1 l=180n w=1u m=1
	mn001 (out net13 vssa vssa) nmos1 l=180n w=1u m=1
	mnpd2 (net13 pd vssa vssa) nmos1 l=1.7e-07n w=9.9e-07u m=1
	mnc01 (net13 net69 net12 vssa) nmos1 l=180n w=1u m=1
	mpb02 (net27 net51 net158 vdda) pmos1 l=1.6e-07n w=1.4e-06u m=1
	mppd1 (net158 xpd vdda vdda) pmos1 l=2.0e-07n w=1.6e-06u m=1
	mps11 (net31 net158 vdda vdda) pmos1 l=180n w=1u m=1
	mpd11 (net56 inn net31 net31) pmos1 l=180n w=1u m=1
	mp001 (out net158 vdda vdda) pmos1 l=180n w=1u m=1
	mpd12 (net13 inp net31 net31) pmos1 l=180n w=1u m=1
	mpb01 (net158 net158 vdda vdda) pmos1 l=2.8e-07n w=1.8e-06u m=1
ends OPAMP1_variant857

subckt OPAMP1_variant858 inn inp out pd xpd vdda vssa
	xd1 (vssa vdda) prim_nwd AREA=6.13907e-9 PJ=476.6e-6 m=1
	xi0 (vssa net69) prim_nd AREA=1.3e-09 PJ=5.6e-05 m=1
	xi3 (net51 vdda) prim_pd AREA=790e-15 PJ=3.3e-6 m=1
	xr0 (vssa vdda net51) prim_rdiffp l=2.1e-6 w=700e-9 m=1
	xr1 (vdda vdda net69) prim_rdiffp l=2.1e-6 w=700e-9 m=1
	xcc01 (net12 out) prim_cpoly c=1p m=1
	mnm12 (net13 net56 vssa vssa) nmos1 l=180n w=1u m=1
	mnm11 (net56 net56 vssa vssa) nmos1 l=180n w=1u m=1
	mnb02 (net27 net27 net21 vssa) nmos1 l=180n w=1u m=1
	mnpd1 (net21 xpd vssa vssa) nmos1 l=180n w=1u m=1
	mn001 (out net13 vssa vssa) nmos1 l=2.7e-07n w=6.0e-07u m=1
	mnpd2 (net13 pd vssa vssa) nmos1 l=180n w=1u m=1
	mnc01 (net13 net69 net12 vssa) nmos1 l=3.0e-07n w=1.4e-06u m=1
	mpb02 (net27 net51 net158 vdda) pmos1 l=180n w=1u m=1
	mppd1 (net158 xpd vdda vdda) pmos1 l=180n w=1u m=1
	mps11 (net31 net158 vdda vdda) pmos1 l=180n w=1u m=1
	mpd11 (net56 inn net31 net31) pmos1 l=180n w=1u m=1
	mp001 (out net158 vdda vdda) pmos1 l=180n w=1u m=1
	mpd12 (net13 inp net31 net31) pmos1 l=1.7e-07n w=6.1e-07u m=1
	mpb01 (net158 net158 vdda vdda) pmos1 l=180n w=1u m=1
ends OPAMP1_variant858

subckt OPAMP1_variant859 inn inp out pd xpd vdda vssa
	xd1 (vssa vdda) prim_nwd AREA=6.13907e-9 PJ=476.6e-6 m=1
	xi0 (vssa net69) prim_nd AREA=1e-12 PJ=4e-6 m=1
	xi3 (net51 vdda) prim_pd AREA=9.9e-09 PJ=7.8e-05 m=1
	xr0 (vssa vdda net51) prim_rdiffp l=2.1e-6 w=700e-9 m=1
	xr1 (vdda vdda net69) prim_rdiffp l=2.1e-6 w=700e-9 m=1
	xcc01 (net12 out) prim_cpoly c=1p m=1
	mnm12 (net13 net56 vssa vssa) nmos1 l=180n w=1u m=1
	mnm11 (net56 net56 vssa vssa) nmos1 l=2.1e-07n w=1.8e-06u m=1
	mnb02 (net27 net27 net21 vssa) nmos1 l=180n w=1u m=1
	mnpd1 (net21 xpd vssa vssa) nmos1 l=2.5e-07n w=6.0e-07u m=1
	mn001 (out net13 vssa vssa) nmos1 l=180n w=1u m=1
	mnpd2 (net13 pd vssa vssa) nmos1 l=180n w=1u m=1
	mnc01 (net13 net69 net12 vssa) nmos1 l=180n w=1u m=1
	mpb02 (net27 net51 net158 vdda) pmos1 l=180n w=1u m=1
	mppd1 (net158 xpd vdda vdda) pmos1 l=180n w=1u m=1
	mps11 (net31 net158 vdda vdda) pmos1 l=3.0e-07n w=1.3e-06u m=1
	mpd11 (net56 inn net31 net31) pmos1 l=180n w=1u m=1
	mp001 (out net158 vdda vdda) pmos1 l=180n w=1u m=1
	mpd12 (net13 inp net31 net31) pmos1 l=180n w=1u m=1
	mpb01 (net158 net158 vdda vdda) pmos1 l=2.1e-07n w=1.9e-06u m=1
ends OPAMP1_variant859

subckt OPAMP1_variant860 inn inp out pd xpd vdda vssa
	xd1 (vssa vdda) prim_nwd AREA=3.2e-09 PJ=5.1e-05 m=1
	xi0 (vssa net69) prim_nd AREA=1e-12 PJ=4e-6 m=1
	xi3 (net51 vdda) prim_pd AREA=790e-15 PJ=3.3e-6 m=1
	xr0 (vssa vdda net51) prim_rdiffp l=2.1e-6 w=700e-9 m=1
	xr1 (vdda vdda net69) prim_rdiffp l=2.1e-6 w=700e-9 m=1
	xcc01 (net12 out) prim_cpoly c=1p m=1
	mnm12 (net13 net56 vssa vssa) nmos1 l=180n w=1u m=1
	mnm11 (net56 net56 vssa vssa) nmos1 l=180n w=1u m=1
	mnb02 (net27 net27 net21 vssa) nmos1 l=180n w=1u m=1
	mnpd1 (net21 xpd vssa vssa) nmos1 l=180n w=1u m=1
	mn001 (out net13 vssa vssa) nmos1 l=180n w=1u m=1
	mnpd2 (net13 pd vssa vssa) nmos1 l=180n w=1u m=1
	mnc01 (net13 net69 net12 vssa) nmos1 l=180n w=1u m=1
	mpb02 (net27 net51 net158 vdda) pmos1 l=180n w=1u m=1
	mppd1 (net158 xpd vdda vdda) pmos1 l=1.1e-07n w=1.3e-06u m=1
	mps11 (net31 net158 vdda vdda) pmos1 l=180n w=1u m=1
	mpd11 (net56 inn net31 net31) pmos1 l=180n w=1u m=1
	mp001 (out net158 vdda vdda) pmos1 l=180n w=1u m=1
	mpd12 (net13 inp net31 net31) pmos1 l=180n w=1u m=1
	mpb01 (net158 net158 vdda vdda) pmos1 l=1.9e-07n w=1.0e-06u m=1
ends OPAMP1_variant860

subckt OPAMP1_variant861 inn inp out pd xpd vdda vssa
	xd1 (vssa vdda) prim_nwd AREA=6.13907e-9 PJ=476.6e-6 m=1
	xi0 (vssa net69) prim_nd AREA=1e-12 PJ=4e-6 m=1
	xi3 (net51 vdda) prim_pd AREA=790e-15 PJ=3.3e-6 m=1
	xr0 (vssa vdda net51) prim_rdiffp l=2.1e-6 w=700e-9 m=1
	xr1 (vdda vdda net69) prim_rdiffp l=1.8e-07 w=1.9e-06 m=1
	xcc01 (net12 out) prim_cpoly c=1p m=1
	mnm12 (net13 net56 vssa vssa) nmos1 l=180n w=1u m=1
	mnm11 (net56 net56 vssa vssa) nmos1 l=2.4e-07n w=1.3e-06u m=1
	mnb02 (net27 net27 net21 vssa) nmos1 l=180n w=1u m=1
	mnpd1 (net21 xpd vssa vssa) nmos1 l=180n w=1u m=1
	mn001 (out net13 vssa vssa) nmos1 l=180n w=1u m=1
	mnpd2 (net13 pd vssa vssa) nmos1 l=180n w=1u m=1
	mnc01 (net13 net69 net12 vssa) nmos1 l=180n w=1u m=1
	mpb02 (net27 net51 net158 vdda) pmos1 l=180n w=1u m=1
	mppd1 (net158 xpd vdda vdda) pmos1 l=180n w=1u m=1
	mps11 (net31 net158 vdda vdda) pmos1 l=180n w=1u m=1
	mpd11 (net56 inn net31 net31) pmos1 l=180n w=1u m=1
	mp001 (out net158 vdda vdda) pmos1 l=180n w=1u m=1
	mpd12 (net13 inp net31 net31) pmos1 l=180n w=1u m=1
	mpb01 (net158 net158 vdda vdda) pmos1 l=180n w=1u m=1
ends OPAMP1_variant861

subckt OPAMP1_variant862 inn inp out pd xpd vdda vssa
	xd1 (vssa vdda) prim_nwd AREA=6.13907e-9 PJ=476.6e-6 m=1
	xi0 (vssa net69) prim_nd AREA=1e-12 PJ=4e-6 m=1
	xi3 (net51 vdda) prim_pd AREA=790e-15 PJ=3.3e-6 m=1
	xr0 (vssa vdda net51) prim_rdiffp l=2.3e-07 w=1.2e-06 m=1
	xr1 (vdda vdda net69) prim_rdiffp l=2.6e-07 w=1.2e-06 m=1
	xcc01 (net12 out) prim_cpoly c=1p m=1
	mnm12 (net13 net56 vssa vssa) nmos1 l=180n w=1u m=1
	mnm11 (net56 net56 vssa vssa) nmos1 l=180n w=1u m=1
	mnb02 (net27 net27 net21 vssa) nmos1 l=2.2e-07n w=1.9e-06u m=1
	mnpd1 (net21 xpd vssa vssa) nmos1 l=180n w=1u m=1
	mn001 (out net13 vssa vssa) nmos1 l=180n w=1u m=1
	mnpd2 (net13 pd vssa vssa) nmos1 l=2.1e-07n w=1.7e-06u m=1
	mnc01 (net13 net69 net12 vssa) nmos1 l=180n w=1u m=1
	mpb02 (net27 net51 net158 vdda) pmos1 l=180n w=1u m=1
	mppd1 (net158 xpd vdda vdda) pmos1 l=180n w=1u m=1
	mps11 (net31 net158 vdda vdda) pmos1 l=180n w=1u m=1
	mpd11 (net56 inn net31 net31) pmos1 l=180n w=1u m=1
	mp001 (out net158 vdda vdda) pmos1 l=180n w=1u m=1
	mpd12 (net13 inp net31 net31) pmos1 l=180n w=1u m=1
	mpb01 (net158 net158 vdda vdda) pmos1 l=180n w=1u m=1
ends OPAMP1_variant862

subckt OPAMP1_variant863 inn inp out pd xpd vdda vssa
	xd1 (vssa vdda) prim_nwd AREA=6.13907e-9 PJ=476.6e-6 m=1
	xi0 (vssa net69) prim_nd AREA=1e-12 PJ=4e-6 m=1
	xi3 (net51 vdda) prim_pd AREA=790e-15 PJ=3.3e-6 m=1
	xr0 (vssa vdda net51) prim_rdiffp l=2.1e-6 w=700e-9 m=1
	xr1 (vdda vdda net69) prim_rdiffp l=2.1e-6 w=700e-9 m=1
	xcc01 (net12 out) prim_cpoly c=1p m=1
	mnm12 (net13 net56 vssa vssa) nmos1 l=180n w=1u m=1
	mnm11 (net56 net56 vssa vssa) nmos1 l=180n w=1u m=1
	mnb02 (net27 net27 net21 vssa) nmos1 l=180n w=1u m=1
	mnpd1 (net21 xpd vssa vssa) nmos1 l=180n w=1u m=1
	mn001 (out net13 vssa vssa) nmos1 l=2.2e-07n w=1.5e-06u m=1
	mnpd2 (net13 pd vssa vssa) nmos1 l=180n w=1u m=1
	mnc01 (net13 net69 net12 vssa) nmos1 l=180n w=1u m=1
	mpb02 (net27 net51 net158 vdda) pmos1 l=180n w=1u m=1
	mppd1 (net158 xpd vdda vdda) pmos1 l=180n w=1u m=1
	mps11 (net31 net158 vdda vdda) pmos1 l=180n w=1u m=1
	mpd11 (net56 inn net31 net31) pmos1 l=180n w=1u m=1
	mp001 (out net158 vdda vdda) pmos1 l=180n w=1u m=1
	mpd12 (net13 inp net31 net31) pmos1 l=2.3e-07n w=6.5e-07u m=1
	mpb01 (net158 net158 vdda vdda) pmos1 l=1.5e-07n w=1.8e-06u m=1
ends OPAMP1_variant863

subckt OPAMP1_variant864 inn inp out pd xpd vdda vssa
	xd1 (vssa vdda) prim_nwd AREA=6.13907e-9 PJ=476.6e-6 m=1
	xi0 (vssa net69) prim_nd AREA=1e-12 PJ=4e-6 m=1
	xi3 (net51 vdda) prim_pd AREA=790e-15 PJ=3.3e-6 m=1
	xr0 (vssa vdda net51) prim_rdiffp l=2.1e-6 w=700e-9 m=1
	xr1 (vdda vdda net69) prim_rdiffp l=2.1e-6 w=700e-9 m=1
	xcc01 (net12 out) prim_cpoly c=1p m=1
	mnm12 (net13 net56 vssa vssa) nmos1 l=2.4e-07n w=1.2e-06u m=1
	mnm11 (net56 net56 vssa vssa) nmos1 l=180n w=1u m=1
	mnb02 (net27 net27 net21 vssa) nmos1 l=180n w=1u m=1
	mnpd1 (net21 xpd vssa vssa) nmos1 l=2.8e-07n w=5.2e-07u m=1
	mn001 (out net13 vssa vssa) nmos1 l=2.2e-07n w=1.0e-06u m=1
	mnpd2 (net13 pd vssa vssa) nmos1 l=180n w=1u m=1
	mnc01 (net13 net69 net12 vssa) nmos1 l=180n w=1u m=1
	mpb02 (net27 net51 net158 vdda) pmos1 l=180n w=1u m=1
	mppd1 (net158 xpd vdda vdda) pmos1 l=1.6e-07n w=1.9e-06u m=1
	mps11 (net31 net158 vdda vdda) pmos1 l=180n w=1u m=1
	mpd11 (net56 inn net31 net31) pmos1 l=180n w=1u m=1
	mp001 (out net158 vdda vdda) pmos1 l=180n w=1u m=1
	mpd12 (net13 inp net31 net31) pmos1 l=180n w=1u m=1
	mpb01 (net158 net158 vdda vdda) pmos1 l=180n w=1u m=1
ends OPAMP1_variant864

subckt OPAMP1_variant865 inn inp out pd xpd vdda vssa
	xd1 (vssa vdda) prim_nwd AREA=6.13907e-9 PJ=476.6e-6 m=1
	xi0 (vssa net69) prim_nd AREA=1e-12 PJ=4e-6 m=1
	xi3 (net51 vdda) prim_pd AREA=790e-15 PJ=3.3e-6 m=1
	xr0 (vssa vdda net51) prim_rdiffp l=1.7e-07 w=7.3e-07 m=1
	xr1 (vdda vdda net69) prim_rdiffp l=2.1e-6 w=700e-9 m=1
	xcc01 (net12 out) prim_cpoly c=1p m=1
	mnm12 (net13 net56 vssa vssa) nmos1 l=180n w=1u m=1
	mnm11 (net56 net56 vssa vssa) nmos1 l=180n w=1u m=1
	mnb02 (net27 net27 net21 vssa) nmos1 l=180n w=1u m=1
	mnpd1 (net21 xpd vssa vssa) nmos1 l=180n w=1u m=1
	mn001 (out net13 vssa vssa) nmos1 l=180n w=1u m=1
	mnpd2 (net13 pd vssa vssa) nmos1 l=180n w=1u m=1
	mnc01 (net13 net69 net12 vssa) nmos1 l=2.4e-07n w=1.2e-06u m=1
	mpb02 (net27 net51 net158 vdda) pmos1 l=180n w=1u m=1
	mppd1 (net158 xpd vdda vdda) pmos1 l=180n w=1u m=1
	mps11 (net31 net158 vdda vdda) pmos1 l=180n w=1u m=1
	mpd11 (net56 inn net31 net31) pmos1 l=180n w=1u m=1
	mp001 (out net158 vdda vdda) pmos1 l=180n w=1u m=1
	mpd12 (net13 inp net31 net31) pmos1 l=180n w=1u m=1
	mpb01 (net158 net158 vdda vdda) pmos1 l=180n w=1u m=1
ends OPAMP1_variant865

subckt OPAMP1_variant866 inn inp out pd xpd vdda vssa
	xd1 (vssa vdda) prim_nwd AREA=6.13907e-9 PJ=476.6e-6 m=1
	xi0 (vssa net69) prim_nd AREA=1e-12 PJ=4e-6 m=1
	xi3 (net51 vdda) prim_pd AREA=4.1e-09 PJ=8.6e-05 m=1
	xr0 (vssa vdda net51) prim_rdiffp l=2.1e-6 w=700e-9 m=1
	xr1 (vdda vdda net69) prim_rdiffp l=2.1e-6 w=700e-9 m=1
	xcc01 (net12 out) prim_cpoly c=1p m=1
	mnm12 (net13 net56 vssa vssa) nmos1 l=2.3e-07n w=5.7e-07u m=1
	mnm11 (net56 net56 vssa vssa) nmos1 l=1.2e-07n w=1.7e-06u m=1
	mnb02 (net27 net27 net21 vssa) nmos1 l=180n w=1u m=1
	mnpd1 (net21 xpd vssa vssa) nmos1 l=180n w=1u m=1
	mn001 (out net13 vssa vssa) nmos1 l=180n w=1u m=1
	mnpd2 (net13 pd vssa vssa) nmos1 l=180n w=1u m=1
	mnc01 (net13 net69 net12 vssa) nmos1 l=180n w=1u m=1
	mpb02 (net27 net51 net158 vdda) pmos1 l=180n w=1u m=1
	mppd1 (net158 xpd vdda vdda) pmos1 l=180n w=1u m=1
	mps11 (net31 net158 vdda vdda) pmos1 l=180n w=1u m=1
	mpd11 (net56 inn net31 net31) pmos1 l=180n w=1u m=1
	mp001 (out net158 vdda vdda) pmos1 l=180n w=1u m=1
	mpd12 (net13 inp net31 net31) pmos1 l=180n w=1u m=1
	mpb01 (net158 net158 vdda vdda) pmos1 l=180n w=1u m=1
ends OPAMP1_variant866

subckt OPAMP1_variant867 inn inp out pd xpd vdda vssa
	xd1 (vssa vdda) prim_nwd AREA=6.13907e-9 PJ=476.6e-6 m=1
	xi0 (vssa net69) prim_nd AREA=1e-12 PJ=4e-6 m=1
	xi3 (net51 vdda) prim_pd AREA=790e-15 PJ=3.3e-6 m=1
	xr0 (vssa vdda net51) prim_rdiffp l=2.1e-6 w=700e-9 m=1
	xr1 (vdda vdda net69) prim_rdiffp l=2.1e-6 w=700e-9 m=1
	xcc01 (net12 out) prim_cpoly c=1p m=1
	mnm12 (net13 net56 vssa vssa) nmos1 l=180n w=1u m=1
	mnm11 (net56 net56 vssa vssa) nmos1 l=180n w=1u m=1
	mnb02 (net27 net27 net21 vssa) nmos1 l=180n w=1u m=1
	mnpd1 (net21 xpd vssa vssa) nmos1 l=2.1e-07n w=5.6e-07u m=1
	mn001 (out net13 vssa vssa) nmos1 l=180n w=1u m=1
	mnpd2 (net13 pd vssa vssa) nmos1 l=180n w=1u m=1
	mnc01 (net13 net69 net12 vssa) nmos1 l=180n w=1u m=1
	mpb02 (net27 net51 net158 vdda) pmos1 l=1.6e-07n w=2.0e-06u m=1
	mppd1 (net158 xpd vdda vdda) pmos1 l=180n w=1u m=1
	mps11 (net31 net158 vdda vdda) pmos1 l=1.2e-07n w=7.9e-07u m=1
	mpd11 (net56 inn net31 net31) pmos1 l=180n w=1u m=1
	mp001 (out net158 vdda vdda) pmos1 l=180n w=1u m=1
	mpd12 (net13 inp net31 net31) pmos1 l=2.9e-07n w=1.2e-06u m=1
	mpb01 (net158 net158 vdda vdda) pmos1 l=180n w=1u m=1
ends OPAMP1_variant867

subckt OPAMP1_variant868 inn inp out pd xpd vdda vssa
	xd1 (vssa vdda) prim_nwd AREA=6.13907e-9 PJ=476.6e-6 m=1
	xi0 (vssa net69) prim_nd AREA=5.1e-09 PJ=6.2e-05 m=1
	xi3 (net51 vdda) prim_pd AREA=790e-15 PJ=3.3e-6 m=1
	xr0 (vssa vdda net51) prim_rdiffp l=1.7e-07 w=1.2e-06 m=1
	xr1 (vdda vdda net69) prim_rdiffp l=2.1e-6 w=700e-9 m=1
	xcc01 (net12 out) prim_cpoly c=9.4e-13p m=1
	mnm12 (net13 net56 vssa vssa) nmos1 l=180n w=1u m=1
	mnm11 (net56 net56 vssa vssa) nmos1 l=180n w=1u m=1
	mnb02 (net27 net27 net21 vssa) nmos1 l=180n w=1u m=1
	mnpd1 (net21 xpd vssa vssa) nmos1 l=180n w=1u m=1
	mn001 (out net13 vssa vssa) nmos1 l=1.3e-07n w=1.2e-06u m=1
	mnpd2 (net13 pd vssa vssa) nmos1 l=180n w=1u m=1
	mnc01 (net13 net69 net12 vssa) nmos1 l=2.1e-07n w=1.4e-06u m=1
	mpb02 (net27 net51 net158 vdda) pmos1 l=180n w=1u m=1
	mppd1 (net158 xpd vdda vdda) pmos1 l=180n w=1u m=1
	mps11 (net31 net158 vdda vdda) pmos1 l=180n w=1u m=1
	mpd11 (net56 inn net31 net31) pmos1 l=180n w=1u m=1
	mp001 (out net158 vdda vdda) pmos1 l=180n w=1u m=1
	mpd12 (net13 inp net31 net31) pmos1 l=180n w=1u m=1
	mpb01 (net158 net158 vdda vdda) pmos1 l=180n w=1u m=1
ends OPAMP1_variant868

subckt OPAMP1_variant869 inn inp out pd xpd vdda vssa
	xd1 (vssa vdda) prim_nwd AREA=6.13907e-9 PJ=476.6e-6 m=1
	xi0 (vssa net69) prim_nd AREA=4.0e-09 PJ=9.1e-05 m=1
	xi3 (net51 vdda) prim_pd AREA=790e-15 PJ=3.3e-6 m=1
	xr0 (vssa vdda net51) prim_rdiffp l=2.1e-6 w=700e-9 m=1
	xr1 (vdda vdda net69) prim_rdiffp l=1.2e-07 w=1.6e-06 m=1
	xcc01 (net12 out) prim_cpoly c=1p m=1
	mnm12 (net13 net56 vssa vssa) nmos1 l=180n w=1u m=1
	mnm11 (net56 net56 vssa vssa) nmos1 l=180n w=1u m=1
	mnb02 (net27 net27 net21 vssa) nmos1 l=180n w=1u m=1
	mnpd1 (net21 xpd vssa vssa) nmos1 l=180n w=1u m=1
	mn001 (out net13 vssa vssa) nmos1 l=180n w=1u m=1
	mnpd2 (net13 pd vssa vssa) nmos1 l=180n w=1u m=1
	mnc01 (net13 net69 net12 vssa) nmos1 l=180n w=1u m=1
	mpb02 (net27 net51 net158 vdda) pmos1 l=180n w=1u m=1
	mppd1 (net158 xpd vdda vdda) pmos1 l=180n w=1u m=1
	mps11 (net31 net158 vdda vdda) pmos1 l=1.9e-07n w=1.7e-06u m=1
	mpd11 (net56 inn net31 net31) pmos1 l=180n w=1u m=1
	mp001 (out net158 vdda vdda) pmos1 l=180n w=1u m=1
	mpd12 (net13 inp net31 net31) pmos1 l=180n w=1u m=1
	mpb01 (net158 net158 vdda vdda) pmos1 l=180n w=1u m=1
ends OPAMP1_variant869

subckt OPAMP1_variant870 inn inp out pd xpd vdda vssa
	xd1 (vssa vdda) prim_nwd AREA=6.13907e-9 PJ=476.6e-6 m=1
	xi0 (vssa net69) prim_nd AREA=1e-12 PJ=4e-6 m=1
	xi3 (net51 vdda) prim_pd AREA=790e-15 PJ=3.3e-6 m=1
	xr0 (vssa vdda net51) prim_rdiffp l=2.1e-6 w=700e-9 m=1
	xr1 (vdda vdda net69) prim_rdiffp l=2.1e-6 w=700e-9 m=1
	xcc01 (net12 out) prim_cpoly c=1p m=1
	mnm12 (net13 net56 vssa vssa) nmos1 l=180n w=1u m=1
	mnm11 (net56 net56 vssa vssa) nmos1 l=180n w=1u m=1
	mnb02 (net27 net27 net21 vssa) nmos1 l=2.5e-07n w=6.2e-07u m=1
	mnpd1 (net21 xpd vssa vssa) nmos1 l=180n w=1u m=1
	mn001 (out net13 vssa vssa) nmos1 l=1.7e-07n w=1.5e-06u m=1
	mnpd2 (net13 pd vssa vssa) nmos1 l=180n w=1u m=1
	mnc01 (net13 net69 net12 vssa) nmos1 l=180n w=1u m=1
	mpb02 (net27 net51 net158 vdda) pmos1 l=180n w=1u m=1
	mppd1 (net158 xpd vdda vdda) pmos1 l=180n w=1u m=1
	mps11 (net31 net158 vdda vdda) pmos1 l=180n w=1u m=1
	mpd11 (net56 inn net31 net31) pmos1 l=180n w=1u m=1
	mp001 (out net158 vdda vdda) pmos1 l=2.1e-07n w=5.6e-07u m=1
	mpd12 (net13 inp net31 net31) pmos1 l=2.6e-07n w=1.9e-06u m=1
	mpb01 (net158 net158 vdda vdda) pmos1 l=180n w=1u m=1
ends OPAMP1_variant870

subckt OPAMP1_variant871 inn inp out pd xpd vdda vssa
	xd1 (vssa vdda) prim_nwd AREA=6.13907e-9 PJ=476.6e-6 m=1
	xi0 (vssa net69) prim_nd AREA=1e-12 PJ=4e-6 m=1
	xi3 (net51 vdda) prim_pd AREA=790e-15 PJ=3.3e-6 m=1
	xr0 (vssa vdda net51) prim_rdiffp l=2.1e-6 w=700e-9 m=1
	xr1 (vdda vdda net69) prim_rdiffp l=2.7e-07 w=1.6e-06 m=1
	xcc01 (net12 out) prim_cpoly c=1p m=1
	mnm12 (net13 net56 vssa vssa) nmos1 l=2.6e-07n w=5.2e-07u m=1
	mnm11 (net56 net56 vssa vssa) nmos1 l=180n w=1u m=1
	mnb02 (net27 net27 net21 vssa) nmos1 l=180n w=1u m=1
	mnpd1 (net21 xpd vssa vssa) nmos1 l=180n w=1u m=1
	mn001 (out net13 vssa vssa) nmos1 l=180n w=1u m=1
	mnpd2 (net13 pd vssa vssa) nmos1 l=180n w=1u m=1
	mnc01 (net13 net69 net12 vssa) nmos1 l=180n w=1u m=1
	mpb02 (net27 net51 net158 vdda) pmos1 l=180n w=1u m=1
	mppd1 (net158 xpd vdda vdda) pmos1 l=180n w=1u m=1
	mps11 (net31 net158 vdda vdda) pmos1 l=180n w=1u m=1
	mpd11 (net56 inn net31 net31) pmos1 l=180n w=1u m=1
	mp001 (out net158 vdda vdda) pmos1 l=180n w=1u m=1
	mpd12 (net13 inp net31 net31) pmos1 l=180n w=1u m=1
	mpb01 (net158 net158 vdda vdda) pmos1 l=180n w=1u m=1
ends OPAMP1_variant871

subckt OPAMP1_variant872 inn inp out pd xpd vdda vssa
	xd1 (vssa vdda) prim_nwd AREA=1.8e-09 PJ=2.0e-05 m=1
	xi0 (vssa net69) prim_nd AREA=1e-12 PJ=4e-6 m=1
	xi3 (net51 vdda) prim_pd AREA=790e-15 PJ=3.3e-6 m=1
	xr0 (vssa vdda net51) prim_rdiffp l=2.1e-6 w=700e-9 m=1
	xr1 (vdda vdda net69) prim_rdiffp l=2.1e-6 w=700e-9 m=1
	xcc01 (net12 out) prim_cpoly c=1p m=1
	mnm12 (net13 net56 vssa vssa) nmos1 l=180n w=1u m=1
	mnm11 (net56 net56 vssa vssa) nmos1 l=1.2e-07n w=1.4e-06u m=1
	mnb02 (net27 net27 net21 vssa) nmos1 l=180n w=1u m=1
	mnpd1 (net21 xpd vssa vssa) nmos1 l=180n w=1u m=1
	mn001 (out net13 vssa vssa) nmos1 l=180n w=1u m=1
	mnpd2 (net13 pd vssa vssa) nmos1 l=1.9e-07n w=8.0e-07u m=1
	mnc01 (net13 net69 net12 vssa) nmos1 l=180n w=1u m=1
	mpb02 (net27 net51 net158 vdda) pmos1 l=180n w=1u m=1
	mppd1 (net158 xpd vdda vdda) pmos1 l=180n w=1u m=1
	mps11 (net31 net158 vdda vdda) pmos1 l=180n w=1u m=1
	mpd11 (net56 inn net31 net31) pmos1 l=180n w=1u m=1
	mp001 (out net158 vdda vdda) pmos1 l=180n w=1u m=1
	mpd12 (net13 inp net31 net31) pmos1 l=1.1e-07n w=1.7e-06u m=1
	mpb01 (net158 net158 vdda vdda) pmos1 l=1.1e-07n w=8.4e-07u m=1
ends OPAMP1_variant872

subckt OPAMP1_variant873 inn inp out pd xpd vdda vssa
	xd1 (vssa vdda) prim_nwd AREA=2.1e-09 PJ=9.7e-05 m=1
	xi0 (vssa net69) prim_nd AREA=1.3e-09 PJ=9.4e-05 m=1
	xi3 (net51 vdda) prim_pd AREA=4.9e-09 PJ=1.4e-06 m=1
	xr0 (vssa vdda net51) prim_rdiffp l=2.1e-6 w=700e-9 m=1
	xr1 (vdda vdda net69) prim_rdiffp l=2.1e-6 w=700e-9 m=1
	xcc01 (net12 out) prim_cpoly c=1p m=1
	mnm12 (net13 net56 vssa vssa) nmos1 l=2.6e-07n w=1.4e-06u m=1
	mnm11 (net56 net56 vssa vssa) nmos1 l=2.4e-07n w=7.4e-07u m=1
	mnb02 (net27 net27 net21 vssa) nmos1 l=180n w=1u m=1
	mnpd1 (net21 xpd vssa vssa) nmos1 l=180n w=1u m=1
	mn001 (out net13 vssa vssa) nmos1 l=180n w=1u m=1
	mnpd2 (net13 pd vssa vssa) nmos1 l=180n w=1u m=1
	mnc01 (net13 net69 net12 vssa) nmos1 l=180n w=1u m=1
	mpb02 (net27 net51 net158 vdda) pmos1 l=180n w=1u m=1
	mppd1 (net158 xpd vdda vdda) pmos1 l=180n w=1u m=1
	mps11 (net31 net158 vdda vdda) pmos1 l=180n w=1u m=1
	mpd11 (net56 inn net31 net31) pmos1 l=180n w=1u m=1
	mp001 (out net158 vdda vdda) pmos1 l=180n w=1u m=1
	mpd12 (net13 inp net31 net31) pmos1 l=180n w=1u m=1
	mpb01 (net158 net158 vdda vdda) pmos1 l=180n w=1u m=1
ends OPAMP1_variant873

subckt OPAMP1_variant874 inn inp out pd xpd vdda vssa
	xd1 (vssa vdda) prim_nwd AREA=6.13907e-9 PJ=476.6e-6 m=1
	xi0 (vssa net69) prim_nd AREA=1e-12 PJ=4e-6 m=1
	xi3 (net51 vdda) prim_pd AREA=790e-15 PJ=3.3e-6 m=1
	xr0 (vssa vdda net51) prim_rdiffp l=2.1e-6 w=700e-9 m=1
	xr1 (vdda vdda net69) prim_rdiffp l=2.1e-6 w=700e-9 m=1
	xcc01 (net12 out) prim_cpoly c=1p m=1
	mnm12 (net13 net56 vssa vssa) nmos1 l=180n w=1u m=1
	mnm11 (net56 net56 vssa vssa) nmos1 l=180n w=1u m=1
	mnb02 (net27 net27 net21 vssa) nmos1 l=1.4e-07n w=1.1e-06u m=1
	mnpd1 (net21 xpd vssa vssa) nmos1 l=1.8e-07n w=2.0e-06u m=1
	mn001 (out net13 vssa vssa) nmos1 l=180n w=1u m=1
	mnpd2 (net13 pd vssa vssa) nmos1 l=180n w=1u m=1
	mnc01 (net13 net69 net12 vssa) nmos1 l=180n w=1u m=1
	mpb02 (net27 net51 net158 vdda) pmos1 l=180n w=1u m=1
	mppd1 (net158 xpd vdda vdda) pmos1 l=180n w=1u m=1
	mps11 (net31 net158 vdda vdda) pmos1 l=2.3e-07n w=1.3e-06u m=1
	mpd11 (net56 inn net31 net31) pmos1 l=180n w=1u m=1
	mp001 (out net158 vdda vdda) pmos1 l=180n w=1u m=1
	mpd12 (net13 inp net31 net31) pmos1 l=180n w=1u m=1
	mpb01 (net158 net158 vdda vdda) pmos1 l=180n w=1u m=1
ends OPAMP1_variant874

subckt OPAMP1_variant875 inn inp out pd xpd vdda vssa
	xd1 (vssa vdda) prim_nwd AREA=6.13907e-9 PJ=476.6e-6 m=1
	xi0 (vssa net69) prim_nd AREA=1e-12 PJ=4e-6 m=1
	xi3 (net51 vdda) prim_pd AREA=5.5e-09 PJ=3.3e-05 m=1
	xr0 (vssa vdda net51) prim_rdiffp l=1.6e-07 w=9.8e-07 m=1
	xr1 (vdda vdda net69) prim_rdiffp l=2.1e-6 w=700e-9 m=1
	xcc01 (net12 out) prim_cpoly c=1p m=1
	mnm12 (net13 net56 vssa vssa) nmos1 l=180n w=1u m=1
	mnm11 (net56 net56 vssa vssa) nmos1 l=180n w=1u m=1
	mnb02 (net27 net27 net21 vssa) nmos1 l=180n w=1u m=1
	mnpd1 (net21 xpd vssa vssa) nmos1 l=180n w=1u m=1
	mn001 (out net13 vssa vssa) nmos1 l=180n w=1u m=1
	mnpd2 (net13 pd vssa vssa) nmos1 l=180n w=1u m=1
	mnc01 (net13 net69 net12 vssa) nmos1 l=180n w=1u m=1
	mpb02 (net27 net51 net158 vdda) pmos1 l=180n w=1u m=1
	mppd1 (net158 xpd vdda vdda) pmos1 l=180n w=1u m=1
	mps11 (net31 net158 vdda vdda) pmos1 l=180n w=1u m=1
	mpd11 (net56 inn net31 net31) pmos1 l=180n w=1u m=1
	mp001 (out net158 vdda vdda) pmos1 l=180n w=1u m=1
	mpd12 (net13 inp net31 net31) pmos1 l=180n w=1u m=1
	mpb01 (net158 net158 vdda vdda) pmos1 l=180n w=1u m=1
ends OPAMP1_variant875

subckt OPAMP1_variant876 inn inp out pd xpd vdda vssa
	xd1 (vssa vdda) prim_nwd AREA=6.13907e-9 PJ=476.6e-6 m=1
	xi0 (vssa net69) prim_nd AREA=1e-12 PJ=4e-6 m=1
	xi3 (net51 vdda) prim_pd AREA=6.0e-09 PJ=6.3e-05 m=1
	xr0 (vssa vdda net51) prim_rdiffp l=2.1e-6 w=700e-9 m=1
	xr1 (vdda vdda net69) prim_rdiffp l=2.1e-6 w=700e-9 m=1
	xcc01 (net12 out) prim_cpoly c=1p m=1
	mnm12 (net13 net56 vssa vssa) nmos1 l=180n w=1u m=1
	mnm11 (net56 net56 vssa vssa) nmos1 l=2.4e-07n w=9.9e-07u m=1
	mnb02 (net27 net27 net21 vssa) nmos1 l=180n w=1u m=1
	mnpd1 (net21 xpd vssa vssa) nmos1 l=180n w=1u m=1
	mn001 (out net13 vssa vssa) nmos1 l=180n w=1u m=1
	mnpd2 (net13 pd vssa vssa) nmos1 l=180n w=1u m=1
	mnc01 (net13 net69 net12 vssa) nmos1 l=180n w=1u m=1
	mpb02 (net27 net51 net158 vdda) pmos1 l=180n w=1u m=1
	mppd1 (net158 xpd vdda vdda) pmos1 l=180n w=1u m=1
	mps11 (net31 net158 vdda vdda) pmos1 l=180n w=1u m=1
	mpd11 (net56 inn net31 net31) pmos1 l=180n w=1u m=1
	mp001 (out net158 vdda vdda) pmos1 l=180n w=1u m=1
	mpd12 (net13 inp net31 net31) pmos1 l=180n w=1u m=1
	mpb01 (net158 net158 vdda vdda) pmos1 l=180n w=1u m=1
ends OPAMP1_variant876

subckt OPAMP1_variant877 inn inp out pd xpd vdda vssa
	xd1 (vssa vdda) prim_nwd AREA=6.13907e-9 PJ=476.6e-6 m=1
	xi0 (vssa net69) prim_nd AREA=1e-12 PJ=4e-6 m=1
	xi3 (net51 vdda) prim_pd AREA=790e-15 PJ=3.3e-6 m=1
	xr0 (vssa vdda net51) prim_rdiffp l=2.1e-6 w=700e-9 m=1
	xr1 (vdda vdda net69) prim_rdiffp l=2.4e-07 w=5.7e-07 m=1
	xcc01 (net12 out) prim_cpoly c=1p m=1
	mnm12 (net13 net56 vssa vssa) nmos1 l=180n w=1u m=1
	mnm11 (net56 net56 vssa vssa) nmos1 l=180n w=1u m=1
	mnb02 (net27 net27 net21 vssa) nmos1 l=180n w=1u m=1
	mnpd1 (net21 xpd vssa vssa) nmos1 l=180n w=1u m=1
	mn001 (out net13 vssa vssa) nmos1 l=180n w=1u m=1
	mnpd2 (net13 pd vssa vssa) nmos1 l=180n w=1u m=1
	mnc01 (net13 net69 net12 vssa) nmos1 l=180n w=1u m=1
	mpb02 (net27 net51 net158 vdda) pmos1 l=180n w=1u m=1
	mppd1 (net158 xpd vdda vdda) pmos1 l=3.0e-07n w=8.8e-07u m=1
	mps11 (net31 net158 vdda vdda) pmos1 l=180n w=1u m=1
	mpd11 (net56 inn net31 net31) pmos1 l=180n w=1u m=1
	mp001 (out net158 vdda vdda) pmos1 l=180n w=1u m=1
	mpd12 (net13 inp net31 net31) pmos1 l=180n w=1u m=1
	mpb01 (net158 net158 vdda vdda) pmos1 l=180n w=1u m=1
ends OPAMP1_variant877

subckt OPAMP1_variant878 inn inp out pd xpd vdda vssa
	xd1 (vssa vdda) prim_nwd AREA=6.5e-09 PJ=6.2e-05 m=1
	xi0 (vssa net69) prim_nd AREA=1e-12 PJ=4e-6 m=1
	xi3 (net51 vdda) prim_pd AREA=790e-15 PJ=3.3e-6 m=1
	xr0 (vssa vdda net51) prim_rdiffp l=2.1e-6 w=700e-9 m=1
	xr1 (vdda vdda net69) prim_rdiffp l=2.1e-6 w=700e-9 m=1
	xcc01 (net12 out) prim_cpoly c=1p m=1
	mnm12 (net13 net56 vssa vssa) nmos1 l=180n w=1u m=1
	mnm11 (net56 net56 vssa vssa) nmos1 l=180n w=1u m=1
	mnb02 (net27 net27 net21 vssa) nmos1 l=180n w=1u m=1
	mnpd1 (net21 xpd vssa vssa) nmos1 l=180n w=1u m=1
	mn001 (out net13 vssa vssa) nmos1 l=2.2e-07n w=1.2e-06u m=1
	mnpd2 (net13 pd vssa vssa) nmos1 l=2.0e-07n w=1.6e-06u m=1
	mnc01 (net13 net69 net12 vssa) nmos1 l=180n w=1u m=1
	mpb02 (net27 net51 net158 vdda) pmos1 l=180n w=1u m=1
	mppd1 (net158 xpd vdda vdda) pmos1 l=180n w=1u m=1
	mps11 (net31 net158 vdda vdda) pmos1 l=180n w=1u m=1
	mpd11 (net56 inn net31 net31) pmos1 l=180n w=1u m=1
	mp001 (out net158 vdda vdda) pmos1 l=180n w=1u m=1
	mpd12 (net13 inp net31 net31) pmos1 l=180n w=1u m=1
	mpb01 (net158 net158 vdda vdda) pmos1 l=180n w=1u m=1
ends OPAMP1_variant878

subckt OPAMP1_variant879 inn inp out pd xpd vdda vssa
	xd1 (vssa vdda) prim_nwd AREA=6.13907e-9 PJ=476.6e-6 m=1
	xi0 (vssa net69) prim_nd AREA=1e-12 PJ=4e-6 m=1
	xi3 (net51 vdda) prim_pd AREA=6.9e-09 PJ=1.5e-05 m=1
	xr0 (vssa vdda net51) prim_rdiffp l=2.1e-6 w=700e-9 m=1
	xr1 (vdda vdda net69) prim_rdiffp l=2.1e-6 w=700e-9 m=1
	xcc01 (net12 out) prim_cpoly c=1p m=1
	mnm12 (net13 net56 vssa vssa) nmos1 l=180n w=1u m=1
	mnm11 (net56 net56 vssa vssa) nmos1 l=2.5e-07n w=1.2e-06u m=1
	mnb02 (net27 net27 net21 vssa) nmos1 l=180n w=1u m=1
	mnpd1 (net21 xpd vssa vssa) nmos1 l=180n w=1u m=1
	mn001 (out net13 vssa vssa) nmos1 l=180n w=1u m=1
	mnpd2 (net13 pd vssa vssa) nmos1 l=180n w=1u m=1
	mnc01 (net13 net69 net12 vssa) nmos1 l=180n w=1u m=1
	mpb02 (net27 net51 net158 vdda) pmos1 l=180n w=1u m=1
	mppd1 (net158 xpd vdda vdda) pmos1 l=180n w=1u m=1
	mps11 (net31 net158 vdda vdda) pmos1 l=180n w=1u m=1
	mpd11 (net56 inn net31 net31) pmos1 l=180n w=1u m=1
	mp001 (out net158 vdda vdda) pmos1 l=180n w=1u m=1
	mpd12 (net13 inp net31 net31) pmos1 l=180n w=1u m=1
	mpb01 (net158 net158 vdda vdda) pmos1 l=180n w=1u m=1
ends OPAMP1_variant879

subckt OPAMP1_variant880 inn inp out pd xpd vdda vssa
	xd1 (vssa vdda) prim_nwd AREA=6.13907e-9 PJ=476.6e-6 m=1
	xi0 (vssa net69) prim_nd AREA=1e-12 PJ=4e-6 m=1
	xi3 (net51 vdda) prim_pd AREA=790e-15 PJ=3.3e-6 m=1
	xr0 (vssa vdda net51) prim_rdiffp l=2.1e-6 w=700e-9 m=1
	xr1 (vdda vdda net69) prim_rdiffp l=2.1e-6 w=700e-9 m=1
	xcc01 (net12 out) prim_cpoly c=1p m=1
	mnm12 (net13 net56 vssa vssa) nmos1 l=180n w=1u m=1
	mnm11 (net56 net56 vssa vssa) nmos1 l=180n w=1u m=1
	mnb02 (net27 net27 net21 vssa) nmos1 l=180n w=1u m=1
	mnpd1 (net21 xpd vssa vssa) nmos1 l=2.4e-07n w=7.5e-07u m=1
	mn001 (out net13 vssa vssa) nmos1 l=180n w=1u m=1
	mnpd2 (net13 pd vssa vssa) nmos1 l=1.7e-07n w=8.2e-07u m=1
	mnc01 (net13 net69 net12 vssa) nmos1 l=1.3e-07n w=1.8e-06u m=1
	mpb02 (net27 net51 net158 vdda) pmos1 l=180n w=1u m=1
	mppd1 (net158 xpd vdda vdda) pmos1 l=180n w=1u m=1
	mps11 (net31 net158 vdda vdda) pmos1 l=180n w=1u m=1
	mpd11 (net56 inn net31 net31) pmos1 l=2.9e-07n w=1.8e-06u m=1
	mp001 (out net158 vdda vdda) pmos1 l=180n w=1u m=1
	mpd12 (net13 inp net31 net31) pmos1 l=2.6e-07n w=1.5e-06u m=1
	mpb01 (net158 net158 vdda vdda) pmos1 l=180n w=1u m=1
ends OPAMP1_variant880

subckt OPAMP1_variant881 inn inp out pd xpd vdda vssa
	xd1 (vssa vdda) prim_nwd AREA=6.13907e-9 PJ=476.6e-6 m=1
	xi0 (vssa net69) prim_nd AREA=1e-12 PJ=4e-6 m=1
	xi3 (net51 vdda) prim_pd AREA=790e-15 PJ=3.3e-6 m=1
	xr0 (vssa vdda net51) prim_rdiffp l=2.6e-07 w=1.5e-06 m=1
	xr1 (vdda vdda net69) prim_rdiffp l=2.1e-6 w=700e-9 m=1
	xcc01 (net12 out) prim_cpoly c=1.9e-12p m=1
	mnm12 (net13 net56 vssa vssa) nmos1 l=180n w=1u m=1
	mnm11 (net56 net56 vssa vssa) nmos1 l=180n w=1u m=1
	mnb02 (net27 net27 net21 vssa) nmos1 l=180n w=1u m=1
	mnpd1 (net21 xpd vssa vssa) nmos1 l=2.4e-07n w=5.4e-07u m=1
	mn001 (out net13 vssa vssa) nmos1 l=180n w=1u m=1
	mnpd2 (net13 pd vssa vssa) nmos1 l=180n w=1u m=1
	mnc01 (net13 net69 net12 vssa) nmos1 l=180n w=1u m=1
	mpb02 (net27 net51 net158 vdda) pmos1 l=180n w=1u m=1
	mppd1 (net158 xpd vdda vdda) pmos1 l=180n w=1u m=1
	mps11 (net31 net158 vdda vdda) pmos1 l=180n w=1u m=1
	mpd11 (net56 inn net31 net31) pmos1 l=180n w=1u m=1
	mp001 (out net158 vdda vdda) pmos1 l=180n w=1u m=1
	mpd12 (net13 inp net31 net31) pmos1 l=180n w=1u m=1
	mpb01 (net158 net158 vdda vdda) pmos1 l=180n w=1u m=1
ends OPAMP1_variant881

subckt OPAMP1_variant882 inn inp out pd xpd vdda vssa
	xd1 (vssa vdda) prim_nwd AREA=6.13907e-9 PJ=476.6e-6 m=1
	xi0 (vssa net69) prim_nd AREA=1e-12 PJ=4e-6 m=1
	xi3 (net51 vdda) prim_pd AREA=790e-15 PJ=3.3e-6 m=1
	xr0 (vssa vdda net51) prim_rdiffp l=2.1e-6 w=700e-9 m=1
	xr1 (vdda vdda net69) prim_rdiffp l=2.3e-07 w=1.7e-06 m=1
	xcc01 (net12 out) prim_cpoly c=1p m=1
	mnm12 (net13 net56 vssa vssa) nmos1 l=180n w=1u m=1
	mnm11 (net56 net56 vssa vssa) nmos1 l=1.1e-07n w=1.4e-06u m=1
	mnb02 (net27 net27 net21 vssa) nmos1 l=180n w=1u m=1
	mnpd1 (net21 xpd vssa vssa) nmos1 l=180n w=1u m=1
	mn001 (out net13 vssa vssa) nmos1 l=180n w=1u m=1
	mnpd2 (net13 pd vssa vssa) nmos1 l=180n w=1u m=1
	mnc01 (net13 net69 net12 vssa) nmos1 l=2.7e-07n w=6.0e-07u m=1
	mpb02 (net27 net51 net158 vdda) pmos1 l=180n w=1u m=1
	mppd1 (net158 xpd vdda vdda) pmos1 l=180n w=1u m=1
	mps11 (net31 net158 vdda vdda) pmos1 l=180n w=1u m=1
	mpd11 (net56 inn net31 net31) pmos1 l=180n w=1u m=1
	mp001 (out net158 vdda vdda) pmos1 l=180n w=1u m=1
	mpd12 (net13 inp net31 net31) pmos1 l=180n w=1u m=1
	mpb01 (net158 net158 vdda vdda) pmos1 l=180n w=1u m=1
ends OPAMP1_variant882

subckt OPAMP1_variant883 inn inp out pd xpd vdda vssa
	xd1 (vssa vdda) prim_nwd AREA=6.13907e-9 PJ=476.6e-6 m=1
	xi0 (vssa net69) prim_nd AREA=3.1e-09 PJ=8.2e-05 m=1
	xi3 (net51 vdda) prim_pd AREA=790e-15 PJ=3.3e-6 m=1
	xr0 (vssa vdda net51) prim_rdiffp l=1.3e-07 w=5.8e-07 m=1
	xr1 (vdda vdda net69) prim_rdiffp l=2.1e-6 w=700e-9 m=1
	xcc01 (net12 out) prim_cpoly c=1p m=1
	mnm12 (net13 net56 vssa vssa) nmos1 l=180n w=1u m=1
	mnm11 (net56 net56 vssa vssa) nmos1 l=180n w=1u m=1
	mnb02 (net27 net27 net21 vssa) nmos1 l=180n w=1u m=1
	mnpd1 (net21 xpd vssa vssa) nmos1 l=1.9e-07n w=1.8e-06u m=1
	mn001 (out net13 vssa vssa) nmos1 l=180n w=1u m=1
	mnpd2 (net13 pd vssa vssa) nmos1 l=180n w=1u m=1
	mnc01 (net13 net69 net12 vssa) nmos1 l=2.7e-07n w=6.2e-07u m=1
	mpb02 (net27 net51 net158 vdda) pmos1 l=180n w=1u m=1
	mppd1 (net158 xpd vdda vdda) pmos1 l=180n w=1u m=1
	mps11 (net31 net158 vdda vdda) pmos1 l=180n w=1u m=1
	mpd11 (net56 inn net31 net31) pmos1 l=180n w=1u m=1
	mp001 (out net158 vdda vdda) pmos1 l=180n w=1u m=1
	mpd12 (net13 inp net31 net31) pmos1 l=180n w=1u m=1
	mpb01 (net158 net158 vdda vdda) pmos1 l=180n w=1u m=1
ends OPAMP1_variant883

subckt OPAMP1_variant884 inn inp out pd xpd vdda vssa
	xd1 (vssa vdda) prim_nwd AREA=6.13907e-9 PJ=476.6e-6 m=1
	xi0 (vssa net69) prim_nd AREA=1e-12 PJ=4e-6 m=1
	xi3 (net51 vdda) prim_pd AREA=9.7e-09 PJ=4.6e-05 m=1
	xr0 (vssa vdda net51) prim_rdiffp l=2.1e-6 w=700e-9 m=1
	xr1 (vdda vdda net69) prim_rdiffp l=2.1e-6 w=700e-9 m=1
	xcc01 (net12 out) prim_cpoly c=1p m=1
	mnm12 (net13 net56 vssa vssa) nmos1 l=180n w=1u m=1
	mnm11 (net56 net56 vssa vssa) nmos1 l=180n w=1u m=1
	mnb02 (net27 net27 net21 vssa) nmos1 l=180n w=1u m=1
	mnpd1 (net21 xpd vssa vssa) nmos1 l=180n w=1u m=1
	mn001 (out net13 vssa vssa) nmos1 l=180n w=1u m=1
	mnpd2 (net13 pd vssa vssa) nmos1 l=180n w=1u m=1
	mnc01 (net13 net69 net12 vssa) nmos1 l=2.9e-07n w=1.5e-06u m=1
	mpb02 (net27 net51 net158 vdda) pmos1 l=180n w=1u m=1
	mppd1 (net158 xpd vdda vdda) pmos1 l=180n w=1u m=1
	mps11 (net31 net158 vdda vdda) pmos1 l=180n w=1u m=1
	mpd11 (net56 inn net31 net31) pmos1 l=180n w=1u m=1
	mp001 (out net158 vdda vdda) pmos1 l=1.4e-07n w=1.7e-06u m=1
	mpd12 (net13 inp net31 net31) pmos1 l=180n w=1u m=1
	mpb01 (net158 net158 vdda vdda) pmos1 l=180n w=1u m=1
ends OPAMP1_variant884

subckt OPAMP1_variant885 inn inp out pd xpd vdda vssa
	xd1 (vssa vdda) prim_nwd AREA=6.13907e-9 PJ=476.6e-6 m=1
	xi0 (vssa net69) prim_nd AREA=1e-12 PJ=4e-6 m=1
	xi3 (net51 vdda) prim_pd AREA=790e-15 PJ=3.3e-6 m=1
	xr0 (vssa vdda net51) prim_rdiffp l=2.1e-6 w=700e-9 m=1
	xr1 (vdda vdda net69) prim_rdiffp l=2.1e-6 w=700e-9 m=1
	xcc01 (net12 out) prim_cpoly c=9.6e-13p m=1
	mnm12 (net13 net56 vssa vssa) nmos1 l=1.8e-07n w=1.6e-06u m=1
	mnm11 (net56 net56 vssa vssa) nmos1 l=180n w=1u m=1
	mnb02 (net27 net27 net21 vssa) nmos1 l=180n w=1u m=1
	mnpd1 (net21 xpd vssa vssa) nmos1 l=180n w=1u m=1
	mn001 (out net13 vssa vssa) nmos1 l=180n w=1u m=1
	mnpd2 (net13 pd vssa vssa) nmos1 l=180n w=1u m=1
	mnc01 (net13 net69 net12 vssa) nmos1 l=180n w=1u m=1
	mpb02 (net27 net51 net158 vdda) pmos1 l=180n w=1u m=1
	mppd1 (net158 xpd vdda vdda) pmos1 l=180n w=1u m=1
	mps11 (net31 net158 vdda vdda) pmos1 l=180n w=1u m=1
	mpd11 (net56 inn net31 net31) pmos1 l=180n w=1u m=1
	mp001 (out net158 vdda vdda) pmos1 l=180n w=1u m=1
	mpd12 (net13 inp net31 net31) pmos1 l=180n w=1u m=1
	mpb01 (net158 net158 vdda vdda) pmos1 l=2.4e-07n w=6.5e-07u m=1
ends OPAMP1_variant885

subckt OPAMP1_variant886 inn inp out pd xpd vdda vssa
	xd1 (vssa vdda) prim_nwd AREA=6.13907e-9 PJ=476.6e-6 m=1
	xi0 (vssa net69) prim_nd AREA=1e-12 PJ=4e-6 m=1
	xi3 (net51 vdda) prim_pd AREA=790e-15 PJ=3.3e-6 m=1
	xr0 (vssa vdda net51) prim_rdiffp l=2.1e-6 w=700e-9 m=1
	xr1 (vdda vdda net69) prim_rdiffp l=2.1e-6 w=700e-9 m=1
	xcc01 (net12 out) prim_cpoly c=1p m=1
	mnm12 (net13 net56 vssa vssa) nmos1 l=180n w=1u m=1
	mnm11 (net56 net56 vssa vssa) nmos1 l=2.4e-07n w=1.2e-06u m=1
	mnb02 (net27 net27 net21 vssa) nmos1 l=180n w=1u m=1
	mnpd1 (net21 xpd vssa vssa) nmos1 l=1.9e-07n w=1.6e-06u m=1
	mn001 (out net13 vssa vssa) nmos1 l=180n w=1u m=1
	mnpd2 (net13 pd vssa vssa) nmos1 l=2.0e-07n w=1.4e-06u m=1
	mnc01 (net13 net69 net12 vssa) nmos1 l=180n w=1u m=1
	mpb02 (net27 net51 net158 vdda) pmos1 l=180n w=1u m=1
	mppd1 (net158 xpd vdda vdda) pmos1 l=1.7e-07n w=9.0e-07u m=1
	mps11 (net31 net158 vdda vdda) pmos1 l=180n w=1u m=1
	mpd11 (net56 inn net31 net31) pmos1 l=180n w=1u m=1
	mp001 (out net158 vdda vdda) pmos1 l=180n w=1u m=1
	mpd12 (net13 inp net31 net31) pmos1 l=2.3e-07n w=1.8e-06u m=1
	mpb01 (net158 net158 vdda vdda) pmos1 l=180n w=1u m=1
ends OPAMP1_variant886

subckt OPAMP1_variant887 inn inp out pd xpd vdda vssa
	xd1 (vssa vdda) prim_nwd AREA=6.13907e-9 PJ=476.6e-6 m=1
	xi0 (vssa net69) prim_nd AREA=1e-12 PJ=4e-6 m=1
	xi3 (net51 vdda) prim_pd AREA=790e-15 PJ=3.3e-6 m=1
	xr0 (vssa vdda net51) prim_rdiffp l=2.1e-6 w=700e-9 m=1
	xr1 (vdda vdda net69) prim_rdiffp l=2.1e-6 w=700e-9 m=1
	xcc01 (net12 out) prim_cpoly c=1p m=1
	mnm12 (net13 net56 vssa vssa) nmos1 l=1.1e-07n w=1.0e-06u m=1
	mnm11 (net56 net56 vssa vssa) nmos1 l=180n w=1u m=1
	mnb02 (net27 net27 net21 vssa) nmos1 l=180n w=1u m=1
	mnpd1 (net21 xpd vssa vssa) nmos1 l=180n w=1u m=1
	mn001 (out net13 vssa vssa) nmos1 l=180n w=1u m=1
	mnpd2 (net13 pd vssa vssa) nmos1 l=180n w=1u m=1
	mnc01 (net13 net69 net12 vssa) nmos1 l=180n w=1u m=1
	mpb02 (net27 net51 net158 vdda) pmos1 l=180n w=1u m=1
	mppd1 (net158 xpd vdda vdda) pmos1 l=180n w=1u m=1
	mps11 (net31 net158 vdda vdda) pmos1 l=2.2e-07n w=5.0e-07u m=1
	mpd11 (net56 inn net31 net31) pmos1 l=180n w=1u m=1
	mp001 (out net158 vdda vdda) pmos1 l=180n w=1u m=1
	mpd12 (net13 inp net31 net31) pmos1 l=180n w=1u m=1
	mpb01 (net158 net158 vdda vdda) pmos1 l=180n w=1u m=1
ends OPAMP1_variant887

subckt OPAMP1_variant888 inn inp out pd xpd vdda vssa
	xd1 (vssa vdda) prim_nwd AREA=6.13907e-9 PJ=476.6e-6 m=1
	xi0 (vssa net69) prim_nd AREA=1e-12 PJ=4e-6 m=1
	xi3 (net51 vdda) prim_pd AREA=790e-15 PJ=3.3e-6 m=1
	xr0 (vssa vdda net51) prim_rdiffp l=2.1e-6 w=700e-9 m=1
	xr1 (vdda vdda net69) prim_rdiffp l=2.1e-6 w=700e-9 m=1
	xcc01 (net12 out) prim_cpoly c=1.7e-12p m=1
	mnm12 (net13 net56 vssa vssa) nmos1 l=180n w=1u m=1
	mnm11 (net56 net56 vssa vssa) nmos1 l=180n w=1u m=1
	mnb02 (net27 net27 net21 vssa) nmos1 l=180n w=1u m=1
	mnpd1 (net21 xpd vssa vssa) nmos1 l=180n w=1u m=1
	mn001 (out net13 vssa vssa) nmos1 l=180n w=1u m=1
	mnpd2 (net13 pd vssa vssa) nmos1 l=180n w=1u m=1
	mnc01 (net13 net69 net12 vssa) nmos1 l=180n w=1u m=1
	mpb02 (net27 net51 net158 vdda) pmos1 l=2.7e-07n w=1.7e-06u m=1
	mppd1 (net158 xpd vdda vdda) pmos1 l=180n w=1u m=1
	mps11 (net31 net158 vdda vdda) pmos1 l=180n w=1u m=1
	mpd11 (net56 inn net31 net31) pmos1 l=180n w=1u m=1
	mp001 (out net158 vdda vdda) pmos1 l=180n w=1u m=1
	mpd12 (net13 inp net31 net31) pmos1 l=180n w=1u m=1
	mpb01 (net158 net158 vdda vdda) pmos1 l=180n w=1u m=1
ends OPAMP1_variant888

subckt OPAMP1_variant889 inn inp out pd xpd vdda vssa
	xd1 (vssa vdda) prim_nwd AREA=6.13907e-9 PJ=476.6e-6 m=1
	xi0 (vssa net69) prim_nd AREA=1e-12 PJ=4e-6 m=1
	xi3 (net51 vdda) prim_pd AREA=790e-15 PJ=3.3e-6 m=1
	xr0 (vssa vdda net51) prim_rdiffp l=2.1e-6 w=700e-9 m=1
	xr1 (vdda vdda net69) prim_rdiffp l=2.1e-6 w=700e-9 m=1
	xcc01 (net12 out) prim_cpoly c=1p m=1
	mnm12 (net13 net56 vssa vssa) nmos1 l=2.5e-07n w=1.6e-06u m=1
	mnm11 (net56 net56 vssa vssa) nmos1 l=180n w=1u m=1
	mnb02 (net27 net27 net21 vssa) nmos1 l=180n w=1u m=1
	mnpd1 (net21 xpd vssa vssa) nmos1 l=180n w=1u m=1
	mn001 (out net13 vssa vssa) nmos1 l=2.3e-07n w=1.3e-06u m=1
	mnpd2 (net13 pd vssa vssa) nmos1 l=180n w=1u m=1
	mnc01 (net13 net69 net12 vssa) nmos1 l=180n w=1u m=1
	mpb02 (net27 net51 net158 vdda) pmos1 l=180n w=1u m=1
	mppd1 (net158 xpd vdda vdda) pmos1 l=180n w=1u m=1
	mps11 (net31 net158 vdda vdda) pmos1 l=180n w=1u m=1
	mpd11 (net56 inn net31 net31) pmos1 l=180n w=1u m=1
	mp001 (out net158 vdda vdda) pmos1 l=180n w=1u m=1
	mpd12 (net13 inp net31 net31) pmos1 l=180n w=1u m=1
	mpb01 (net158 net158 vdda vdda) pmos1 l=180n w=1u m=1
ends OPAMP1_variant889

subckt OPAMP1_variant890 inn inp out pd xpd vdda vssa
	xd1 (vssa vdda) prim_nwd AREA=6.0e-09 PJ=5.5e-05 m=1
	xi0 (vssa net69) prim_nd AREA=1e-12 PJ=4e-6 m=1
	xi3 (net51 vdda) prim_pd AREA=790e-15 PJ=3.3e-6 m=1
	xr0 (vssa vdda net51) prim_rdiffp l=1.0e-07 w=1.5e-06 m=1
	xr1 (vdda vdda net69) prim_rdiffp l=2.1e-6 w=700e-9 m=1
	xcc01 (net12 out) prim_cpoly c=1.3e-12p m=1
	mnm12 (net13 net56 vssa vssa) nmos1 l=180n w=1u m=1
	mnm11 (net56 net56 vssa vssa) nmos1 l=180n w=1u m=1
	mnb02 (net27 net27 net21 vssa) nmos1 l=180n w=1u m=1
	mnpd1 (net21 xpd vssa vssa) nmos1 l=180n w=1u m=1
	mn001 (out net13 vssa vssa) nmos1 l=180n w=1u m=1
	mnpd2 (net13 pd vssa vssa) nmos1 l=1.4e-07n w=1.2e-06u m=1
	mnc01 (net13 net69 net12 vssa) nmos1 l=180n w=1u m=1
	mpb02 (net27 net51 net158 vdda) pmos1 l=180n w=1u m=1
	mppd1 (net158 xpd vdda vdda) pmos1 l=180n w=1u m=1
	mps11 (net31 net158 vdda vdda) pmos1 l=180n w=1u m=1
	mpd11 (net56 inn net31 net31) pmos1 l=180n w=1u m=1
	mp001 (out net158 vdda vdda) pmos1 l=180n w=1u m=1
	mpd12 (net13 inp net31 net31) pmos1 l=180n w=1u m=1
	mpb01 (net158 net158 vdda vdda) pmos1 l=180n w=1u m=1
ends OPAMP1_variant890

subckt OPAMP1_variant891 inn inp out pd xpd vdda vssa
	xd1 (vssa vdda) prim_nwd AREA=6.13907e-9 PJ=476.6e-6 m=1
	xi0 (vssa net69) prim_nd AREA=1e-12 PJ=4e-6 m=1
	xi3 (net51 vdda) prim_pd AREA=790e-15 PJ=3.3e-6 m=1
	xr0 (vssa vdda net51) prim_rdiffp l=2.1e-6 w=700e-9 m=1
	xr1 (vdda vdda net69) prim_rdiffp l=2.1e-6 w=700e-9 m=1
	xcc01 (net12 out) prim_cpoly c=1p m=1
	mnm12 (net13 net56 vssa vssa) nmos1 l=2.5e-07n w=8.3e-07u m=1
	mnm11 (net56 net56 vssa vssa) nmos1 l=180n w=1u m=1
	mnb02 (net27 net27 net21 vssa) nmos1 l=180n w=1u m=1
	mnpd1 (net21 xpd vssa vssa) nmos1 l=180n w=1u m=1
	mn001 (out net13 vssa vssa) nmos1 l=180n w=1u m=1
	mnpd2 (net13 pd vssa vssa) nmos1 l=180n w=1u m=1
	mnc01 (net13 net69 net12 vssa) nmos1 l=180n w=1u m=1
	mpb02 (net27 net51 net158 vdda) pmos1 l=180n w=1u m=1
	mppd1 (net158 xpd vdda vdda) pmos1 l=1.5e-07n w=1.5e-06u m=1
	mps11 (net31 net158 vdda vdda) pmos1 l=180n w=1u m=1
	mpd11 (net56 inn net31 net31) pmos1 l=180n w=1u m=1
	mp001 (out net158 vdda vdda) pmos1 l=180n w=1u m=1
	mpd12 (net13 inp net31 net31) pmos1 l=180n w=1u m=1
	mpb01 (net158 net158 vdda vdda) pmos1 l=180n w=1u m=1
ends OPAMP1_variant891

subckt OPAMP1_variant892 inn inp out pd xpd vdda vssa
	xd1 (vssa vdda) prim_nwd AREA=6.13907e-9 PJ=476.6e-6 m=1
	xi0 (vssa net69) prim_nd AREA=1e-12 PJ=4e-6 m=1
	xi3 (net51 vdda) prim_pd AREA=790e-15 PJ=3.3e-6 m=1
	xr0 (vssa vdda net51) prim_rdiffp l=2.1e-6 w=700e-9 m=1
	xr1 (vdda vdda net69) prim_rdiffp l=2.1e-07 w=1.1e-06 m=1
	xcc01 (net12 out) prim_cpoly c=1p m=1
	mnm12 (net13 net56 vssa vssa) nmos1 l=180n w=1u m=1
	mnm11 (net56 net56 vssa vssa) nmos1 l=180n w=1u m=1
	mnb02 (net27 net27 net21 vssa) nmos1 l=180n w=1u m=1
	mnpd1 (net21 xpd vssa vssa) nmos1 l=1.1e-07n w=1.1e-06u m=1
	mn001 (out net13 vssa vssa) nmos1 l=2.5e-07n w=8.4e-07u m=1
	mnpd2 (net13 pd vssa vssa) nmos1 l=180n w=1u m=1
	mnc01 (net13 net69 net12 vssa) nmos1 l=180n w=1u m=1
	mpb02 (net27 net51 net158 vdda) pmos1 l=180n w=1u m=1
	mppd1 (net158 xpd vdda vdda) pmos1 l=180n w=1u m=1
	mps11 (net31 net158 vdda vdda) pmos1 l=2.5e-07n w=5.2e-07u m=1
	mpd11 (net56 inn net31 net31) pmos1 l=180n w=1u m=1
	mp001 (out net158 vdda vdda) pmos1 l=180n w=1u m=1
	mpd12 (net13 inp net31 net31) pmos1 l=2.5e-07n w=7.1e-07u m=1
	mpb01 (net158 net158 vdda vdda) pmos1 l=180n w=1u m=1
ends OPAMP1_variant892

subckt OPAMP1_variant893 inn inp out pd xpd vdda vssa
	xd1 (vssa vdda) prim_nwd AREA=6.13907e-9 PJ=476.6e-6 m=1
	xi0 (vssa net69) prim_nd AREA=1.0e-09 PJ=7.9e-05 m=1
	xi3 (net51 vdda) prim_pd AREA=7.1e-09 PJ=2.8e-05 m=1
	xr0 (vssa vdda net51) prim_rdiffp l=2.1e-6 w=700e-9 m=1
	xr1 (vdda vdda net69) prim_rdiffp l=2.0e-07 w=1.8e-06 m=1
	xcc01 (net12 out) prim_cpoly c=1p m=1
	mnm12 (net13 net56 vssa vssa) nmos1 l=180n w=1u m=1
	mnm11 (net56 net56 vssa vssa) nmos1 l=180n w=1u m=1
	mnb02 (net27 net27 net21 vssa) nmos1 l=180n w=1u m=1
	mnpd1 (net21 xpd vssa vssa) nmos1 l=180n w=1u m=1
	mn001 (out net13 vssa vssa) nmos1 l=180n w=1u m=1
	mnpd2 (net13 pd vssa vssa) nmos1 l=180n w=1u m=1
	mnc01 (net13 net69 net12 vssa) nmos1 l=180n w=1u m=1
	mpb02 (net27 net51 net158 vdda) pmos1 l=180n w=1u m=1
	mppd1 (net158 xpd vdda vdda) pmos1 l=180n w=1u m=1
	mps11 (net31 net158 vdda vdda) pmos1 l=180n w=1u m=1
	mpd11 (net56 inn net31 net31) pmos1 l=2.2e-07n w=1.8e-06u m=1
	mp001 (out net158 vdda vdda) pmos1 l=180n w=1u m=1
	mpd12 (net13 inp net31 net31) pmos1 l=180n w=1u m=1
	mpb01 (net158 net158 vdda vdda) pmos1 l=180n w=1u m=1
ends OPAMP1_variant893

subckt OPAMP1_variant894 inn inp out pd xpd vdda vssa
	xd1 (vssa vdda) prim_nwd AREA=6.13907e-9 PJ=476.6e-6 m=1
	xi0 (vssa net69) prim_nd AREA=1e-12 PJ=4e-6 m=1
	xi3 (net51 vdda) prim_pd AREA=790e-15 PJ=3.3e-6 m=1
	xr0 (vssa vdda net51) prim_rdiffp l=2.1e-6 w=700e-9 m=1
	xr1 (vdda vdda net69) prim_rdiffp l=2.1e-6 w=700e-9 m=1
	xcc01 (net12 out) prim_cpoly c=1p m=1
	mnm12 (net13 net56 vssa vssa) nmos1 l=180n w=1u m=1
	mnm11 (net56 net56 vssa vssa) nmos1 l=180n w=1u m=1
	mnb02 (net27 net27 net21 vssa) nmos1 l=180n w=1u m=1
	mnpd1 (net21 xpd vssa vssa) nmos1 l=180n w=1u m=1
	mn001 (out net13 vssa vssa) nmos1 l=180n w=1u m=1
	mnpd2 (net13 pd vssa vssa) nmos1 l=2.6e-07n w=9.4e-07u m=1
	mnc01 (net13 net69 net12 vssa) nmos1 l=180n w=1u m=1
	mpb02 (net27 net51 net158 vdda) pmos1 l=3.0e-07n w=1.9e-06u m=1
	mppd1 (net158 xpd vdda vdda) pmos1 l=180n w=1u m=1
	mps11 (net31 net158 vdda vdda) pmos1 l=180n w=1u m=1
	mpd11 (net56 inn net31 net31) pmos1 l=180n w=1u m=1
	mp001 (out net158 vdda vdda) pmos1 l=180n w=1u m=1
	mpd12 (net13 inp net31 net31) pmos1 l=180n w=1u m=1
	mpb01 (net158 net158 vdda vdda) pmos1 l=180n w=1u m=1
ends OPAMP1_variant894

subckt OPAMP1_variant895 inn inp out pd xpd vdda vssa
	xd1 (vssa vdda) prim_nwd AREA=4.0e-09 PJ=4.5e-05 m=1
	xi0 (vssa net69) prim_nd AREA=1e-12 PJ=4e-6 m=1
	xi3 (net51 vdda) prim_pd AREA=3.2e-09 PJ=6.4e-05 m=1
	xr0 (vssa vdda net51) prim_rdiffp l=2.1e-6 w=700e-9 m=1
	xr1 (vdda vdda net69) prim_rdiffp l=2.1e-6 w=700e-9 m=1
	xcc01 (net12 out) prim_cpoly c=1p m=1
	mnm12 (net13 net56 vssa vssa) nmos1 l=180n w=1u m=1
	mnm11 (net56 net56 vssa vssa) nmos1 l=180n w=1u m=1
	mnb02 (net27 net27 net21 vssa) nmos1 l=180n w=1u m=1
	mnpd1 (net21 xpd vssa vssa) nmos1 l=180n w=1u m=1
	mn001 (out net13 vssa vssa) nmos1 l=180n w=1u m=1
	mnpd2 (net13 pd vssa vssa) nmos1 l=180n w=1u m=1
	mnc01 (net13 net69 net12 vssa) nmos1 l=180n w=1u m=1
	mpb02 (net27 net51 net158 vdda) pmos1 l=180n w=1u m=1
	mppd1 (net158 xpd vdda vdda) pmos1 l=180n w=1u m=1
	mps11 (net31 net158 vdda vdda) pmos1 l=180n w=1u m=1
	mpd11 (net56 inn net31 net31) pmos1 l=180n w=1u m=1
	mp001 (out net158 vdda vdda) pmos1 l=180n w=1u m=1
	mpd12 (net13 inp net31 net31) pmos1 l=180n w=1u m=1
	mpb01 (net158 net158 vdda vdda) pmos1 l=180n w=1u m=1
ends OPAMP1_variant895

subckt OPAMP1_variant896 inn inp out pd xpd vdda vssa
	xd1 (vssa vdda) prim_nwd AREA=6.13907e-9 PJ=476.6e-6 m=1
	xi0 (vssa net69) prim_nd AREA=5.9e-09 PJ=5.9e-06 m=1
	xi3 (net51 vdda) prim_pd AREA=8.5e-09 PJ=3.6e-05 m=1
	xr0 (vssa vdda net51) prim_rdiffp l=2.1e-6 w=700e-9 m=1
	xr1 (vdda vdda net69) prim_rdiffp l=2.1e-6 w=700e-9 m=1
	xcc01 (net12 out) prim_cpoly c=1p m=1
	mnm12 (net13 net56 vssa vssa) nmos1 l=180n w=1u m=1
	mnm11 (net56 net56 vssa vssa) nmos1 l=180n w=1u m=1
	mnb02 (net27 net27 net21 vssa) nmos1 l=2.9e-07n w=8.8e-07u m=1
	mnpd1 (net21 xpd vssa vssa) nmos1 l=1.3e-07n w=1.9e-06u m=1
	mn001 (out net13 vssa vssa) nmos1 l=180n w=1u m=1
	mnpd2 (net13 pd vssa vssa) nmos1 l=180n w=1u m=1
	mnc01 (net13 net69 net12 vssa) nmos1 l=1.0e-07n w=7.1e-07u m=1
	mpb02 (net27 net51 net158 vdda) pmos1 l=180n w=1u m=1
	mppd1 (net158 xpd vdda vdda) pmos1 l=180n w=1u m=1
	mps11 (net31 net158 vdda vdda) pmos1 l=180n w=1u m=1
	mpd11 (net56 inn net31 net31) pmos1 l=180n w=1u m=1
	mp001 (out net158 vdda vdda) pmos1 l=180n w=1u m=1
	mpd12 (net13 inp net31 net31) pmos1 l=180n w=1u m=1
	mpb01 (net158 net158 vdda vdda) pmos1 l=180n w=1u m=1
ends OPAMP1_variant896

subckt OPAMP1_variant897 inn inp out pd xpd vdda vssa
	xd1 (vssa vdda) prim_nwd AREA=6.13907e-9 PJ=476.6e-6 m=1
	xi0 (vssa net69) prim_nd AREA=1e-12 PJ=4e-6 m=1
	xi3 (net51 vdda) prim_pd AREA=790e-15 PJ=3.3e-6 m=1
	xr0 (vssa vdda net51) prim_rdiffp l=2.1e-6 w=700e-9 m=1
	xr1 (vdda vdda net69) prim_rdiffp l=2.6e-07 w=1.7e-06 m=1
	xcc01 (net12 out) prim_cpoly c=1p m=1
	mnm12 (net13 net56 vssa vssa) nmos1 l=180n w=1u m=1
	mnm11 (net56 net56 vssa vssa) nmos1 l=3.0e-07n w=9.7e-07u m=1
	mnb02 (net27 net27 net21 vssa) nmos1 l=180n w=1u m=1
	mnpd1 (net21 xpd vssa vssa) nmos1 l=180n w=1u m=1
	mn001 (out net13 vssa vssa) nmos1 l=180n w=1u m=1
	mnpd2 (net13 pd vssa vssa) nmos1 l=180n w=1u m=1
	mnc01 (net13 net69 net12 vssa) nmos1 l=180n w=1u m=1
	mpb02 (net27 net51 net158 vdda) pmos1 l=180n w=1u m=1
	mppd1 (net158 xpd vdda vdda) pmos1 l=180n w=1u m=1
	mps11 (net31 net158 vdda vdda) pmos1 l=180n w=1u m=1
	mpd11 (net56 inn net31 net31) pmos1 l=180n w=1u m=1
	mp001 (out net158 vdda vdda) pmos1 l=180n w=1u m=1
	mpd12 (net13 inp net31 net31) pmos1 l=180n w=1u m=1
	mpb01 (net158 net158 vdda vdda) pmos1 l=180n w=1u m=1
ends OPAMP1_variant897

subckt OPAMP1_variant898 inn inp out pd xpd vdda vssa
	xd1 (vssa vdda) prim_nwd AREA=6.13907e-9 PJ=476.6e-6 m=1
	xi0 (vssa net69) prim_nd AREA=1e-12 PJ=4e-6 m=1
	xi3 (net51 vdda) prim_pd AREA=790e-15 PJ=3.3e-6 m=1
	xr0 (vssa vdda net51) prim_rdiffp l=1.8e-07 w=7.3e-07 m=1
	xr1 (vdda vdda net69) prim_rdiffp l=2.1e-6 w=700e-9 m=1
	xcc01 (net12 out) prim_cpoly c=1.9e-12p m=1
	mnm12 (net13 net56 vssa vssa) nmos1 l=180n w=1u m=1
	mnm11 (net56 net56 vssa vssa) nmos1 l=180n w=1u m=1
	mnb02 (net27 net27 net21 vssa) nmos1 l=180n w=1u m=1
	mnpd1 (net21 xpd vssa vssa) nmos1 l=180n w=1u m=1
	mn001 (out net13 vssa vssa) nmos1 l=180n w=1u m=1
	mnpd2 (net13 pd vssa vssa) nmos1 l=180n w=1u m=1
	mnc01 (net13 net69 net12 vssa) nmos1 l=180n w=1u m=1
	mpb02 (net27 net51 net158 vdda) pmos1 l=180n w=1u m=1
	mppd1 (net158 xpd vdda vdda) pmos1 l=180n w=1u m=1
	mps11 (net31 net158 vdda vdda) pmos1 l=180n w=1u m=1
	mpd11 (net56 inn net31 net31) pmos1 l=180n w=1u m=1
	mp001 (out net158 vdda vdda) pmos1 l=180n w=1u m=1
	mpd12 (net13 inp net31 net31) pmos1 l=1.7e-07n w=2.0e-06u m=1
	mpb01 (net158 net158 vdda vdda) pmos1 l=180n w=1u m=1
ends OPAMP1_variant898

subckt OPAMP1_variant899 inn inp out pd xpd vdda vssa
	xd1 (vssa vdda) prim_nwd AREA=3.0e-09 PJ=6.3e-05 m=1
	xi0 (vssa net69) prim_nd AREA=1e-12 PJ=4e-6 m=1
	xi3 (net51 vdda) prim_pd AREA=790e-15 PJ=3.3e-6 m=1
	xr0 (vssa vdda net51) prim_rdiffp l=2.1e-6 w=700e-9 m=1
	xr1 (vdda vdda net69) prim_rdiffp l=2.1e-6 w=700e-9 m=1
	xcc01 (net12 out) prim_cpoly c=1p m=1
	mnm12 (net13 net56 vssa vssa) nmos1 l=1.5e-07n w=1.9e-06u m=1
	mnm11 (net56 net56 vssa vssa) nmos1 l=180n w=1u m=1
	mnb02 (net27 net27 net21 vssa) nmos1 l=2.3e-07n w=2.0e-06u m=1
	mnpd1 (net21 xpd vssa vssa) nmos1 l=180n w=1u m=1
	mn001 (out net13 vssa vssa) nmos1 l=180n w=1u m=1
	mnpd2 (net13 pd vssa vssa) nmos1 l=1.7e-07n w=1.5e-06u m=1
	mnc01 (net13 net69 net12 vssa) nmos1 l=2.1e-07n w=1.8e-06u m=1
	mpb02 (net27 net51 net158 vdda) pmos1 l=180n w=1u m=1
	mppd1 (net158 xpd vdda vdda) pmos1 l=180n w=1u m=1
	mps11 (net31 net158 vdda vdda) pmos1 l=180n w=1u m=1
	mpd11 (net56 inn net31 net31) pmos1 l=180n w=1u m=1
	mp001 (out net158 vdda vdda) pmos1 l=180n w=1u m=1
	mpd12 (net13 inp net31 net31) pmos1 l=180n w=1u m=1
	mpb01 (net158 net158 vdda vdda) pmos1 l=180n w=1u m=1
ends OPAMP1_variant899

subckt OPAMP1_variant900 inn inp out pd xpd vdda vssa
	xd1 (vssa vdda) prim_nwd AREA=6.13907e-9 PJ=476.6e-6 m=1
	xi0 (vssa net69) prim_nd AREA=1e-12 PJ=4e-6 m=1
	xi3 (net51 vdda) prim_pd AREA=790e-15 PJ=3.3e-6 m=1
	xr0 (vssa vdda net51) prim_rdiffp l=2.1e-6 w=700e-9 m=1
	xr1 (vdda vdda net69) prim_rdiffp l=2.1e-6 w=700e-9 m=1
	xcc01 (net12 out) prim_cpoly c=1p m=1
	mnm12 (net13 net56 vssa vssa) nmos1 l=180n w=1u m=1
	mnm11 (net56 net56 vssa vssa) nmos1 l=180n w=1u m=1
	mnb02 (net27 net27 net21 vssa) nmos1 l=2.4e-07n w=7.1e-07u m=1
	mnpd1 (net21 xpd vssa vssa) nmos1 l=180n w=1u m=1
	mn001 (out net13 vssa vssa) nmos1 l=180n w=1u m=1
	mnpd2 (net13 pd vssa vssa) nmos1 l=1.2e-07n w=1.9e-06u m=1
	mnc01 (net13 net69 net12 vssa) nmos1 l=180n w=1u m=1
	mpb02 (net27 net51 net158 vdda) pmos1 l=180n w=1u m=1
	mppd1 (net158 xpd vdda vdda) pmos1 l=180n w=1u m=1
	mps11 (net31 net158 vdda vdda) pmos1 l=180n w=1u m=1
	mpd11 (net56 inn net31 net31) pmos1 l=3.0e-07n w=9.5e-07u m=1
	mp001 (out net158 vdda vdda) pmos1 l=180n w=1u m=1
	mpd12 (net13 inp net31 net31) pmos1 l=180n w=1u m=1
	mpb01 (net158 net158 vdda vdda) pmos1 l=180n w=1u m=1
ends OPAMP1_variant900

subckt OPAMP1_variant901 inn inp out pd xpd vdda vssa
	xd1 (vssa vdda) prim_nwd AREA=1.5e-09 PJ=2.9e-05 m=1
	xi0 (vssa net69) prim_nd AREA=1e-12 PJ=4e-6 m=1
	xi3 (net51 vdda) prim_pd AREA=790e-15 PJ=3.3e-6 m=1
	xr0 (vssa vdda net51) prim_rdiffp l=2.1e-6 w=700e-9 m=1
	xr1 (vdda vdda net69) prim_rdiffp l=2.1e-6 w=700e-9 m=1
	xcc01 (net12 out) prim_cpoly c=1p m=1
	mnm12 (net13 net56 vssa vssa) nmos1 l=180n w=1u m=1
	mnm11 (net56 net56 vssa vssa) nmos1 l=180n w=1u m=1
	mnb02 (net27 net27 net21 vssa) nmos1 l=180n w=1u m=1
	mnpd1 (net21 xpd vssa vssa) nmos1 l=180n w=1u m=1
	mn001 (out net13 vssa vssa) nmos1 l=2.2e-07n w=1.7e-06u m=1
	mnpd2 (net13 pd vssa vssa) nmos1 l=180n w=1u m=1
	mnc01 (net13 net69 net12 vssa) nmos1 l=180n w=1u m=1
	mpb02 (net27 net51 net158 vdda) pmos1 l=180n w=1u m=1
	mppd1 (net158 xpd vdda vdda) pmos1 l=180n w=1u m=1
	mps11 (net31 net158 vdda vdda) pmos1 l=180n w=1u m=1
	mpd11 (net56 inn net31 net31) pmos1 l=180n w=1u m=1
	mp001 (out net158 vdda vdda) pmos1 l=180n w=1u m=1
	mpd12 (net13 inp net31 net31) pmos1 l=180n w=1u m=1
	mpb01 (net158 net158 vdda vdda) pmos1 l=1.6e-07n w=1.3e-06u m=1
ends OPAMP1_variant901

subckt OPAMP1_variant902 inn inp out pd xpd vdda vssa
	xd1 (vssa vdda) prim_nwd AREA=9.7e-09 PJ=8.2e-05 m=1
	xi0 (vssa net69) prim_nd AREA=1e-12 PJ=4e-6 m=1
	xi3 (net51 vdda) prim_pd AREA=790e-15 PJ=3.3e-6 m=1
	xr0 (vssa vdda net51) prim_rdiffp l=1.2e-07 w=7.3e-07 m=1
	xr1 (vdda vdda net69) prim_rdiffp l=2.6e-07 w=9.5e-07 m=1
	xcc01 (net12 out) prim_cpoly c=1.2e-12p m=1
	mnm12 (net13 net56 vssa vssa) nmos1 l=180n w=1u m=1
	mnm11 (net56 net56 vssa vssa) nmos1 l=180n w=1u m=1
	mnb02 (net27 net27 net21 vssa) nmos1 l=180n w=1u m=1
	mnpd1 (net21 xpd vssa vssa) nmos1 l=180n w=1u m=1
	mn001 (out net13 vssa vssa) nmos1 l=180n w=1u m=1
	mnpd2 (net13 pd vssa vssa) nmos1 l=180n w=1u m=1
	mnc01 (net13 net69 net12 vssa) nmos1 l=180n w=1u m=1
	mpb02 (net27 net51 net158 vdda) pmos1 l=180n w=1u m=1
	mppd1 (net158 xpd vdda vdda) pmos1 l=180n w=1u m=1
	mps11 (net31 net158 vdda vdda) pmos1 l=180n w=1u m=1
	mpd11 (net56 inn net31 net31) pmos1 l=180n w=1u m=1
	mp001 (out net158 vdda vdda) pmos1 l=180n w=1u m=1
	mpd12 (net13 inp net31 net31) pmos1 l=2.8e-07n w=1.2e-06u m=1
	mpb01 (net158 net158 vdda vdda) pmos1 l=180n w=1u m=1
ends OPAMP1_variant902

subckt OPAMP1_variant903 inn inp out pd xpd vdda vssa
	xd1 (vssa vdda) prim_nwd AREA=6.13907e-9 PJ=476.6e-6 m=1
	xi0 (vssa net69) prim_nd AREA=6.9e-09 PJ=3.0e-05 m=1
	xi3 (net51 vdda) prim_pd AREA=790e-15 PJ=3.3e-6 m=1
	xr0 (vssa vdda net51) prim_rdiffp l=2.1e-6 w=700e-9 m=1
	xr1 (vdda vdda net69) prim_rdiffp l=2.1e-6 w=700e-9 m=1
	xcc01 (net12 out) prim_cpoly c=1p m=1
	mnm12 (net13 net56 vssa vssa) nmos1 l=180n w=1u m=1
	mnm11 (net56 net56 vssa vssa) nmos1 l=2.1e-07n w=7.6e-07u m=1
	mnb02 (net27 net27 net21 vssa) nmos1 l=180n w=1u m=1
	mnpd1 (net21 xpd vssa vssa) nmos1 l=180n w=1u m=1
	mn001 (out net13 vssa vssa) nmos1 l=180n w=1u m=1
	mnpd2 (net13 pd vssa vssa) nmos1 l=180n w=1u m=1
	mnc01 (net13 net69 net12 vssa) nmos1 l=180n w=1u m=1
	mpb02 (net27 net51 net158 vdda) pmos1 l=2.5e-07n w=1.8e-06u m=1
	mppd1 (net158 xpd vdda vdda) pmos1 l=180n w=1u m=1
	mps11 (net31 net158 vdda vdda) pmos1 l=180n w=1u m=1
	mpd11 (net56 inn net31 net31) pmos1 l=180n w=1u m=1
	mp001 (out net158 vdda vdda) pmos1 l=180n w=1u m=1
	mpd12 (net13 inp net31 net31) pmos1 l=180n w=1u m=1
	mpb01 (net158 net158 vdda vdda) pmos1 l=180n w=1u m=1
ends OPAMP1_variant903

subckt OPAMP1_variant904 inn inp out pd xpd vdda vssa
	xd1 (vssa vdda) prim_nwd AREA=6.13907e-9 PJ=476.6e-6 m=1
	xi0 (vssa net69) prim_nd AREA=9.4e-09 PJ=9.7e-05 m=1
	xi3 (net51 vdda) prim_pd AREA=790e-15 PJ=3.3e-6 m=1
	xr0 (vssa vdda net51) prim_rdiffp l=2.1e-6 w=700e-9 m=1
	xr1 (vdda vdda net69) prim_rdiffp l=2.1e-6 w=700e-9 m=1
	xcc01 (net12 out) prim_cpoly c=1.4e-12p m=1
	mnm12 (net13 net56 vssa vssa) nmos1 l=180n w=1u m=1
	mnm11 (net56 net56 vssa vssa) nmos1 l=3.0e-07n w=1.4e-06u m=1
	mnb02 (net27 net27 net21 vssa) nmos1 l=180n w=1u m=1
	mnpd1 (net21 xpd vssa vssa) nmos1 l=180n w=1u m=1
	mn001 (out net13 vssa vssa) nmos1 l=180n w=1u m=1
	mnpd2 (net13 pd vssa vssa) nmos1 l=180n w=1u m=1
	mnc01 (net13 net69 net12 vssa) nmos1 l=2.6e-07n w=9.7e-07u m=1
	mpb02 (net27 net51 net158 vdda) pmos1 l=180n w=1u m=1
	mppd1 (net158 xpd vdda vdda) pmos1 l=180n w=1u m=1
	mps11 (net31 net158 vdda vdda) pmos1 l=1.4e-07n w=1.9e-06u m=1
	mpd11 (net56 inn net31 net31) pmos1 l=180n w=1u m=1
	mp001 (out net158 vdda vdda) pmos1 l=180n w=1u m=1
	mpd12 (net13 inp net31 net31) pmos1 l=180n w=1u m=1
	mpb01 (net158 net158 vdda vdda) pmos1 l=180n w=1u m=1
ends OPAMP1_variant904

subckt OPAMP1_variant905 inn inp out pd xpd vdda vssa
	xd1 (vssa vdda) prim_nwd AREA=6.5e-09 PJ=8.9e-05 m=1
	xi0 (vssa net69) prim_nd AREA=1e-12 PJ=4e-6 m=1
	xi3 (net51 vdda) prim_pd AREA=790e-15 PJ=3.3e-6 m=1
	xr0 (vssa vdda net51) prim_rdiffp l=2.1e-6 w=700e-9 m=1
	xr1 (vdda vdda net69) prim_rdiffp l=2.1e-6 w=700e-9 m=1
	xcc01 (net12 out) prim_cpoly c=7.3e-13p m=1
	mnm12 (net13 net56 vssa vssa) nmos1 l=180n w=1u m=1
	mnm11 (net56 net56 vssa vssa) nmos1 l=180n w=1u m=1
	mnb02 (net27 net27 net21 vssa) nmos1 l=180n w=1u m=1
	mnpd1 (net21 xpd vssa vssa) nmos1 l=180n w=1u m=1
	mn001 (out net13 vssa vssa) nmos1 l=180n w=1u m=1
	mnpd2 (net13 pd vssa vssa) nmos1 l=180n w=1u m=1
	mnc01 (net13 net69 net12 vssa) nmos1 l=180n w=1u m=1
	mpb02 (net27 net51 net158 vdda) pmos1 l=180n w=1u m=1
	mppd1 (net158 xpd vdda vdda) pmos1 l=180n w=1u m=1
	mps11 (net31 net158 vdda vdda) pmos1 l=180n w=1u m=1
	mpd11 (net56 inn net31 net31) pmos1 l=180n w=1u m=1
	mp001 (out net158 vdda vdda) pmos1 l=180n w=1u m=1
	mpd12 (net13 inp net31 net31) pmos1 l=180n w=1u m=1
	mpb01 (net158 net158 vdda vdda) pmos1 l=2.7e-07n w=1.3e-06u m=1
ends OPAMP1_variant905

subckt OPAMP1_variant906 inn inp out pd xpd vdda vssa
	xd1 (vssa vdda) prim_nwd AREA=6.13907e-9 PJ=476.6e-6 m=1
	xi0 (vssa net69) prim_nd AREA=1e-12 PJ=4e-6 m=1
	xi3 (net51 vdda) prim_pd AREA=790e-15 PJ=3.3e-6 m=1
	xr0 (vssa vdda net51) prim_rdiffp l=2.1e-6 w=700e-9 m=1
	xr1 (vdda vdda net69) prim_rdiffp l=2.1e-6 w=700e-9 m=1
	xcc01 (net12 out) prim_cpoly c=1.3e-12p m=1
	mnm12 (net13 net56 vssa vssa) nmos1 l=180n w=1u m=1
	mnm11 (net56 net56 vssa vssa) nmos1 l=180n w=1u m=1
	mnb02 (net27 net27 net21 vssa) nmos1 l=180n w=1u m=1
	mnpd1 (net21 xpd vssa vssa) nmos1 l=180n w=1u m=1
	mn001 (out net13 vssa vssa) nmos1 l=180n w=1u m=1
	mnpd2 (net13 pd vssa vssa) nmos1 l=1.1e-07n w=1.9e-06u m=1
	mnc01 (net13 net69 net12 vssa) nmos1 l=180n w=1u m=1
	mpb02 (net27 net51 net158 vdda) pmos1 l=180n w=1u m=1
	mppd1 (net158 xpd vdda vdda) pmos1 l=180n w=1u m=1
	mps11 (net31 net158 vdda vdda) pmos1 l=180n w=1u m=1
	mpd11 (net56 inn net31 net31) pmos1 l=180n w=1u m=1
	mp001 (out net158 vdda vdda) pmos1 l=180n w=1u m=1
	mpd12 (net13 inp net31 net31) pmos1 l=180n w=1u m=1
	mpb01 (net158 net158 vdda vdda) pmos1 l=180n w=1u m=1
ends OPAMP1_variant906

subckt OPAMP1_variant907 inn inp out pd xpd vdda vssa
	xd1 (vssa vdda) prim_nwd AREA=6.13907e-9 PJ=476.6e-6 m=1
	xi0 (vssa net69) prim_nd AREA=1e-12 PJ=4e-6 m=1
	xi3 (net51 vdda) prim_pd AREA=790e-15 PJ=3.3e-6 m=1
	xr0 (vssa vdda net51) prim_rdiffp l=2.1e-6 w=700e-9 m=1
	xr1 (vdda vdda net69) prim_rdiffp l=2.1e-6 w=700e-9 m=1
	xcc01 (net12 out) prim_cpoly c=1p m=1
	mnm12 (net13 net56 vssa vssa) nmos1 l=180n w=1u m=1
	mnm11 (net56 net56 vssa vssa) nmos1 l=180n w=1u m=1
	mnb02 (net27 net27 net21 vssa) nmos1 l=180n w=1u m=1
	mnpd1 (net21 xpd vssa vssa) nmos1 l=180n w=1u m=1
	mn001 (out net13 vssa vssa) nmos1 l=2.3e-07n w=1.8e-06u m=1
	mnpd2 (net13 pd vssa vssa) nmos1 l=180n w=1u m=1
	mnc01 (net13 net69 net12 vssa) nmos1 l=180n w=1u m=1
	mpb02 (net27 net51 net158 vdda) pmos1 l=180n w=1u m=1
	mppd1 (net158 xpd vdda vdda) pmos1 l=180n w=1u m=1
	mps11 (net31 net158 vdda vdda) pmos1 l=2.1e-07n w=7.9e-07u m=1
	mpd11 (net56 inn net31 net31) pmos1 l=2.8e-07n w=7.4e-07u m=1
	mp001 (out net158 vdda vdda) pmos1 l=2.6e-07n w=5.7e-07u m=1
	mpd12 (net13 inp net31 net31) pmos1 l=180n w=1u m=1
	mpb01 (net158 net158 vdda vdda) pmos1 l=180n w=1u m=1
ends OPAMP1_variant907

subckt OPAMP1_variant908 inn inp out pd xpd vdda vssa
	xd1 (vssa vdda) prim_nwd AREA=2.2e-09 PJ=3.0e-05 m=1
	xi0 (vssa net69) prim_nd AREA=1e-12 PJ=4e-6 m=1
	xi3 (net51 vdda) prim_pd AREA=790e-15 PJ=3.3e-6 m=1
	xr0 (vssa vdda net51) prim_rdiffp l=2.1e-6 w=700e-9 m=1
	xr1 (vdda vdda net69) prim_rdiffp l=2.1e-6 w=700e-9 m=1
	xcc01 (net12 out) prim_cpoly c=8.2e-13p m=1
	mnm12 (net13 net56 vssa vssa) nmos1 l=180n w=1u m=1
	mnm11 (net56 net56 vssa vssa) nmos1 l=180n w=1u m=1
	mnb02 (net27 net27 net21 vssa) nmos1 l=180n w=1u m=1
	mnpd1 (net21 xpd vssa vssa) nmos1 l=180n w=1u m=1
	mn001 (out net13 vssa vssa) nmos1 l=180n w=1u m=1
	mnpd2 (net13 pd vssa vssa) nmos1 l=180n w=1u m=1
	mnc01 (net13 net69 net12 vssa) nmos1 l=180n w=1u m=1
	mpb02 (net27 net51 net158 vdda) pmos1 l=1.3e-07n w=7.0e-07u m=1
	mppd1 (net158 xpd vdda vdda) pmos1 l=180n w=1u m=1
	mps11 (net31 net158 vdda vdda) pmos1 l=1.1e-07n w=1.2e-06u m=1
	mpd11 (net56 inn net31 net31) pmos1 l=180n w=1u m=1
	mp001 (out net158 vdda vdda) pmos1 l=180n w=1u m=1
	mpd12 (net13 inp net31 net31) pmos1 l=180n w=1u m=1
	mpb01 (net158 net158 vdda vdda) pmos1 l=180n w=1u m=1
ends OPAMP1_variant908

subckt OPAMP1_variant909 inn inp out pd xpd vdda vssa
	xd1 (vssa vdda) prim_nwd AREA=6.13907e-9 PJ=476.6e-6 m=1
	xi0 (vssa net69) prim_nd AREA=1e-12 PJ=4e-6 m=1
	xi3 (net51 vdda) prim_pd AREA=790e-15 PJ=3.3e-6 m=1
	xr0 (vssa vdda net51) prim_rdiffp l=2.1e-6 w=700e-9 m=1
	xr1 (vdda vdda net69) prim_rdiffp l=2.1e-6 w=700e-9 m=1
	xcc01 (net12 out) prim_cpoly c=1p m=1
	mnm12 (net13 net56 vssa vssa) nmos1 l=180n w=1u m=1
	mnm11 (net56 net56 vssa vssa) nmos1 l=180n w=1u m=1
	mnb02 (net27 net27 net21 vssa) nmos1 l=180n w=1u m=1
	mnpd1 (net21 xpd vssa vssa) nmos1 l=180n w=1u m=1
	mn001 (out net13 vssa vssa) nmos1 l=2.6e-07n w=1.7e-06u m=1
	mnpd2 (net13 pd vssa vssa) nmos1 l=1.4e-07n w=1.5e-06u m=1
	mnc01 (net13 net69 net12 vssa) nmos1 l=1.1e-07n w=5.3e-07u m=1
	mpb02 (net27 net51 net158 vdda) pmos1 l=180n w=1u m=1
	mppd1 (net158 xpd vdda vdda) pmos1 l=180n w=1u m=1
	mps11 (net31 net158 vdda vdda) pmos1 l=180n w=1u m=1
	mpd11 (net56 inn net31 net31) pmos1 l=180n w=1u m=1
	mp001 (out net158 vdda vdda) pmos1 l=180n w=1u m=1
	mpd12 (net13 inp net31 net31) pmos1 l=180n w=1u m=1
	mpb01 (net158 net158 vdda vdda) pmos1 l=2.9e-07n w=1.8e-06u m=1
ends OPAMP1_variant909

subckt OPAMP1_variant910 inn inp out pd xpd vdda vssa
	xd1 (vssa vdda) prim_nwd AREA=6.13907e-9 PJ=476.6e-6 m=1
	xi0 (vssa net69) prim_nd AREA=1e-12 PJ=4e-6 m=1
	xi3 (net51 vdda) prim_pd AREA=790e-15 PJ=3.3e-6 m=1
	xr0 (vssa vdda net51) prim_rdiffp l=2.1e-6 w=700e-9 m=1
	xr1 (vdda vdda net69) prim_rdiffp l=2.1e-6 w=700e-9 m=1
	xcc01 (net12 out) prim_cpoly c=1p m=1
	mnm12 (net13 net56 vssa vssa) nmos1 l=180n w=1u m=1
	mnm11 (net56 net56 vssa vssa) nmos1 l=180n w=1u m=1
	mnb02 (net27 net27 net21 vssa) nmos1 l=2.0e-07n w=8.4e-07u m=1
	mnpd1 (net21 xpd vssa vssa) nmos1 l=180n w=1u m=1
	mn001 (out net13 vssa vssa) nmos1 l=180n w=1u m=1
	mnpd2 (net13 pd vssa vssa) nmos1 l=180n w=1u m=1
	mnc01 (net13 net69 net12 vssa) nmos1 l=180n w=1u m=1
	mpb02 (net27 net51 net158 vdda) pmos1 l=180n w=1u m=1
	mppd1 (net158 xpd vdda vdda) pmos1 l=2.3e-07n w=1.8e-06u m=1
	mps11 (net31 net158 vdda vdda) pmos1 l=180n w=1u m=1
	mpd11 (net56 inn net31 net31) pmos1 l=180n w=1u m=1
	mp001 (out net158 vdda vdda) pmos1 l=180n w=1u m=1
	mpd12 (net13 inp net31 net31) pmos1 l=180n w=1u m=1
	mpb01 (net158 net158 vdda vdda) pmos1 l=180n w=1u m=1
ends OPAMP1_variant910

subckt OPAMP1_variant911 inn inp out pd xpd vdda vssa
	xd1 (vssa vdda) prim_nwd AREA=6.13907e-9 PJ=476.6e-6 m=1
	xi0 (vssa net69) prim_nd AREA=1.2e-10 PJ=4.2e-05 m=1
	xi3 (net51 vdda) prim_pd AREA=790e-15 PJ=3.3e-6 m=1
	xr0 (vssa vdda net51) prim_rdiffp l=2.1e-6 w=700e-9 m=1
	xr1 (vdda vdda net69) prim_rdiffp l=2.1e-6 w=700e-9 m=1
	xcc01 (net12 out) prim_cpoly c=1.2e-12p m=1
	mnm12 (net13 net56 vssa vssa) nmos1 l=180n w=1u m=1
	mnm11 (net56 net56 vssa vssa) nmos1 l=180n w=1u m=1
	mnb02 (net27 net27 net21 vssa) nmos1 l=180n w=1u m=1
	mnpd1 (net21 xpd vssa vssa) nmos1 l=180n w=1u m=1
	mn001 (out net13 vssa vssa) nmos1 l=180n w=1u m=1
	mnpd2 (net13 pd vssa vssa) nmos1 l=180n w=1u m=1
	mnc01 (net13 net69 net12 vssa) nmos1 l=180n w=1u m=1
	mpb02 (net27 net51 net158 vdda) pmos1 l=180n w=1u m=1
	mppd1 (net158 xpd vdda vdda) pmos1 l=180n w=1u m=1
	mps11 (net31 net158 vdda vdda) pmos1 l=180n w=1u m=1
	mpd11 (net56 inn net31 net31) pmos1 l=180n w=1u m=1
	mp001 (out net158 vdda vdda) pmos1 l=180n w=1u m=1
	mpd12 (net13 inp net31 net31) pmos1 l=180n w=1u m=1
	mpb01 (net158 net158 vdda vdda) pmos1 l=2.7e-07n w=1.1e-06u m=1
ends OPAMP1_variant911

subckt OPAMP1_variant912 inn inp out pd xpd vdda vssa
	xd1 (vssa vdda) prim_nwd AREA=6.13907e-9 PJ=476.6e-6 m=1
	xi0 (vssa net69) prim_nd AREA=1e-12 PJ=4e-6 m=1
	xi3 (net51 vdda) prim_pd AREA=790e-15 PJ=3.3e-6 m=1
	xr0 (vssa vdda net51) prim_rdiffp l=2.1e-6 w=700e-9 m=1
	xr1 (vdda vdda net69) prim_rdiffp l=2.1e-6 w=700e-9 m=1
	xcc01 (net12 out) prim_cpoly c=1.9e-12p m=1
	mnm12 (net13 net56 vssa vssa) nmos1 l=180n w=1u m=1
	mnm11 (net56 net56 vssa vssa) nmos1 l=180n w=1u m=1
	mnb02 (net27 net27 net21 vssa) nmos1 l=180n w=1u m=1
	mnpd1 (net21 xpd vssa vssa) nmos1 l=180n w=1u m=1
	mn001 (out net13 vssa vssa) nmos1 l=180n w=1u m=1
	mnpd2 (net13 pd vssa vssa) nmos1 l=180n w=1u m=1
	mnc01 (net13 net69 net12 vssa) nmos1 l=180n w=1u m=1
	mpb02 (net27 net51 net158 vdda) pmos1 l=180n w=1u m=1
	mppd1 (net158 xpd vdda vdda) pmos1 l=180n w=1u m=1
	mps11 (net31 net158 vdda vdda) pmos1 l=180n w=1u m=1
	mpd11 (net56 inn net31 net31) pmos1 l=180n w=1u m=1
	mp001 (out net158 vdda vdda) pmos1 l=180n w=1u m=1
	mpd12 (net13 inp net31 net31) pmos1 l=180n w=1u m=1
	mpb01 (net158 net158 vdda vdda) pmos1 l=2.6e-07n w=1.8e-06u m=1
ends OPAMP1_variant912

subckt OPAMP1_variant913 inn inp out pd xpd vdda vssa
	xd1 (vssa vdda) prim_nwd AREA=6.13907e-9 PJ=476.6e-6 m=1
	xi0 (vssa net69) prim_nd AREA=1e-12 PJ=4e-6 m=1
	xi3 (net51 vdda) prim_pd AREA=790e-15 PJ=3.3e-6 m=1
	xr0 (vssa vdda net51) prim_rdiffp l=1.5e-07 w=1.4e-06 m=1
	xr1 (vdda vdda net69) prim_rdiffp l=2.1e-6 w=700e-9 m=1
	xcc01 (net12 out) prim_cpoly c=1p m=1
	mnm12 (net13 net56 vssa vssa) nmos1 l=180n w=1u m=1
	mnm11 (net56 net56 vssa vssa) nmos1 l=180n w=1u m=1
	mnb02 (net27 net27 net21 vssa) nmos1 l=180n w=1u m=1
	mnpd1 (net21 xpd vssa vssa) nmos1 l=180n w=1u m=1
	mn001 (out net13 vssa vssa) nmos1 l=1.4e-07n w=9.2e-07u m=1
	mnpd2 (net13 pd vssa vssa) nmos1 l=180n w=1u m=1
	mnc01 (net13 net69 net12 vssa) nmos1 l=180n w=1u m=1
	mpb02 (net27 net51 net158 vdda) pmos1 l=1.2e-07n w=7.1e-07u m=1
	mppd1 (net158 xpd vdda vdda) pmos1 l=1.1e-07n w=1.8e-06u m=1
	mps11 (net31 net158 vdda vdda) pmos1 l=180n w=1u m=1
	mpd11 (net56 inn net31 net31) pmos1 l=180n w=1u m=1
	mp001 (out net158 vdda vdda) pmos1 l=180n w=1u m=1
	mpd12 (net13 inp net31 net31) pmos1 l=180n w=1u m=1
	mpb01 (net158 net158 vdda vdda) pmos1 l=2.7e-07n w=5.4e-07u m=1
ends OPAMP1_variant913

subckt OPAMP1_variant914 inn inp out pd xpd vdda vssa
	xd1 (vssa vdda) prim_nwd AREA=6.13907e-9 PJ=476.6e-6 m=1
	xi0 (vssa net69) prim_nd AREA=1.5e-09 PJ=9.8e-05 m=1
	xi3 (net51 vdda) prim_pd AREA=790e-15 PJ=3.3e-6 m=1
	xr0 (vssa vdda net51) prim_rdiffp l=2.4e-07 w=1.4e-06 m=1
	xr1 (vdda vdda net69) prim_rdiffp l=2.1e-6 w=700e-9 m=1
	xcc01 (net12 out) prim_cpoly c=1p m=1
	mnm12 (net13 net56 vssa vssa) nmos1 l=180n w=1u m=1
	mnm11 (net56 net56 vssa vssa) nmos1 l=180n w=1u m=1
	mnb02 (net27 net27 net21 vssa) nmos1 l=180n w=1u m=1
	mnpd1 (net21 xpd vssa vssa) nmos1 l=180n w=1u m=1
	mn001 (out net13 vssa vssa) nmos1 l=180n w=1u m=1
	mnpd2 (net13 pd vssa vssa) nmos1 l=1.1e-07n w=1.2e-06u m=1
	mnc01 (net13 net69 net12 vssa) nmos1 l=1.8e-07n w=1.2e-06u m=1
	mpb02 (net27 net51 net158 vdda) pmos1 l=180n w=1u m=1
	mppd1 (net158 xpd vdda vdda) pmos1 l=180n w=1u m=1
	mps11 (net31 net158 vdda vdda) pmos1 l=180n w=1u m=1
	mpd11 (net56 inn net31 net31) pmos1 l=180n w=1u m=1
	mp001 (out net158 vdda vdda) pmos1 l=180n w=1u m=1
	mpd12 (net13 inp net31 net31) pmos1 l=180n w=1u m=1
	mpb01 (net158 net158 vdda vdda) pmos1 l=180n w=1u m=1
ends OPAMP1_variant914

subckt OPAMP1_variant915 inn inp out pd xpd vdda vssa
	xd1 (vssa vdda) prim_nwd AREA=6.13907e-9 PJ=476.6e-6 m=1
	xi0 (vssa net69) prim_nd AREA=1e-12 PJ=4e-6 m=1
	xi3 (net51 vdda) prim_pd AREA=790e-15 PJ=3.3e-6 m=1
	xr0 (vssa vdda net51) prim_rdiffp l=1.4e-07 w=6.8e-07 m=1
	xr1 (vdda vdda net69) prim_rdiffp l=2.1e-6 w=700e-9 m=1
	xcc01 (net12 out) prim_cpoly c=1p m=1
	mnm12 (net13 net56 vssa vssa) nmos1 l=180n w=1u m=1
	mnm11 (net56 net56 vssa vssa) nmos1 l=180n w=1u m=1
	mnb02 (net27 net27 net21 vssa) nmos1 l=2.2e-07n w=9.5e-07u m=1
	mnpd1 (net21 xpd vssa vssa) nmos1 l=2.0e-07n w=1.8e-06u m=1
	mn001 (out net13 vssa vssa) nmos1 l=180n w=1u m=1
	mnpd2 (net13 pd vssa vssa) nmos1 l=180n w=1u m=1
	mnc01 (net13 net69 net12 vssa) nmos1 l=180n w=1u m=1
	mpb02 (net27 net51 net158 vdda) pmos1 l=180n w=1u m=1
	mppd1 (net158 xpd vdda vdda) pmos1 l=2.2e-07n w=1.6e-06u m=1
	mps11 (net31 net158 vdda vdda) pmos1 l=180n w=1u m=1
	mpd11 (net56 inn net31 net31) pmos1 l=180n w=1u m=1
	mp001 (out net158 vdda vdda) pmos1 l=3.0e-07n w=1.3e-06u m=1
	mpd12 (net13 inp net31 net31) pmos1 l=180n w=1u m=1
	mpb01 (net158 net158 vdda vdda) pmos1 l=180n w=1u m=1
ends OPAMP1_variant915

subckt OPAMP1_variant916 inn inp out pd xpd vdda vssa
	xd1 (vssa vdda) prim_nwd AREA=6.13907e-9 PJ=476.6e-6 m=1
	xi0 (vssa net69) prim_nd AREA=1e-12 PJ=4e-6 m=1
	xi3 (net51 vdda) prim_pd AREA=790e-15 PJ=3.3e-6 m=1
	xr0 (vssa vdda net51) prim_rdiffp l=1.1e-07 w=1.3e-06 m=1
	xr1 (vdda vdda net69) prim_rdiffp l=2.1e-6 w=700e-9 m=1
	xcc01 (net12 out) prim_cpoly c=1p m=1
	mnm12 (net13 net56 vssa vssa) nmos1 l=180n w=1u m=1
	mnm11 (net56 net56 vssa vssa) nmos1 l=180n w=1u m=1
	mnb02 (net27 net27 net21 vssa) nmos1 l=180n w=1u m=1
	mnpd1 (net21 xpd vssa vssa) nmos1 l=180n w=1u m=1
	mn001 (out net13 vssa vssa) nmos1 l=180n w=1u m=1
	mnpd2 (net13 pd vssa vssa) nmos1 l=3.0e-07n w=9.2e-07u m=1
	mnc01 (net13 net69 net12 vssa) nmos1 l=180n w=1u m=1
	mpb02 (net27 net51 net158 vdda) pmos1 l=1.1e-07n w=1.2e-06u m=1
	mppd1 (net158 xpd vdda vdda) pmos1 l=180n w=1u m=1
	mps11 (net31 net158 vdda vdda) pmos1 l=180n w=1u m=1
	mpd11 (net56 inn net31 net31) pmos1 l=1.6e-07n w=1.7e-06u m=1
	mp001 (out net158 vdda vdda) pmos1 l=180n w=1u m=1
	mpd12 (net13 inp net31 net31) pmos1 l=180n w=1u m=1
	mpb01 (net158 net158 vdda vdda) pmos1 l=180n w=1u m=1
ends OPAMP1_variant916

subckt OPAMP1_variant917 inn inp out pd xpd vdda vssa
	xd1 (vssa vdda) prim_nwd AREA=4.3e-09 PJ=2.5e-05 m=1
	xi0 (vssa net69) prim_nd AREA=1e-12 PJ=4e-6 m=1
	xi3 (net51 vdda) prim_pd AREA=790e-15 PJ=3.3e-6 m=1
	xr0 (vssa vdda net51) prim_rdiffp l=2.1e-6 w=700e-9 m=1
	xr1 (vdda vdda net69) prim_rdiffp l=2.1e-6 w=700e-9 m=1
	xcc01 (net12 out) prim_cpoly c=1p m=1
	mnm12 (net13 net56 vssa vssa) nmos1 l=180n w=1u m=1
	mnm11 (net56 net56 vssa vssa) nmos1 l=180n w=1u m=1
	mnb02 (net27 net27 net21 vssa) nmos1 l=180n w=1u m=1
	mnpd1 (net21 xpd vssa vssa) nmos1 l=180n w=1u m=1
	mn001 (out net13 vssa vssa) nmos1 l=180n w=1u m=1
	mnpd2 (net13 pd vssa vssa) nmos1 l=180n w=1u m=1
	mnc01 (net13 net69 net12 vssa) nmos1 l=2.9e-07n w=1.1e-06u m=1
	mpb02 (net27 net51 net158 vdda) pmos1 l=2.4e-07n w=1.2e-06u m=1
	mppd1 (net158 xpd vdda vdda) pmos1 l=180n w=1u m=1
	mps11 (net31 net158 vdda vdda) pmos1 l=180n w=1u m=1
	mpd11 (net56 inn net31 net31) pmos1 l=180n w=1u m=1
	mp001 (out net158 vdda vdda) pmos1 l=180n w=1u m=1
	mpd12 (net13 inp net31 net31) pmos1 l=180n w=1u m=1
	mpb01 (net158 net158 vdda vdda) pmos1 l=1.1e-07n w=1.0e-06u m=1
ends OPAMP1_variant917

subckt OPAMP1_variant918 inn inp out pd xpd vdda vssa
	xd1 (vssa vdda) prim_nwd AREA=6.13907e-9 PJ=476.6e-6 m=1
	xi0 (vssa net69) prim_nd AREA=1e-12 PJ=4e-6 m=1
	xi3 (net51 vdda) prim_pd AREA=790e-15 PJ=3.3e-6 m=1
	xr0 (vssa vdda net51) prim_rdiffp l=2.1e-6 w=700e-9 m=1
	xr1 (vdda vdda net69) prim_rdiffp l=2.1e-6 w=700e-9 m=1
	xcc01 (net12 out) prim_cpoly c=5.4e-13p m=1
	mnm12 (net13 net56 vssa vssa) nmos1 l=180n w=1u m=1
	mnm11 (net56 net56 vssa vssa) nmos1 l=180n w=1u m=1
	mnb02 (net27 net27 net21 vssa) nmos1 l=180n w=1u m=1
	mnpd1 (net21 xpd vssa vssa) nmos1 l=180n w=1u m=1
	mn001 (out net13 vssa vssa) nmos1 l=2.6e-07n w=7.4e-07u m=1
	mnpd2 (net13 pd vssa vssa) nmos1 l=180n w=1u m=1
	mnc01 (net13 net69 net12 vssa) nmos1 l=180n w=1u m=1
	mpb02 (net27 net51 net158 vdda) pmos1 l=180n w=1u m=1
	mppd1 (net158 xpd vdda vdda) pmos1 l=180n w=1u m=1
	mps11 (net31 net158 vdda vdda) pmos1 l=180n w=1u m=1
	mpd11 (net56 inn net31 net31) pmos1 l=2.4e-07n w=5.5e-07u m=1
	mp001 (out net158 vdda vdda) pmos1 l=180n w=1u m=1
	mpd12 (net13 inp net31 net31) pmos1 l=180n w=1u m=1
	mpb01 (net158 net158 vdda vdda) pmos1 l=180n w=1u m=1
ends OPAMP1_variant918

subckt OPAMP1_variant919 inn inp out pd xpd vdda vssa
	xd1 (vssa vdda) prim_nwd AREA=6.13907e-9 PJ=476.6e-6 m=1
	xi0 (vssa net69) prim_nd AREA=1e-12 PJ=4e-6 m=1
	xi3 (net51 vdda) prim_pd AREA=790e-15 PJ=3.3e-6 m=1
	xr0 (vssa vdda net51) prim_rdiffp l=2.1e-6 w=700e-9 m=1
	xr1 (vdda vdda net69) prim_rdiffp l=2.1e-6 w=700e-9 m=1
	xcc01 (net12 out) prim_cpoly c=1p m=1
	mnm12 (net13 net56 vssa vssa) nmos1 l=180n w=1u m=1
	mnm11 (net56 net56 vssa vssa) nmos1 l=1.2e-07n w=7.9e-07u m=1
	mnb02 (net27 net27 net21 vssa) nmos1 l=180n w=1u m=1
	mnpd1 (net21 xpd vssa vssa) nmos1 l=180n w=1u m=1
	mn001 (out net13 vssa vssa) nmos1 l=180n w=1u m=1
	mnpd2 (net13 pd vssa vssa) nmos1 l=180n w=1u m=1
	mnc01 (net13 net69 net12 vssa) nmos1 l=2.1e-07n w=1.7e-06u m=1
	mpb02 (net27 net51 net158 vdda) pmos1 l=2.4e-07n w=5.5e-07u m=1
	mppd1 (net158 xpd vdda vdda) pmos1 l=180n w=1u m=1
	mps11 (net31 net158 vdda vdda) pmos1 l=180n w=1u m=1
	mpd11 (net56 inn net31 net31) pmos1 l=180n w=1u m=1
	mp001 (out net158 vdda vdda) pmos1 l=180n w=1u m=1
	mpd12 (net13 inp net31 net31) pmos1 l=180n w=1u m=1
	mpb01 (net158 net158 vdda vdda) pmos1 l=180n w=1u m=1
ends OPAMP1_variant919

subckt OPAMP1_variant920 inn inp out pd xpd vdda vssa
	xd1 (vssa vdda) prim_nwd AREA=6.13907e-9 PJ=476.6e-6 m=1
	xi0 (vssa net69) prim_nd AREA=1e-12 PJ=4e-6 m=1
	xi3 (net51 vdda) prim_pd AREA=790e-15 PJ=3.3e-6 m=1
	xr0 (vssa vdda net51) prim_rdiffp l=2.1e-6 w=700e-9 m=1
	xr1 (vdda vdda net69) prim_rdiffp l=2.1e-6 w=700e-9 m=1
	xcc01 (net12 out) prim_cpoly c=1p m=1
	mnm12 (net13 net56 vssa vssa) nmos1 l=180n w=1u m=1
	mnm11 (net56 net56 vssa vssa) nmos1 l=180n w=1u m=1
	mnb02 (net27 net27 net21 vssa) nmos1 l=180n w=1u m=1
	mnpd1 (net21 xpd vssa vssa) nmos1 l=1.9e-07n w=1.6e-06u m=1
	mn001 (out net13 vssa vssa) nmos1 l=180n w=1u m=1
	mnpd2 (net13 pd vssa vssa) nmos1 l=180n w=1u m=1
	mnc01 (net13 net69 net12 vssa) nmos1 l=2.1e-07n w=1.6e-06u m=1
	mpb02 (net27 net51 net158 vdda) pmos1 l=180n w=1u m=1
	mppd1 (net158 xpd vdda vdda) pmos1 l=180n w=1u m=1
	mps11 (net31 net158 vdda vdda) pmos1 l=180n w=1u m=1
	mpd11 (net56 inn net31 net31) pmos1 l=180n w=1u m=1
	mp001 (out net158 vdda vdda) pmos1 l=180n w=1u m=1
	mpd12 (net13 inp net31 net31) pmos1 l=180n w=1u m=1
	mpb01 (net158 net158 vdda vdda) pmos1 l=180n w=1u m=1
ends OPAMP1_variant920

subckt OPAMP1_variant921 inn inp out pd xpd vdda vssa
	xd1 (vssa vdda) prim_nwd AREA=5.4e-09 PJ=5.2e-05 m=1
	xi0 (vssa net69) prim_nd AREA=5.2e-09 PJ=3.5e-05 m=1
	xi3 (net51 vdda) prim_pd AREA=790e-15 PJ=3.3e-6 m=1
	xr0 (vssa vdda net51) prim_rdiffp l=2.1e-6 w=700e-9 m=1
	xr1 (vdda vdda net69) prim_rdiffp l=2.1e-6 w=700e-9 m=1
	xcc01 (net12 out) prim_cpoly c=1p m=1
	mnm12 (net13 net56 vssa vssa) nmos1 l=180n w=1u m=1
	mnm11 (net56 net56 vssa vssa) nmos1 l=180n w=1u m=1
	mnb02 (net27 net27 net21 vssa) nmos1 l=2.6e-07n w=1.2e-06u m=1
	mnpd1 (net21 xpd vssa vssa) nmos1 l=180n w=1u m=1
	mn001 (out net13 vssa vssa) nmos1 l=1.0e-07n w=6.1e-07u m=1
	mnpd2 (net13 pd vssa vssa) nmos1 l=180n w=1u m=1
	mnc01 (net13 net69 net12 vssa) nmos1 l=2.7e-07n w=1.7e-06u m=1
	mpb02 (net27 net51 net158 vdda) pmos1 l=180n w=1u m=1
	mppd1 (net158 xpd vdda vdda) pmos1 l=180n w=1u m=1
	mps11 (net31 net158 vdda vdda) pmos1 l=180n w=1u m=1
	mpd11 (net56 inn net31 net31) pmos1 l=180n w=1u m=1
	mp001 (out net158 vdda vdda) pmos1 l=180n w=1u m=1
	mpd12 (net13 inp net31 net31) pmos1 l=180n w=1u m=1
	mpb01 (net158 net158 vdda vdda) pmos1 l=180n w=1u m=1
ends OPAMP1_variant921

subckt OPAMP1_variant922 inn inp out pd xpd vdda vssa
	xd1 (vssa vdda) prim_nwd AREA=6.7e-09 PJ=9.3e-05 m=1
	xi0 (vssa net69) prim_nd AREA=1e-12 PJ=4e-6 m=1
	xi3 (net51 vdda) prim_pd AREA=790e-15 PJ=3.3e-6 m=1
	xr0 (vssa vdda net51) prim_rdiffp l=2.1e-6 w=700e-9 m=1
	xr1 (vdda vdda net69) prim_rdiffp l=2.1e-6 w=700e-9 m=1
	xcc01 (net12 out) prim_cpoly c=1p m=1
	mnm12 (net13 net56 vssa vssa) nmos1 l=180n w=1u m=1
	mnm11 (net56 net56 vssa vssa) nmos1 l=2.0e-07n w=1.8e-06u m=1
	mnb02 (net27 net27 net21 vssa) nmos1 l=180n w=1u m=1
	mnpd1 (net21 xpd vssa vssa) nmos1 l=180n w=1u m=1
	mn001 (out net13 vssa vssa) nmos1 l=1.4e-07n w=1.7e-06u m=1
	mnpd2 (net13 pd vssa vssa) nmos1 l=180n w=1u m=1
	mnc01 (net13 net69 net12 vssa) nmos1 l=1.5e-07n w=1.1e-06u m=1
	mpb02 (net27 net51 net158 vdda) pmos1 l=180n w=1u m=1
	mppd1 (net158 xpd vdda vdda) pmos1 l=180n w=1u m=1
	mps11 (net31 net158 vdda vdda) pmos1 l=180n w=1u m=1
	mpd11 (net56 inn net31 net31) pmos1 l=180n w=1u m=1
	mp001 (out net158 vdda vdda) pmos1 l=1.8e-07n w=1.6e-06u m=1
	mpd12 (net13 inp net31 net31) pmos1 l=180n w=1u m=1
	mpb01 (net158 net158 vdda vdda) pmos1 l=180n w=1u m=1
ends OPAMP1_variant922

subckt OPAMP1_variant923 inn inp out pd xpd vdda vssa
	xd1 (vssa vdda) prim_nwd AREA=6.13907e-9 PJ=476.6e-6 m=1
	xi0 (vssa net69) prim_nd AREA=7.9e-10 PJ=7.1e-05 m=1
	xi3 (net51 vdda) prim_pd AREA=790e-15 PJ=3.3e-6 m=1
	xr0 (vssa vdda net51) prim_rdiffp l=2.4e-07 w=8.1e-07 m=1
	xr1 (vdda vdda net69) prim_rdiffp l=2.1e-6 w=700e-9 m=1
	xcc01 (net12 out) prim_cpoly c=1p m=1
	mnm12 (net13 net56 vssa vssa) nmos1 l=180n w=1u m=1
	mnm11 (net56 net56 vssa vssa) nmos1 l=180n w=1u m=1
	mnb02 (net27 net27 net21 vssa) nmos1 l=180n w=1u m=1
	mnpd1 (net21 xpd vssa vssa) nmos1 l=1.4e-07n w=5.0e-07u m=1
	mn001 (out net13 vssa vssa) nmos1 l=180n w=1u m=1
	mnpd2 (net13 pd vssa vssa) nmos1 l=180n w=1u m=1
	mnc01 (net13 net69 net12 vssa) nmos1 l=180n w=1u m=1
	mpb02 (net27 net51 net158 vdda) pmos1 l=180n w=1u m=1
	mppd1 (net158 xpd vdda vdda) pmos1 l=180n w=1u m=1
	mps11 (net31 net158 vdda vdda) pmos1 l=180n w=1u m=1
	mpd11 (net56 inn net31 net31) pmos1 l=180n w=1u m=1
	mp001 (out net158 vdda vdda) pmos1 l=180n w=1u m=1
	mpd12 (net13 inp net31 net31) pmos1 l=2.2e-07n w=6.2e-07u m=1
	mpb01 (net158 net158 vdda vdda) pmos1 l=180n w=1u m=1
ends OPAMP1_variant923

subckt OPAMP1_variant924 inn inp out pd xpd vdda vssa
	xd1 (vssa vdda) prim_nwd AREA=6.13907e-9 PJ=476.6e-6 m=1
	xi0 (vssa net69) prim_nd AREA=3.2e-10 PJ=5.0e-05 m=1
	xi3 (net51 vdda) prim_pd AREA=790e-15 PJ=3.3e-6 m=1
	xr0 (vssa vdda net51) prim_rdiffp l=2.1e-6 w=700e-9 m=1
	xr1 (vdda vdda net69) prim_rdiffp l=2.1e-6 w=700e-9 m=1
	xcc01 (net12 out) prim_cpoly c=1p m=1
	mnm12 (net13 net56 vssa vssa) nmos1 l=1.3e-07n w=1.9e-06u m=1
	mnm11 (net56 net56 vssa vssa) nmos1 l=180n w=1u m=1
	mnb02 (net27 net27 net21 vssa) nmos1 l=180n w=1u m=1
	mnpd1 (net21 xpd vssa vssa) nmos1 l=180n w=1u m=1
	mn001 (out net13 vssa vssa) nmos1 l=180n w=1u m=1
	mnpd2 (net13 pd vssa vssa) nmos1 l=180n w=1u m=1
	mnc01 (net13 net69 net12 vssa) nmos1 l=180n w=1u m=1
	mpb02 (net27 net51 net158 vdda) pmos1 l=180n w=1u m=1
	mppd1 (net158 xpd vdda vdda) pmos1 l=180n w=1u m=1
	mps11 (net31 net158 vdda vdda) pmos1 l=180n w=1u m=1
	mpd11 (net56 inn net31 net31) pmos1 l=180n w=1u m=1
	mp001 (out net158 vdda vdda) pmos1 l=180n w=1u m=1
	mpd12 (net13 inp net31 net31) pmos1 l=180n w=1u m=1
	mpb01 (net158 net158 vdda vdda) pmos1 l=180n w=1u m=1
ends OPAMP1_variant924

subckt OPAMP1_variant925 inn inp out pd xpd vdda vssa
	xd1 (vssa vdda) prim_nwd AREA=6.13907e-9 PJ=476.6e-6 m=1
	xi0 (vssa net69) prim_nd AREA=1e-12 PJ=4e-6 m=1
	xi3 (net51 vdda) prim_pd AREA=6.8e-10 PJ=8.3e-05 m=1
	xr0 (vssa vdda net51) prim_rdiffp l=2.1e-6 w=700e-9 m=1
	xr1 (vdda vdda net69) prim_rdiffp l=2.1e-6 w=700e-9 m=1
	xcc01 (net12 out) prim_cpoly c=1p m=1
	mnm12 (net13 net56 vssa vssa) nmos1 l=180n w=1u m=1
	mnm11 (net56 net56 vssa vssa) nmos1 l=180n w=1u m=1
	mnb02 (net27 net27 net21 vssa) nmos1 l=1.9e-07n w=1.3e-06u m=1
	mnpd1 (net21 xpd vssa vssa) nmos1 l=180n w=1u m=1
	mn001 (out net13 vssa vssa) nmos1 l=180n w=1u m=1
	mnpd2 (net13 pd vssa vssa) nmos1 l=180n w=1u m=1
	mnc01 (net13 net69 net12 vssa) nmos1 l=180n w=1u m=1
	mpb02 (net27 net51 net158 vdda) pmos1 l=180n w=1u m=1
	mppd1 (net158 xpd vdda vdda) pmos1 l=180n w=1u m=1
	mps11 (net31 net158 vdda vdda) pmos1 l=180n w=1u m=1
	mpd11 (net56 inn net31 net31) pmos1 l=180n w=1u m=1
	mp001 (out net158 vdda vdda) pmos1 l=180n w=1u m=1
	mpd12 (net13 inp net31 net31) pmos1 l=180n w=1u m=1
	mpb01 (net158 net158 vdda vdda) pmos1 l=180n w=1u m=1
ends OPAMP1_variant925

subckt OPAMP1_variant926 inn inp out pd xpd vdda vssa
	xd1 (vssa vdda) prim_nwd AREA=6.13907e-9 PJ=476.6e-6 m=1
	xi0 (vssa net69) prim_nd AREA=1e-12 PJ=4e-6 m=1
	xi3 (net51 vdda) prim_pd AREA=790e-15 PJ=3.3e-6 m=1
	xr0 (vssa vdda net51) prim_rdiffp l=2.1e-6 w=700e-9 m=1
	xr1 (vdda vdda net69) prim_rdiffp l=2.1e-6 w=700e-9 m=1
	xcc01 (net12 out) prim_cpoly c=1p m=1
	mnm12 (net13 net56 vssa vssa) nmos1 l=180n w=1u m=1
	mnm11 (net56 net56 vssa vssa) nmos1 l=2.1e-07n w=1.4e-06u m=1
	mnb02 (net27 net27 net21 vssa) nmos1 l=3.0e-07n w=1.5e-06u m=1
	mnpd1 (net21 xpd vssa vssa) nmos1 l=180n w=1u m=1
	mn001 (out net13 vssa vssa) nmos1 l=180n w=1u m=1
	mnpd2 (net13 pd vssa vssa) nmos1 l=180n w=1u m=1
	mnc01 (net13 net69 net12 vssa) nmos1 l=180n w=1u m=1
	mpb02 (net27 net51 net158 vdda) pmos1 l=180n w=1u m=1
	mppd1 (net158 xpd vdda vdda) pmos1 l=180n w=1u m=1
	mps11 (net31 net158 vdda vdda) pmos1 l=180n w=1u m=1
	mpd11 (net56 inn net31 net31) pmos1 l=180n w=1u m=1
	mp001 (out net158 vdda vdda) pmos1 l=180n w=1u m=1
	mpd12 (net13 inp net31 net31) pmos1 l=180n w=1u m=1
	mpb01 (net158 net158 vdda vdda) pmos1 l=180n w=1u m=1
ends OPAMP1_variant926

subckt OPAMP1_variant927 inn inp out pd xpd vdda vssa
	xd1 (vssa vdda) prim_nwd AREA=6.13907e-9 PJ=476.6e-6 m=1
	xi0 (vssa net69) prim_nd AREA=1e-12 PJ=4e-6 m=1
	xi3 (net51 vdda) prim_pd AREA=790e-15 PJ=3.3e-6 m=1
	xr0 (vssa vdda net51) prim_rdiffp l=2.1e-6 w=700e-9 m=1
	xr1 (vdda vdda net69) prim_rdiffp l=2.1e-6 w=700e-9 m=1
	xcc01 (net12 out) prim_cpoly c=1p m=1
	mnm12 (net13 net56 vssa vssa) nmos1 l=180n w=1u m=1
	mnm11 (net56 net56 vssa vssa) nmos1 l=2.5e-07n w=1.5e-06u m=1
	mnb02 (net27 net27 net21 vssa) nmos1 l=180n w=1u m=1
	mnpd1 (net21 xpd vssa vssa) nmos1 l=180n w=1u m=1
	mn001 (out net13 vssa vssa) nmos1 l=180n w=1u m=1
	mnpd2 (net13 pd vssa vssa) nmos1 l=180n w=1u m=1
	mnc01 (net13 net69 net12 vssa) nmos1 l=180n w=1u m=1
	mpb02 (net27 net51 net158 vdda) pmos1 l=180n w=1u m=1
	mppd1 (net158 xpd vdda vdda) pmos1 l=180n w=1u m=1
	mps11 (net31 net158 vdda vdda) pmos1 l=180n w=1u m=1
	mpd11 (net56 inn net31 net31) pmos1 l=1.9e-07n w=9.5e-07u m=1
	mp001 (out net158 vdda vdda) pmos1 l=180n w=1u m=1
	mpd12 (net13 inp net31 net31) pmos1 l=180n w=1u m=1
	mpb01 (net158 net158 vdda vdda) pmos1 l=180n w=1u m=1
ends OPAMP1_variant927

subckt OPAMP1_variant928 inn inp out pd xpd vdda vssa
	xd1 (vssa vdda) prim_nwd AREA=6.13907e-9 PJ=476.6e-6 m=1
	xi0 (vssa net69) prim_nd AREA=1e-12 PJ=4e-6 m=1
	xi3 (net51 vdda) prim_pd AREA=790e-15 PJ=3.3e-6 m=1
	xr0 (vssa vdda net51) prim_rdiffp l=2.1e-6 w=700e-9 m=1
	xr1 (vdda vdda net69) prim_rdiffp l=2.1e-6 w=700e-9 m=1
	xcc01 (net12 out) prim_cpoly c=1p m=1
	mnm12 (net13 net56 vssa vssa) nmos1 l=1.9e-07n w=1.0e-06u m=1
	mnm11 (net56 net56 vssa vssa) nmos1 l=180n w=1u m=1
	mnb02 (net27 net27 net21 vssa) nmos1 l=180n w=1u m=1
	mnpd1 (net21 xpd vssa vssa) nmos1 l=180n w=1u m=1
	mn001 (out net13 vssa vssa) nmos1 l=180n w=1u m=1
	mnpd2 (net13 pd vssa vssa) nmos1 l=180n w=1u m=1
	mnc01 (net13 net69 net12 vssa) nmos1 l=180n w=1u m=1
	mpb02 (net27 net51 net158 vdda) pmos1 l=180n w=1u m=1
	mppd1 (net158 xpd vdda vdda) pmos1 l=180n w=1u m=1
	mps11 (net31 net158 vdda vdda) pmos1 l=1.6e-07n w=1.1e-06u m=1
	mpd11 (net56 inn net31 net31) pmos1 l=1.7e-07n w=9.4e-07u m=1
	mp001 (out net158 vdda vdda) pmos1 l=2.6e-07n w=9.0e-07u m=1
	mpd12 (net13 inp net31 net31) pmos1 l=2.9e-07n w=1.7e-06u m=1
	mpb01 (net158 net158 vdda vdda) pmos1 l=180n w=1u m=1
ends OPAMP1_variant928

subckt OPAMP1_variant929 inn inp out pd xpd vdda vssa
	xd1 (vssa vdda) prim_nwd AREA=6.13907e-9 PJ=476.6e-6 m=1
	xi0 (vssa net69) prim_nd AREA=1e-12 PJ=4e-6 m=1
	xi3 (net51 vdda) prim_pd AREA=790e-15 PJ=3.3e-6 m=1
	xr0 (vssa vdda net51) prim_rdiffp l=2.1e-6 w=700e-9 m=1
	xr1 (vdda vdda net69) prim_rdiffp l=2.1e-6 w=700e-9 m=1
	xcc01 (net12 out) prim_cpoly c=1p m=1
	mnm12 (net13 net56 vssa vssa) nmos1 l=180n w=1u m=1
	mnm11 (net56 net56 vssa vssa) nmos1 l=180n w=1u m=1
	mnb02 (net27 net27 net21 vssa) nmos1 l=2.1e-07n w=1.4e-06u m=1
	mnpd1 (net21 xpd vssa vssa) nmos1 l=180n w=1u m=1
	mn001 (out net13 vssa vssa) nmos1 l=180n w=1u m=1
	mnpd2 (net13 pd vssa vssa) nmos1 l=180n w=1u m=1
	mnc01 (net13 net69 net12 vssa) nmos1 l=180n w=1u m=1
	mpb02 (net27 net51 net158 vdda) pmos1 l=180n w=1u m=1
	mppd1 (net158 xpd vdda vdda) pmos1 l=180n w=1u m=1
	mps11 (net31 net158 vdda vdda) pmos1 l=180n w=1u m=1
	mpd11 (net56 inn net31 net31) pmos1 l=180n w=1u m=1
	mp001 (out net158 vdda vdda) pmos1 l=1.0e-07n w=9.5e-07u m=1
	mpd12 (net13 inp net31 net31) pmos1 l=180n w=1u m=1
	mpb01 (net158 net158 vdda vdda) pmos1 l=180n w=1u m=1
ends OPAMP1_variant929

subckt OPAMP1_variant930 inn inp out pd xpd vdda vssa
	xd1 (vssa vdda) prim_nwd AREA=6.13907e-9 PJ=476.6e-6 m=1
	xi0 (vssa net69) prim_nd AREA=1.7e-09 PJ=8.4e-05 m=1
	xi3 (net51 vdda) prim_pd AREA=3.6e-09 PJ=2.9e-05 m=1
	xr0 (vssa vdda net51) prim_rdiffp l=2.1e-6 w=700e-9 m=1
	xr1 (vdda vdda net69) prim_rdiffp l=2.1e-6 w=700e-9 m=1
	xcc01 (net12 out) prim_cpoly c=1p m=1
	mnm12 (net13 net56 vssa vssa) nmos1 l=180n w=1u m=1
	mnm11 (net56 net56 vssa vssa) nmos1 l=2.6e-07n w=1.7e-06u m=1
	mnb02 (net27 net27 net21 vssa) nmos1 l=1.5e-07n w=1.1e-06u m=1
	mnpd1 (net21 xpd vssa vssa) nmos1 l=180n w=1u m=1
	mn001 (out net13 vssa vssa) nmos1 l=180n w=1u m=1
	mnpd2 (net13 pd vssa vssa) nmos1 l=180n w=1u m=1
	mnc01 (net13 net69 net12 vssa) nmos1 l=180n w=1u m=1
	mpb02 (net27 net51 net158 vdda) pmos1 l=180n w=1u m=1
	mppd1 (net158 xpd vdda vdda) pmos1 l=180n w=1u m=1
	mps11 (net31 net158 vdda vdda) pmos1 l=180n w=1u m=1
	mpd11 (net56 inn net31 net31) pmos1 l=180n w=1u m=1
	mp001 (out net158 vdda vdda) pmos1 l=180n w=1u m=1
	mpd12 (net13 inp net31 net31) pmos1 l=180n w=1u m=1
	mpb01 (net158 net158 vdda vdda) pmos1 l=1.3e-07n w=7.1e-07u m=1
ends OPAMP1_variant930

subckt OPAMP1_variant931 inn inp out pd xpd vdda vssa
	xd1 (vssa vdda) prim_nwd AREA=6.13907e-9 PJ=476.6e-6 m=1
	xi0 (vssa net69) prim_nd AREA=1e-12 PJ=4e-6 m=1
	xi3 (net51 vdda) prim_pd AREA=790e-15 PJ=3.3e-6 m=1
	xr0 (vssa vdda net51) prim_rdiffp l=2.1e-6 w=700e-9 m=1
	xr1 (vdda vdda net69) prim_rdiffp l=1.5e-07 w=1.8e-06 m=1
	xcc01 (net12 out) prim_cpoly c=1p m=1
	mnm12 (net13 net56 vssa vssa) nmos1 l=180n w=1u m=1
	mnm11 (net56 net56 vssa vssa) nmos1 l=180n w=1u m=1
	mnb02 (net27 net27 net21 vssa) nmos1 l=180n w=1u m=1
	mnpd1 (net21 xpd vssa vssa) nmos1 l=180n w=1u m=1
	mn001 (out net13 vssa vssa) nmos1 l=180n w=1u m=1
	mnpd2 (net13 pd vssa vssa) nmos1 l=1.1e-07n w=1.8e-06u m=1
	mnc01 (net13 net69 net12 vssa) nmos1 l=180n w=1u m=1
	mpb02 (net27 net51 net158 vdda) pmos1 l=180n w=1u m=1
	mppd1 (net158 xpd vdda vdda) pmos1 l=180n w=1u m=1
	mps11 (net31 net158 vdda vdda) pmos1 l=180n w=1u m=1
	mpd11 (net56 inn net31 net31) pmos1 l=180n w=1u m=1
	mp001 (out net158 vdda vdda) pmos1 l=180n w=1u m=1
	mpd12 (net13 inp net31 net31) pmos1 l=180n w=1u m=1
	mpb01 (net158 net158 vdda vdda) pmos1 l=180n w=1u m=1
ends OPAMP1_variant931

subckt OPAMP1_variant932 inn inp out pd xpd vdda vssa
	xd1 (vssa vdda) prim_nwd AREA=6.13907e-9 PJ=476.6e-6 m=1
	xi0 (vssa net69) prim_nd AREA=1e-12 PJ=4e-6 m=1
	xi3 (net51 vdda) prim_pd AREA=790e-15 PJ=3.3e-6 m=1
	xr0 (vssa vdda net51) prim_rdiffp l=2.1e-6 w=700e-9 m=1
	xr1 (vdda vdda net69) prim_rdiffp l=2.1e-6 w=700e-9 m=1
	xcc01 (net12 out) prim_cpoly c=1p m=1
	mnm12 (net13 net56 vssa vssa) nmos1 l=180n w=1u m=1
	mnm11 (net56 net56 vssa vssa) nmos1 l=180n w=1u m=1
	mnb02 (net27 net27 net21 vssa) nmos1 l=180n w=1u m=1
	mnpd1 (net21 xpd vssa vssa) nmos1 l=180n w=1u m=1
	mn001 (out net13 vssa vssa) nmos1 l=180n w=1u m=1
	mnpd2 (net13 pd vssa vssa) nmos1 l=180n w=1u m=1
	mnc01 (net13 net69 net12 vssa) nmos1 l=180n w=1u m=1
	mpb02 (net27 net51 net158 vdda) pmos1 l=180n w=1u m=1
	mppd1 (net158 xpd vdda vdda) pmos1 l=1.9e-07n w=6.9e-07u m=1
	mps11 (net31 net158 vdda vdda) pmos1 l=180n w=1u m=1
	mpd11 (net56 inn net31 net31) pmos1 l=180n w=1u m=1
	mp001 (out net158 vdda vdda) pmos1 l=1.9e-07n w=1.8e-06u m=1
	mpd12 (net13 inp net31 net31) pmos1 l=180n w=1u m=1
	mpb01 (net158 net158 vdda vdda) pmos1 l=180n w=1u m=1
ends OPAMP1_variant932

subckt OPAMP1_variant933 inn inp out pd xpd vdda vssa
	xd1 (vssa vdda) prim_nwd AREA=8.6e-09 PJ=7.8e-05 m=1
	xi0 (vssa net69) prim_nd AREA=1e-12 PJ=4e-6 m=1
	xi3 (net51 vdda) prim_pd AREA=790e-15 PJ=3.3e-6 m=1
	xr0 (vssa vdda net51) prim_rdiffp l=2.1e-6 w=700e-9 m=1
	xr1 (vdda vdda net69) prim_rdiffp l=2.1e-6 w=700e-9 m=1
	xcc01 (net12 out) prim_cpoly c=1p m=1
	mnm12 (net13 net56 vssa vssa) nmos1 l=180n w=1u m=1
	mnm11 (net56 net56 vssa vssa) nmos1 l=2.1e-07n w=9.1e-07u m=1
	mnb02 (net27 net27 net21 vssa) nmos1 l=180n w=1u m=1
	mnpd1 (net21 xpd vssa vssa) nmos1 l=180n w=1u m=1
	mn001 (out net13 vssa vssa) nmos1 l=180n w=1u m=1
	mnpd2 (net13 pd vssa vssa) nmos1 l=180n w=1u m=1
	mnc01 (net13 net69 net12 vssa) nmos1 l=2.8e-07n w=8.0e-07u m=1
	mpb02 (net27 net51 net158 vdda) pmos1 l=180n w=1u m=1
	mppd1 (net158 xpd vdda vdda) pmos1 l=2.4e-07n w=1.5e-06u m=1
	mps11 (net31 net158 vdda vdda) pmos1 l=180n w=1u m=1
	mpd11 (net56 inn net31 net31) pmos1 l=180n w=1u m=1
	mp001 (out net158 vdda vdda) pmos1 l=180n w=1u m=1
	mpd12 (net13 inp net31 net31) pmos1 l=1.1e-07n w=1.4e-06u m=1
	mpb01 (net158 net158 vdda vdda) pmos1 l=180n w=1u m=1
ends OPAMP1_variant933

subckt OPAMP1_variant934 inn inp out pd xpd vdda vssa
	xd1 (vssa vdda) prim_nwd AREA=5.9e-09 PJ=7.5e-05 m=1
	xi0 (vssa net69) prim_nd AREA=1e-12 PJ=4e-6 m=1
	xi3 (net51 vdda) prim_pd AREA=790e-15 PJ=3.3e-6 m=1
	xr0 (vssa vdda net51) prim_rdiffp l=2.1e-6 w=700e-9 m=1
	xr1 (vdda vdda net69) prim_rdiffp l=2.1e-6 w=700e-9 m=1
	xcc01 (net12 out) prim_cpoly c=1.9e-12p m=1
	mnm12 (net13 net56 vssa vssa) nmos1 l=2.8e-07n w=1.3e-06u m=1
	mnm11 (net56 net56 vssa vssa) nmos1 l=180n w=1u m=1
	mnb02 (net27 net27 net21 vssa) nmos1 l=1.3e-07n w=9.7e-07u m=1
	mnpd1 (net21 xpd vssa vssa) nmos1 l=180n w=1u m=1
	mn001 (out net13 vssa vssa) nmos1 l=180n w=1u m=1
	mnpd2 (net13 pd vssa vssa) nmos1 l=180n w=1u m=1
	mnc01 (net13 net69 net12 vssa) nmos1 l=180n w=1u m=1
	mpb02 (net27 net51 net158 vdda) pmos1 l=180n w=1u m=1
	mppd1 (net158 xpd vdda vdda) pmos1 l=180n w=1u m=1
	mps11 (net31 net158 vdda vdda) pmos1 l=2.4e-07n w=1.7e-06u m=1
	mpd11 (net56 inn net31 net31) pmos1 l=180n w=1u m=1
	mp001 (out net158 vdda vdda) pmos1 l=180n w=1u m=1
	mpd12 (net13 inp net31 net31) pmos1 l=180n w=1u m=1
	mpb01 (net158 net158 vdda vdda) pmos1 l=180n w=1u m=1
ends OPAMP1_variant934

subckt OPAMP1_variant935 inn inp out pd xpd vdda vssa
	xd1 (vssa vdda) prim_nwd AREA=6.13907e-9 PJ=476.6e-6 m=1
	xi0 (vssa net69) prim_nd AREA=1e-12 PJ=4e-6 m=1
	xi3 (net51 vdda) prim_pd AREA=790e-15 PJ=3.3e-6 m=1
	xr0 (vssa vdda net51) prim_rdiffp l=2.1e-6 w=700e-9 m=1
	xr1 (vdda vdda net69) prim_rdiffp l=2.6e-07 w=1.5e-06 m=1
	xcc01 (net12 out) prim_cpoly c=1p m=1
	mnm12 (net13 net56 vssa vssa) nmos1 l=180n w=1u m=1
	mnm11 (net56 net56 vssa vssa) nmos1 l=180n w=1u m=1
	mnb02 (net27 net27 net21 vssa) nmos1 l=180n w=1u m=1
	mnpd1 (net21 xpd vssa vssa) nmos1 l=180n w=1u m=1
	mn001 (out net13 vssa vssa) nmos1 l=180n w=1u m=1
	mnpd2 (net13 pd vssa vssa) nmos1 l=180n w=1u m=1
	mnc01 (net13 net69 net12 vssa) nmos1 l=180n w=1u m=1
	mpb02 (net27 net51 net158 vdda) pmos1 l=180n w=1u m=1
	mppd1 (net158 xpd vdda vdda) pmos1 l=180n w=1u m=1
	mps11 (net31 net158 vdda vdda) pmos1 l=180n w=1u m=1
	mpd11 (net56 inn net31 net31) pmos1 l=180n w=1u m=1
	mp001 (out net158 vdda vdda) pmos1 l=2.8e-07n w=1.5e-06u m=1
	mpd12 (net13 inp net31 net31) pmos1 l=180n w=1u m=1
	mpb01 (net158 net158 vdda vdda) pmos1 l=180n w=1u m=1
ends OPAMP1_variant935

subckt OPAMP1_variant936 inn inp out pd xpd vdda vssa
	xd1 (vssa vdda) prim_nwd AREA=6.13907e-9 PJ=476.6e-6 m=1
	xi0 (vssa net69) prim_nd AREA=1e-12 PJ=4e-6 m=1
	xi3 (net51 vdda) prim_pd AREA=790e-15 PJ=3.3e-6 m=1
	xr0 (vssa vdda net51) prim_rdiffp l=1.5e-07 w=1.1e-06 m=1
	xr1 (vdda vdda net69) prim_rdiffp l=2.1e-6 w=700e-9 m=1
	xcc01 (net12 out) prim_cpoly c=1p m=1
	mnm12 (net13 net56 vssa vssa) nmos1 l=2.6e-07n w=1.5e-06u m=1
	mnm11 (net56 net56 vssa vssa) nmos1 l=2.5e-07n w=1.1e-06u m=1
	mnb02 (net27 net27 net21 vssa) nmos1 l=180n w=1u m=1
	mnpd1 (net21 xpd vssa vssa) nmos1 l=2.1e-07n w=1.7e-06u m=1
	mn001 (out net13 vssa vssa) nmos1 l=180n w=1u m=1
	mnpd2 (net13 pd vssa vssa) nmos1 l=3.0e-07n w=1.7e-06u m=1
	mnc01 (net13 net69 net12 vssa) nmos1 l=180n w=1u m=1
	mpb02 (net27 net51 net158 vdda) pmos1 l=180n w=1u m=1
	mppd1 (net158 xpd vdda vdda) pmos1 l=180n w=1u m=1
	mps11 (net31 net158 vdda vdda) pmos1 l=180n w=1u m=1
	mpd11 (net56 inn net31 net31) pmos1 l=180n w=1u m=1
	mp001 (out net158 vdda vdda) pmos1 l=180n w=1u m=1
	mpd12 (net13 inp net31 net31) pmos1 l=180n w=1u m=1
	mpb01 (net158 net158 vdda vdda) pmos1 l=180n w=1u m=1
ends OPAMP1_variant936

subckt OPAMP1_variant937 inn inp out pd xpd vdda vssa
	xd1 (vssa vdda) prim_nwd AREA=6.13907e-9 PJ=476.6e-6 m=1
	xi0 (vssa net69) prim_nd AREA=1e-12 PJ=4e-6 m=1
	xi3 (net51 vdda) prim_pd AREA=4.8e-09 PJ=7.6e-05 m=1
	xr0 (vssa vdda net51) prim_rdiffp l=2.3e-07 w=2.0e-06 m=1
	xr1 (vdda vdda net69) prim_rdiffp l=2.1e-6 w=700e-9 m=1
	xcc01 (net12 out) prim_cpoly c=1p m=1
	mnm12 (net13 net56 vssa vssa) nmos1 l=180n w=1u m=1
	mnm11 (net56 net56 vssa vssa) nmos1 l=180n w=1u m=1
	mnb02 (net27 net27 net21 vssa) nmos1 l=180n w=1u m=1
	mnpd1 (net21 xpd vssa vssa) nmos1 l=180n w=1u m=1
	mn001 (out net13 vssa vssa) nmos1 l=180n w=1u m=1
	mnpd2 (net13 pd vssa vssa) nmos1 l=180n w=1u m=1
	mnc01 (net13 net69 net12 vssa) nmos1 l=180n w=1u m=1
	mpb02 (net27 net51 net158 vdda) pmos1 l=180n w=1u m=1
	mppd1 (net158 xpd vdda vdda) pmos1 l=180n w=1u m=1
	mps11 (net31 net158 vdda vdda) pmos1 l=180n w=1u m=1
	mpd11 (net56 inn net31 net31) pmos1 l=2.2e-07n w=1.5e-06u m=1
	mp001 (out net158 vdda vdda) pmos1 l=180n w=1u m=1
	mpd12 (net13 inp net31 net31) pmos1 l=180n w=1u m=1
	mpb01 (net158 net158 vdda vdda) pmos1 l=180n w=1u m=1
ends OPAMP1_variant937

subckt OPAMP1_variant938 inn inp out pd xpd vdda vssa
	xd1 (vssa vdda) prim_nwd AREA=6.13907e-9 PJ=476.6e-6 m=1
	xi0 (vssa net69) prim_nd AREA=1e-12 PJ=4e-6 m=1
	xi3 (net51 vdda) prim_pd AREA=3.5e-09 PJ=8.3e-05 m=1
	xr0 (vssa vdda net51) prim_rdiffp l=2.1e-6 w=700e-9 m=1
	xr1 (vdda vdda net69) prim_rdiffp l=2.1e-6 w=700e-9 m=1
	xcc01 (net12 out) prim_cpoly c=1p m=1
	mnm12 (net13 net56 vssa vssa) nmos1 l=180n w=1u m=1
	mnm11 (net56 net56 vssa vssa) nmos1 l=180n w=1u m=1
	mnb02 (net27 net27 net21 vssa) nmos1 l=180n w=1u m=1
	mnpd1 (net21 xpd vssa vssa) nmos1 l=180n w=1u m=1
	mn001 (out net13 vssa vssa) nmos1 l=180n w=1u m=1
	mnpd2 (net13 pd vssa vssa) nmos1 l=180n w=1u m=1
	mnc01 (net13 net69 net12 vssa) nmos1 l=180n w=1u m=1
	mpb02 (net27 net51 net158 vdda) pmos1 l=180n w=1u m=1
	mppd1 (net158 xpd vdda vdda) pmos1 l=180n w=1u m=1
	mps11 (net31 net158 vdda vdda) pmos1 l=1.6e-07n w=9.9e-07u m=1
	mpd11 (net56 inn net31 net31) pmos1 l=180n w=1u m=1
	mp001 (out net158 vdda vdda) pmos1 l=180n w=1u m=1
	mpd12 (net13 inp net31 net31) pmos1 l=2.3e-07n w=1.7e-06u m=1
	mpb01 (net158 net158 vdda vdda) pmos1 l=180n w=1u m=1
ends OPAMP1_variant938

subckt OPAMP1_variant939 inn inp out pd xpd vdda vssa
	xd1 (vssa vdda) prim_nwd AREA=6.13907e-9 PJ=476.6e-6 m=1
	xi0 (vssa net69) prim_nd AREA=1e-12 PJ=4e-6 m=1
	xi3 (net51 vdda) prim_pd AREA=790e-15 PJ=3.3e-6 m=1
	xr0 (vssa vdda net51) prim_rdiffp l=2.1e-6 w=700e-9 m=1
	xr1 (vdda vdda net69) prim_rdiffp l=2.1e-6 w=700e-9 m=1
	xcc01 (net12 out) prim_cpoly c=1p m=1
	mnm12 (net13 net56 vssa vssa) nmos1 l=180n w=1u m=1
	mnm11 (net56 net56 vssa vssa) nmos1 l=180n w=1u m=1
	mnb02 (net27 net27 net21 vssa) nmos1 l=1.1e-07n w=7.3e-07u m=1
	mnpd1 (net21 xpd vssa vssa) nmos1 l=180n w=1u m=1
	mn001 (out net13 vssa vssa) nmos1 l=2.7e-07n w=1.3e-06u m=1
	mnpd2 (net13 pd vssa vssa) nmos1 l=1.2e-07n w=1.2e-06u m=1
	mnc01 (net13 net69 net12 vssa) nmos1 l=180n w=1u m=1
	mpb02 (net27 net51 net158 vdda) pmos1 l=180n w=1u m=1
	mppd1 (net158 xpd vdda vdda) pmos1 l=180n w=1u m=1
	mps11 (net31 net158 vdda vdda) pmos1 l=1.9e-07n w=1.7e-06u m=1
	mpd11 (net56 inn net31 net31) pmos1 l=180n w=1u m=1
	mp001 (out net158 vdda vdda) pmos1 l=2.9e-07n w=1.1e-06u m=1
	mpd12 (net13 inp net31 net31) pmos1 l=180n w=1u m=1
	mpb01 (net158 net158 vdda vdda) pmos1 l=180n w=1u m=1
ends OPAMP1_variant939

subckt OPAMP1_variant940 inn inp out pd xpd vdda vssa
	xd1 (vssa vdda) prim_nwd AREA=6.13907e-9 PJ=476.6e-6 m=1
	xi0 (vssa net69) prim_nd AREA=1e-12 PJ=4e-6 m=1
	xi3 (net51 vdda) prim_pd AREA=8.5e-10 PJ=1.5e-05 m=1
	xr0 (vssa vdda net51) prim_rdiffp l=2.1e-6 w=700e-9 m=1
	xr1 (vdda vdda net69) prim_rdiffp l=2.1e-6 w=700e-9 m=1
	xcc01 (net12 out) prim_cpoly c=1p m=1
	mnm12 (net13 net56 vssa vssa) nmos1 l=2.5e-07n w=1.7e-06u m=1
	mnm11 (net56 net56 vssa vssa) nmos1 l=180n w=1u m=1
	mnb02 (net27 net27 net21 vssa) nmos1 l=180n w=1u m=1
	mnpd1 (net21 xpd vssa vssa) nmos1 l=2.9e-07n w=1.0e-06u m=1
	mn001 (out net13 vssa vssa) nmos1 l=180n w=1u m=1
	mnpd2 (net13 pd vssa vssa) nmos1 l=180n w=1u m=1
	mnc01 (net13 net69 net12 vssa) nmos1 l=180n w=1u m=1
	mpb02 (net27 net51 net158 vdda) pmos1 l=2.1e-07n w=1.5e-06u m=1
	mppd1 (net158 xpd vdda vdda) pmos1 l=180n w=1u m=1
	mps11 (net31 net158 vdda vdda) pmos1 l=180n w=1u m=1
	mpd11 (net56 inn net31 net31) pmos1 l=180n w=1u m=1
	mp001 (out net158 vdda vdda) pmos1 l=180n w=1u m=1
	mpd12 (net13 inp net31 net31) pmos1 l=180n w=1u m=1
	mpb01 (net158 net158 vdda vdda) pmos1 l=2.7e-07n w=7.6e-07u m=1
ends OPAMP1_variant940

subckt OPAMP1_variant941 inn inp out pd xpd vdda vssa
	xd1 (vssa vdda) prim_nwd AREA=6.13907e-9 PJ=476.6e-6 m=1
	xi0 (vssa net69) prim_nd AREA=1e-12 PJ=4e-6 m=1
	xi3 (net51 vdda) prim_pd AREA=790e-15 PJ=3.3e-6 m=1
	xr0 (vssa vdda net51) prim_rdiffp l=2.1e-6 w=700e-9 m=1
	xr1 (vdda vdda net69) prim_rdiffp l=1.7e-07 w=6.3e-07 m=1
	xcc01 (net12 out) prim_cpoly c=8.5e-13p m=1
	mnm12 (net13 net56 vssa vssa) nmos1 l=180n w=1u m=1
	mnm11 (net56 net56 vssa vssa) nmos1 l=180n w=1u m=1
	mnb02 (net27 net27 net21 vssa) nmos1 l=180n w=1u m=1
	mnpd1 (net21 xpd vssa vssa) nmos1 l=180n w=1u m=1
	mn001 (out net13 vssa vssa) nmos1 l=1.7e-07n w=1.0e-06u m=1
	mnpd2 (net13 pd vssa vssa) nmos1 l=2.4e-07n w=1.4e-06u m=1
	mnc01 (net13 net69 net12 vssa) nmos1 l=180n w=1u m=1
	mpb02 (net27 net51 net158 vdda) pmos1 l=180n w=1u m=1
	mppd1 (net158 xpd vdda vdda) pmos1 l=180n w=1u m=1
	mps11 (net31 net158 vdda vdda) pmos1 l=180n w=1u m=1
	mpd11 (net56 inn net31 net31) pmos1 l=180n w=1u m=1
	mp001 (out net158 vdda vdda) pmos1 l=180n w=1u m=1
	mpd12 (net13 inp net31 net31) pmos1 l=180n w=1u m=1
	mpb01 (net158 net158 vdda vdda) pmos1 l=180n w=1u m=1
ends OPAMP1_variant941

subckt OPAMP1_variant942 inn inp out pd xpd vdda vssa
	xd1 (vssa vdda) prim_nwd AREA=6.13907e-9 PJ=476.6e-6 m=1
	xi0 (vssa net69) prim_nd AREA=1e-12 PJ=4e-6 m=1
	xi3 (net51 vdda) prim_pd AREA=790e-15 PJ=3.3e-6 m=1
	xr0 (vssa vdda net51) prim_rdiffp l=2.1e-07 w=1.7e-06 m=1
	xr1 (vdda vdda net69) prim_rdiffp l=2.1e-6 w=700e-9 m=1
	xcc01 (net12 out) prim_cpoly c=1p m=1
	mnm12 (net13 net56 vssa vssa) nmos1 l=180n w=1u m=1
	mnm11 (net56 net56 vssa vssa) nmos1 l=180n w=1u m=1
	mnb02 (net27 net27 net21 vssa) nmos1 l=180n w=1u m=1
	mnpd1 (net21 xpd vssa vssa) nmos1 l=1.4e-07n w=1.6e-06u m=1
	mn001 (out net13 vssa vssa) nmos1 l=180n w=1u m=1
	mnpd2 (net13 pd vssa vssa) nmos1 l=2.7e-07n w=1.3e-06u m=1
	mnc01 (net13 net69 net12 vssa) nmos1 l=180n w=1u m=1
	mpb02 (net27 net51 net158 vdda) pmos1 l=180n w=1u m=1
	mppd1 (net158 xpd vdda vdda) pmos1 l=1.4e-07n w=2.0e-06u m=1
	mps11 (net31 net158 vdda vdda) pmos1 l=2.6e-07n w=1.3e-06u m=1
	mpd11 (net56 inn net31 net31) pmos1 l=180n w=1u m=1
	mp001 (out net158 vdda vdda) pmos1 l=180n w=1u m=1
	mpd12 (net13 inp net31 net31) pmos1 l=180n w=1u m=1
	mpb01 (net158 net158 vdda vdda) pmos1 l=180n w=1u m=1
ends OPAMP1_variant942

subckt OPAMP1_variant943 inn inp out pd xpd vdda vssa
	xd1 (vssa vdda) prim_nwd AREA=6.13907e-9 PJ=476.6e-6 m=1
	xi0 (vssa net69) prim_nd AREA=1e-12 PJ=4e-6 m=1
	xi3 (net51 vdda) prim_pd AREA=8.1e-09 PJ=5.5e-06 m=1
	xr0 (vssa vdda net51) prim_rdiffp l=2.1e-6 w=700e-9 m=1
	xr1 (vdda vdda net69) prim_rdiffp l=2.1e-6 w=700e-9 m=1
	xcc01 (net12 out) prim_cpoly c=1p m=1
	mnm12 (net13 net56 vssa vssa) nmos1 l=180n w=1u m=1
	mnm11 (net56 net56 vssa vssa) nmos1 l=180n w=1u m=1
	mnb02 (net27 net27 net21 vssa) nmos1 l=180n w=1u m=1
	mnpd1 (net21 xpd vssa vssa) nmos1 l=1.9e-07n w=1.1e-06u m=1
	mn001 (out net13 vssa vssa) nmos1 l=2.5e-07n w=1.2e-06u m=1
	mnpd2 (net13 pd vssa vssa) nmos1 l=180n w=1u m=1
	mnc01 (net13 net69 net12 vssa) nmos1 l=180n w=1u m=1
	mpb02 (net27 net51 net158 vdda) pmos1 l=180n w=1u m=1
	mppd1 (net158 xpd vdda vdda) pmos1 l=180n w=1u m=1
	mps11 (net31 net158 vdda vdda) pmos1 l=180n w=1u m=1
	mpd11 (net56 inn net31 net31) pmos1 l=180n w=1u m=1
	mp001 (out net158 vdda vdda) pmos1 l=180n w=1u m=1
	mpd12 (net13 inp net31 net31) pmos1 l=180n w=1u m=1
	mpb01 (net158 net158 vdda vdda) pmos1 l=180n w=1u m=1
ends OPAMP1_variant943

subckt OPAMP1_variant944 inn inp out pd xpd vdda vssa
	xd1 (vssa vdda) prim_nwd AREA=9.3e-09 PJ=9.7e-05 m=1
	xi0 (vssa net69) prim_nd AREA=1e-12 PJ=4e-6 m=1
	xi3 (net51 vdda) prim_pd AREA=1.5e-10 PJ=1.0e-04 m=1
	xr0 (vssa vdda net51) prim_rdiffp l=2.1e-6 w=700e-9 m=1
	xr1 (vdda vdda net69) prim_rdiffp l=2.1e-6 w=700e-9 m=1
	xcc01 (net12 out) prim_cpoly c=1p m=1
	mnm12 (net13 net56 vssa vssa) nmos1 l=180n w=1u m=1
	mnm11 (net56 net56 vssa vssa) nmos1 l=180n w=1u m=1
	mnb02 (net27 net27 net21 vssa) nmos1 l=180n w=1u m=1
	mnpd1 (net21 xpd vssa vssa) nmos1 l=180n w=1u m=1
	mn001 (out net13 vssa vssa) nmos1 l=180n w=1u m=1
	mnpd2 (net13 pd vssa vssa) nmos1 l=180n w=1u m=1
	mnc01 (net13 net69 net12 vssa) nmos1 l=180n w=1u m=1
	mpb02 (net27 net51 net158 vdda) pmos1 l=180n w=1u m=1
	mppd1 (net158 xpd vdda vdda) pmos1 l=180n w=1u m=1
	mps11 (net31 net158 vdda vdda) pmos1 l=180n w=1u m=1
	mpd11 (net56 inn net31 net31) pmos1 l=2.0e-07n w=1.4e-06u m=1
	mp001 (out net158 vdda vdda) pmos1 l=2.8e-07n w=1.7e-06u m=1
	mpd12 (net13 inp net31 net31) pmos1 l=180n w=1u m=1
	mpb01 (net158 net158 vdda vdda) pmos1 l=2.5e-07n w=1.3e-06u m=1
ends OPAMP1_variant944

subckt OPAMP1_variant945 inn inp out pd xpd vdda vssa
	xd1 (vssa vdda) prim_nwd AREA=6.13907e-9 PJ=476.6e-6 m=1
	xi0 (vssa net69) prim_nd AREA=1e-12 PJ=4e-6 m=1
	xi3 (net51 vdda) prim_pd AREA=790e-15 PJ=3.3e-6 m=1
	xr0 (vssa vdda net51) prim_rdiffp l=2.1e-6 w=700e-9 m=1
	xr1 (vdda vdda net69) prim_rdiffp l=1.2e-07 w=1.0e-06 m=1
	xcc01 (net12 out) prim_cpoly c=1p m=1
	mnm12 (net13 net56 vssa vssa) nmos1 l=180n w=1u m=1
	mnm11 (net56 net56 vssa vssa) nmos1 l=180n w=1u m=1
	mnb02 (net27 net27 net21 vssa) nmos1 l=1.0e-07n w=9.0e-07u m=1
	mnpd1 (net21 xpd vssa vssa) nmos1 l=1.2e-07n w=7.9e-07u m=1
	mn001 (out net13 vssa vssa) nmos1 l=180n w=1u m=1
	mnpd2 (net13 pd vssa vssa) nmos1 l=180n w=1u m=1
	mnc01 (net13 net69 net12 vssa) nmos1 l=180n w=1u m=1
	mpb02 (net27 net51 net158 vdda) pmos1 l=180n w=1u m=1
	mppd1 (net158 xpd vdda vdda) pmos1 l=2.8e-07n w=1.1e-06u m=1
	mps11 (net31 net158 vdda vdda) pmos1 l=180n w=1u m=1
	mpd11 (net56 inn net31 net31) pmos1 l=180n w=1u m=1
	mp001 (out net158 vdda vdda) pmos1 l=180n w=1u m=1
	mpd12 (net13 inp net31 net31) pmos1 l=180n w=1u m=1
	mpb01 (net158 net158 vdda vdda) pmos1 l=180n w=1u m=1
ends OPAMP1_variant945

subckt OPAMP1_variant946 inn inp out pd xpd vdda vssa
	xd1 (vssa vdda) prim_nwd AREA=6.13907e-9 PJ=476.6e-6 m=1
	xi0 (vssa net69) prim_nd AREA=1e-12 PJ=4e-6 m=1
	xi3 (net51 vdda) prim_pd AREA=790e-15 PJ=3.3e-6 m=1
	xr0 (vssa vdda net51) prim_rdiffp l=2.1e-6 w=700e-9 m=1
	xr1 (vdda vdda net69) prim_rdiffp l=1.6e-07 w=1.7e-06 m=1
	xcc01 (net12 out) prim_cpoly c=1p m=1
	mnm12 (net13 net56 vssa vssa) nmos1 l=180n w=1u m=1
	mnm11 (net56 net56 vssa vssa) nmos1 l=1.1e-07n w=7.8e-07u m=1
	mnb02 (net27 net27 net21 vssa) nmos1 l=180n w=1u m=1
	mnpd1 (net21 xpd vssa vssa) nmos1 l=180n w=1u m=1
	mn001 (out net13 vssa vssa) nmos1 l=180n w=1u m=1
	mnpd2 (net13 pd vssa vssa) nmos1 l=180n w=1u m=1
	mnc01 (net13 net69 net12 vssa) nmos1 l=180n w=1u m=1
	mpb02 (net27 net51 net158 vdda) pmos1 l=180n w=1u m=1
	mppd1 (net158 xpd vdda vdda) pmos1 l=180n w=1u m=1
	mps11 (net31 net158 vdda vdda) pmos1 l=2.8e-07n w=1.2e-06u m=1
	mpd11 (net56 inn net31 net31) pmos1 l=180n w=1u m=1
	mp001 (out net158 vdda vdda) pmos1 l=180n w=1u m=1
	mpd12 (net13 inp net31 net31) pmos1 l=180n w=1u m=1
	mpb01 (net158 net158 vdda vdda) pmos1 l=180n w=1u m=1
ends OPAMP1_variant946

subckt OPAMP1_variant947 inn inp out pd xpd vdda vssa
	xd1 (vssa vdda) prim_nwd AREA=6.13907e-9 PJ=476.6e-6 m=1
	xi0 (vssa net69) prim_nd AREA=3.0e-09 PJ=1.9e-05 m=1
	xi3 (net51 vdda) prim_pd AREA=790e-15 PJ=3.3e-6 m=1
	xr0 (vssa vdda net51) prim_rdiffp l=1.7e-07 w=6.0e-07 m=1
	xr1 (vdda vdda net69) prim_rdiffp l=2.1e-6 w=700e-9 m=1
	xcc01 (net12 out) prim_cpoly c=1p m=1
	mnm12 (net13 net56 vssa vssa) nmos1 l=180n w=1u m=1
	mnm11 (net56 net56 vssa vssa) nmos1 l=180n w=1u m=1
	mnb02 (net27 net27 net21 vssa) nmos1 l=180n w=1u m=1
	mnpd1 (net21 xpd vssa vssa) nmos1 l=180n w=1u m=1
	mn001 (out net13 vssa vssa) nmos1 l=180n w=1u m=1
	mnpd2 (net13 pd vssa vssa) nmos1 l=180n w=1u m=1
	mnc01 (net13 net69 net12 vssa) nmos1 l=2.4e-07n w=1.2e-06u m=1
	mpb02 (net27 net51 net158 vdda) pmos1 l=180n w=1u m=1
	mppd1 (net158 xpd vdda vdda) pmos1 l=180n w=1u m=1
	mps11 (net31 net158 vdda vdda) pmos1 l=2.5e-07n w=1.6e-06u m=1
	mpd11 (net56 inn net31 net31) pmos1 l=180n w=1u m=1
	mp001 (out net158 vdda vdda) pmos1 l=180n w=1u m=1
	mpd12 (net13 inp net31 net31) pmos1 l=180n w=1u m=1
	mpb01 (net158 net158 vdda vdda) pmos1 l=180n w=1u m=1
ends OPAMP1_variant947

subckt OPAMP1_variant948 inn inp out pd xpd vdda vssa
	xd1 (vssa vdda) prim_nwd AREA=6.13907e-9 PJ=476.6e-6 m=1
	xi0 (vssa net69) prim_nd AREA=1e-12 PJ=4e-6 m=1
	xi3 (net51 vdda) prim_pd AREA=790e-15 PJ=3.3e-6 m=1
	xr0 (vssa vdda net51) prim_rdiffp l=2.1e-6 w=700e-9 m=1
	xr1 (vdda vdda net69) prim_rdiffp l=2.1e-6 w=700e-9 m=1
	xcc01 (net12 out) prim_cpoly c=1p m=1
	mnm12 (net13 net56 vssa vssa) nmos1 l=2.3e-07n w=1.1e-06u m=1
	mnm11 (net56 net56 vssa vssa) nmos1 l=180n w=1u m=1
	mnb02 (net27 net27 net21 vssa) nmos1 l=180n w=1u m=1
	mnpd1 (net21 xpd vssa vssa) nmos1 l=180n w=1u m=1
	mn001 (out net13 vssa vssa) nmos1 l=180n w=1u m=1
	mnpd2 (net13 pd vssa vssa) nmos1 l=1.5e-07n w=1.7e-06u m=1
	mnc01 (net13 net69 net12 vssa) nmos1 l=180n w=1u m=1
	mpb02 (net27 net51 net158 vdda) pmos1 l=180n w=1u m=1
	mppd1 (net158 xpd vdda vdda) pmos1 l=180n w=1u m=1
	mps11 (net31 net158 vdda vdda) pmos1 l=180n w=1u m=1
	mpd11 (net56 inn net31 net31) pmos1 l=180n w=1u m=1
	mp001 (out net158 vdda vdda) pmos1 l=180n w=1u m=1
	mpd12 (net13 inp net31 net31) pmos1 l=180n w=1u m=1
	mpb01 (net158 net158 vdda vdda) pmos1 l=180n w=1u m=1
ends OPAMP1_variant948

subckt OPAMP1_variant949 inn inp out pd xpd vdda vssa
	xd1 (vssa vdda) prim_nwd AREA=6.13907e-9 PJ=476.6e-6 m=1
	xi0 (vssa net69) prim_nd AREA=1e-12 PJ=4e-6 m=1
	xi3 (net51 vdda) prim_pd AREA=790e-15 PJ=3.3e-6 m=1
	xr0 (vssa vdda net51) prim_rdiffp l=2.1e-6 w=700e-9 m=1
	xr1 (vdda vdda net69) prim_rdiffp l=2.1e-6 w=700e-9 m=1
	xcc01 (net12 out) prim_cpoly c=1p m=1
	mnm12 (net13 net56 vssa vssa) nmos1 l=180n w=1u m=1
	mnm11 (net56 net56 vssa vssa) nmos1 l=1.2e-07n w=1.0e-06u m=1
	mnb02 (net27 net27 net21 vssa) nmos1 l=180n w=1u m=1
	mnpd1 (net21 xpd vssa vssa) nmos1 l=180n w=1u m=1
	mn001 (out net13 vssa vssa) nmos1 l=180n w=1u m=1
	mnpd2 (net13 pd vssa vssa) nmos1 l=180n w=1u m=1
	mnc01 (net13 net69 net12 vssa) nmos1 l=180n w=1u m=1
	mpb02 (net27 net51 net158 vdda) pmos1 l=180n w=1u m=1
	mppd1 (net158 xpd vdda vdda) pmos1 l=180n w=1u m=1
	mps11 (net31 net158 vdda vdda) pmos1 l=180n w=1u m=1
	mpd11 (net56 inn net31 net31) pmos1 l=2.1e-07n w=1.8e-06u m=1
	mp001 (out net158 vdda vdda) pmos1 l=180n w=1u m=1
	mpd12 (net13 inp net31 net31) pmos1 l=180n w=1u m=1
	mpb01 (net158 net158 vdda vdda) pmos1 l=180n w=1u m=1
ends OPAMP1_variant949

subckt OPAMP1_variant950 inn inp out pd xpd vdda vssa
	xd1 (vssa vdda) prim_nwd AREA=6.13907e-9 PJ=476.6e-6 m=1
	xi0 (vssa net69) prim_nd AREA=1e-12 PJ=4e-6 m=1
	xi3 (net51 vdda) prim_pd AREA=4.0e-09 PJ=7.3e-06 m=1
	xr0 (vssa vdda net51) prim_rdiffp l=2.1e-6 w=700e-9 m=1
	xr1 (vdda vdda net69) prim_rdiffp l=2.1e-6 w=700e-9 m=1
	xcc01 (net12 out) prim_cpoly c=1p m=1
	mnm12 (net13 net56 vssa vssa) nmos1 l=180n w=1u m=1
	mnm11 (net56 net56 vssa vssa) nmos1 l=180n w=1u m=1
	mnb02 (net27 net27 net21 vssa) nmos1 l=1.4e-07n w=1.7e-06u m=1
	mnpd1 (net21 xpd vssa vssa) nmos1 l=180n w=1u m=1
	mn001 (out net13 vssa vssa) nmos1 l=180n w=1u m=1
	mnpd2 (net13 pd vssa vssa) nmos1 l=180n w=1u m=1
	mnc01 (net13 net69 net12 vssa) nmos1 l=180n w=1u m=1
	mpb02 (net27 net51 net158 vdda) pmos1 l=180n w=1u m=1
	mppd1 (net158 xpd vdda vdda) pmos1 l=180n w=1u m=1
	mps11 (net31 net158 vdda vdda) pmos1 l=180n w=1u m=1
	mpd11 (net56 inn net31 net31) pmos1 l=1.8e-07n w=1.8e-06u m=1
	mp001 (out net158 vdda vdda) pmos1 l=180n w=1u m=1
	mpd12 (net13 inp net31 net31) pmos1 l=180n w=1u m=1
	mpb01 (net158 net158 vdda vdda) pmos1 l=180n w=1u m=1
ends OPAMP1_variant950

subckt OPAMP1_variant951 inn inp out pd xpd vdda vssa
	xd1 (vssa vdda) prim_nwd AREA=4.3e-09 PJ=8.0e-05 m=1
	xi0 (vssa net69) prim_nd AREA=1e-12 PJ=4e-6 m=1
	xi3 (net51 vdda) prim_pd AREA=4.4e-09 PJ=1.0e-05 m=1
	xr0 (vssa vdda net51) prim_rdiffp l=2.1e-6 w=700e-9 m=1
	xr1 (vdda vdda net69) prim_rdiffp l=2.1e-6 w=700e-9 m=1
	xcc01 (net12 out) prim_cpoly c=1p m=1
	mnm12 (net13 net56 vssa vssa) nmos1 l=180n w=1u m=1
	mnm11 (net56 net56 vssa vssa) nmos1 l=180n w=1u m=1
	mnb02 (net27 net27 net21 vssa) nmos1 l=180n w=1u m=1
	mnpd1 (net21 xpd vssa vssa) nmos1 l=180n w=1u m=1
	mn001 (out net13 vssa vssa) nmos1 l=180n w=1u m=1
	mnpd2 (net13 pd vssa vssa) nmos1 l=180n w=1u m=1
	mnc01 (net13 net69 net12 vssa) nmos1 l=1.9e-07n w=1.9e-06u m=1
	mpb02 (net27 net51 net158 vdda) pmos1 l=180n w=1u m=1
	mppd1 (net158 xpd vdda vdda) pmos1 l=180n w=1u m=1
	mps11 (net31 net158 vdda vdda) pmos1 l=180n w=1u m=1
	mpd11 (net56 inn net31 net31) pmos1 l=180n w=1u m=1
	mp001 (out net158 vdda vdda) pmos1 l=180n w=1u m=1
	mpd12 (net13 inp net31 net31) pmos1 l=180n w=1u m=1
	mpb01 (net158 net158 vdda vdda) pmos1 l=180n w=1u m=1
ends OPAMP1_variant951

subckt OPAMP1_variant952 inn inp out pd xpd vdda vssa
	xd1 (vssa vdda) prim_nwd AREA=6.13907e-9 PJ=476.6e-6 m=1
	xi0 (vssa net69) prim_nd AREA=1e-12 PJ=4e-6 m=1
	xi3 (net51 vdda) prim_pd AREA=790e-15 PJ=3.3e-6 m=1
	xr0 (vssa vdda net51) prim_rdiffp l=2.1e-6 w=700e-9 m=1
	xr1 (vdda vdda net69) prim_rdiffp l=2.1e-6 w=700e-9 m=1
	xcc01 (net12 out) prim_cpoly c=1p m=1
	mnm12 (net13 net56 vssa vssa) nmos1 l=180n w=1u m=1
	mnm11 (net56 net56 vssa vssa) nmos1 l=180n w=1u m=1
	mnb02 (net27 net27 net21 vssa) nmos1 l=1.4e-07n w=1.0e-06u m=1
	mnpd1 (net21 xpd vssa vssa) nmos1 l=180n w=1u m=1
	mn001 (out net13 vssa vssa) nmos1 l=180n w=1u m=1
	mnpd2 (net13 pd vssa vssa) nmos1 l=1.7e-07n w=9.7e-07u m=1
	mnc01 (net13 net69 net12 vssa) nmos1 l=180n w=1u m=1
	mpb02 (net27 net51 net158 vdda) pmos1 l=180n w=1u m=1
	mppd1 (net158 xpd vdda vdda) pmos1 l=180n w=1u m=1
	mps11 (net31 net158 vdda vdda) pmos1 l=180n w=1u m=1
	mpd11 (net56 inn net31 net31) pmos1 l=180n w=1u m=1
	mp001 (out net158 vdda vdda) pmos1 l=180n w=1u m=1
	mpd12 (net13 inp net31 net31) pmos1 l=180n w=1u m=1
	mpb01 (net158 net158 vdda vdda) pmos1 l=180n w=1u m=1
ends OPAMP1_variant952

subckt OPAMP1_variant953 inn inp out pd xpd vdda vssa
	xd1 (vssa vdda) prim_nwd AREA=6.13907e-9 PJ=476.6e-6 m=1
	xi0 (vssa net69) prim_nd AREA=1e-12 PJ=4e-6 m=1
	xi3 (net51 vdda) prim_pd AREA=790e-15 PJ=3.3e-6 m=1
	xr0 (vssa vdda net51) prim_rdiffp l=2.1e-6 w=700e-9 m=1
	xr1 (vdda vdda net69) prim_rdiffp l=2.1e-6 w=700e-9 m=1
	xcc01 (net12 out) prim_cpoly c=1p m=1
	mnm12 (net13 net56 vssa vssa) nmos1 l=180n w=1u m=1
	mnm11 (net56 net56 vssa vssa) nmos1 l=180n w=1u m=1
	mnb02 (net27 net27 net21 vssa) nmos1 l=180n w=1u m=1
	mnpd1 (net21 xpd vssa vssa) nmos1 l=180n w=1u m=1
	mn001 (out net13 vssa vssa) nmos1 l=180n w=1u m=1
	mnpd2 (net13 pd vssa vssa) nmos1 l=1.1e-07n w=1.5e-06u m=1
	mnc01 (net13 net69 net12 vssa) nmos1 l=180n w=1u m=1
	mpb02 (net27 net51 net158 vdda) pmos1 l=180n w=1u m=1
	mppd1 (net158 xpd vdda vdda) pmos1 l=180n w=1u m=1
	mps11 (net31 net158 vdda vdda) pmos1 l=1.2e-07n w=1.3e-06u m=1
	mpd11 (net56 inn net31 net31) pmos1 l=180n w=1u m=1
	mp001 (out net158 vdda vdda) pmos1 l=180n w=1u m=1
	mpd12 (net13 inp net31 net31) pmos1 l=180n w=1u m=1
	mpb01 (net158 net158 vdda vdda) pmos1 l=180n w=1u m=1
ends OPAMP1_variant953

subckt OPAMP1_variant954 inn inp out pd xpd vdda vssa
	xd1 (vssa vdda) prim_nwd AREA=2.8e-09 PJ=1.5e-05 m=1
	xi0 (vssa net69) prim_nd AREA=1e-12 PJ=4e-6 m=1
	xi3 (net51 vdda) prim_pd AREA=790e-15 PJ=3.3e-6 m=1
	xr0 (vssa vdda net51) prim_rdiffp l=2.1e-6 w=700e-9 m=1
	xr1 (vdda vdda net69) prim_rdiffp l=2.1e-6 w=700e-9 m=1
	xcc01 (net12 out) prim_cpoly c=1p m=1
	mnm12 (net13 net56 vssa vssa) nmos1 l=180n w=1u m=1
	mnm11 (net56 net56 vssa vssa) nmos1 l=180n w=1u m=1
	mnb02 (net27 net27 net21 vssa) nmos1 l=180n w=1u m=1
	mnpd1 (net21 xpd vssa vssa) nmos1 l=180n w=1u m=1
	mn001 (out net13 vssa vssa) nmos1 l=180n w=1u m=1
	mnpd2 (net13 pd vssa vssa) nmos1 l=180n w=1u m=1
	mnc01 (net13 net69 net12 vssa) nmos1 l=180n w=1u m=1
	mpb02 (net27 net51 net158 vdda) pmos1 l=180n w=1u m=1
	mppd1 (net158 xpd vdda vdda) pmos1 l=180n w=1u m=1
	mps11 (net31 net158 vdda vdda) pmos1 l=180n w=1u m=1
	mpd11 (net56 inn net31 net31) pmos1 l=1.7e-07n w=1.8e-06u m=1
	mp001 (out net158 vdda vdda) pmos1 l=180n w=1u m=1
	mpd12 (net13 inp net31 net31) pmos1 l=180n w=1u m=1
	mpb01 (net158 net158 vdda vdda) pmos1 l=180n w=1u m=1
ends OPAMP1_variant954

subckt OPAMP1_variant955 inn inp out pd xpd vdda vssa
	xd1 (vssa vdda) prim_nwd AREA=6.13907e-9 PJ=476.6e-6 m=1
	xi0 (vssa net69) prim_nd AREA=1e-12 PJ=4e-6 m=1
	xi3 (net51 vdda) prim_pd AREA=790e-15 PJ=3.3e-6 m=1
	xr0 (vssa vdda net51) prim_rdiffp l=2.1e-6 w=700e-9 m=1
	xr1 (vdda vdda net69) prim_rdiffp l=2.1e-6 w=700e-9 m=1
	xcc01 (net12 out) prim_cpoly c=1p m=1
	mnm12 (net13 net56 vssa vssa) nmos1 l=180n w=1u m=1
	mnm11 (net56 net56 vssa vssa) nmos1 l=180n w=1u m=1
	mnb02 (net27 net27 net21 vssa) nmos1 l=180n w=1u m=1
	mnpd1 (net21 xpd vssa vssa) nmos1 l=1.9e-07n w=1.9e-06u m=1
	mn001 (out net13 vssa vssa) nmos1 l=180n w=1u m=1
	mnpd2 (net13 pd vssa vssa) nmos1 l=180n w=1u m=1
	mnc01 (net13 net69 net12 vssa) nmos1 l=180n w=1u m=1
	mpb02 (net27 net51 net158 vdda) pmos1 l=180n w=1u m=1
	mppd1 (net158 xpd vdda vdda) pmos1 l=1.2e-07n w=6.9e-07u m=1
	mps11 (net31 net158 vdda vdda) pmos1 l=2.2e-07n w=1.6e-06u m=1
	mpd11 (net56 inn net31 net31) pmos1 l=180n w=1u m=1
	mp001 (out net158 vdda vdda) pmos1 l=180n w=1u m=1
	mpd12 (net13 inp net31 net31) pmos1 l=180n w=1u m=1
	mpb01 (net158 net158 vdda vdda) pmos1 l=180n w=1u m=1
ends OPAMP1_variant955

subckt OPAMP1_variant956 inn inp out pd xpd vdda vssa
	xd1 (vssa vdda) prim_nwd AREA=1.8e-09 PJ=4.3e-05 m=1
	xi0 (vssa net69) prim_nd AREA=1e-12 PJ=4e-6 m=1
	xi3 (net51 vdda) prim_pd AREA=790e-15 PJ=3.3e-6 m=1
	xr0 (vssa vdda net51) prim_rdiffp l=2.1e-6 w=700e-9 m=1
	xr1 (vdda vdda net69) prim_rdiffp l=2.1e-6 w=700e-9 m=1
	xcc01 (net12 out) prim_cpoly c=1p m=1
	mnm12 (net13 net56 vssa vssa) nmos1 l=180n w=1u m=1
	mnm11 (net56 net56 vssa vssa) nmos1 l=180n w=1u m=1
	mnb02 (net27 net27 net21 vssa) nmos1 l=180n w=1u m=1
	mnpd1 (net21 xpd vssa vssa) nmos1 l=180n w=1u m=1
	mn001 (out net13 vssa vssa) nmos1 l=180n w=1u m=1
	mnpd2 (net13 pd vssa vssa) nmos1 l=180n w=1u m=1
	mnc01 (net13 net69 net12 vssa) nmos1 l=180n w=1u m=1
	mpb02 (net27 net51 net158 vdda) pmos1 l=180n w=1u m=1
	mppd1 (net158 xpd vdda vdda) pmos1 l=1.2e-07n w=1.7e-06u m=1
	mps11 (net31 net158 vdda vdda) pmos1 l=180n w=1u m=1
	mpd11 (net56 inn net31 net31) pmos1 l=180n w=1u m=1
	mp001 (out net158 vdda vdda) pmos1 l=180n w=1u m=1
	mpd12 (net13 inp net31 net31) pmos1 l=2.8e-07n w=5.7e-07u m=1
	mpb01 (net158 net158 vdda vdda) pmos1 l=180n w=1u m=1
ends OPAMP1_variant956

subckt OPAMP1_variant957 inn inp out pd xpd vdda vssa
	xd1 (vssa vdda) prim_nwd AREA=7.2e-09 PJ=2.8e-05 m=1
	xi0 (vssa net69) prim_nd AREA=7.8e-09 PJ=5.8e-05 m=1
	xi3 (net51 vdda) prim_pd AREA=790e-15 PJ=3.3e-6 m=1
	xr0 (vssa vdda net51) prim_rdiffp l=2.1e-6 w=700e-9 m=1
	xr1 (vdda vdda net69) prim_rdiffp l=2.1e-6 w=700e-9 m=1
	xcc01 (net12 out) prim_cpoly c=1p m=1
	mnm12 (net13 net56 vssa vssa) nmos1 l=180n w=1u m=1
	mnm11 (net56 net56 vssa vssa) nmos1 l=180n w=1u m=1
	mnb02 (net27 net27 net21 vssa) nmos1 l=1.7e-07n w=6.6e-07u m=1
	mnpd1 (net21 xpd vssa vssa) nmos1 l=180n w=1u m=1
	mn001 (out net13 vssa vssa) nmos1 l=180n w=1u m=1
	mnpd2 (net13 pd vssa vssa) nmos1 l=180n w=1u m=1
	mnc01 (net13 net69 net12 vssa) nmos1 l=180n w=1u m=1
	mpb02 (net27 net51 net158 vdda) pmos1 l=180n w=1u m=1
	mppd1 (net158 xpd vdda vdda) pmos1 l=180n w=1u m=1
	mps11 (net31 net158 vdda vdda) pmos1 l=2.6e-07n w=1.2e-06u m=1
	mpd11 (net56 inn net31 net31) pmos1 l=180n w=1u m=1
	mp001 (out net158 vdda vdda) pmos1 l=180n w=1u m=1
	mpd12 (net13 inp net31 net31) pmos1 l=2.7e-07n w=1.5e-06u m=1
	mpb01 (net158 net158 vdda vdda) pmos1 l=180n w=1u m=1
ends OPAMP1_variant957

subckt OPAMP1_variant958 inn inp out pd xpd vdda vssa
	xd1 (vssa vdda) prim_nwd AREA=6.13907e-9 PJ=476.6e-6 m=1
	xi0 (vssa net69) prim_nd AREA=8.7e-09 PJ=1.3e-05 m=1
	xi3 (net51 vdda) prim_pd AREA=4.1e-09 PJ=9.3e-05 m=1
	xr0 (vssa vdda net51) prim_rdiffp l=2.1e-6 w=700e-9 m=1
	xr1 (vdda vdda net69) prim_rdiffp l=2.1e-6 w=700e-9 m=1
	xcc01 (net12 out) prim_cpoly c=1p m=1
	mnm12 (net13 net56 vssa vssa) nmos1 l=180n w=1u m=1
	mnm11 (net56 net56 vssa vssa) nmos1 l=180n w=1u m=1
	mnb02 (net27 net27 net21 vssa) nmos1 l=180n w=1u m=1
	mnpd1 (net21 xpd vssa vssa) nmos1 l=180n w=1u m=1
	mn001 (out net13 vssa vssa) nmos1 l=2.4e-07n w=9.2e-07u m=1
	mnpd2 (net13 pd vssa vssa) nmos1 l=180n w=1u m=1
	mnc01 (net13 net69 net12 vssa) nmos1 l=180n w=1u m=1
	mpb02 (net27 net51 net158 vdda) pmos1 l=180n w=1u m=1
	mppd1 (net158 xpd vdda vdda) pmos1 l=180n w=1u m=1
	mps11 (net31 net158 vdda vdda) pmos1 l=180n w=1u m=1
	mpd11 (net56 inn net31 net31) pmos1 l=180n w=1u m=1
	mp001 (out net158 vdda vdda) pmos1 l=180n w=1u m=1
	mpd12 (net13 inp net31 net31) pmos1 l=2.8e-07n w=2.0e-06u m=1
	mpb01 (net158 net158 vdda vdda) pmos1 l=180n w=1u m=1
ends OPAMP1_variant958

subckt OPAMP1_variant959 inn inp out pd xpd vdda vssa
	xd1 (vssa vdda) prim_nwd AREA=6.13907e-9 PJ=476.6e-6 m=1
	xi0 (vssa net69) prim_nd AREA=1e-12 PJ=4e-6 m=1
	xi3 (net51 vdda) prim_pd AREA=790e-15 PJ=3.3e-6 m=1
	xr0 (vssa vdda net51) prim_rdiffp l=2.1e-6 w=700e-9 m=1
	xr1 (vdda vdda net69) prim_rdiffp l=2.1e-6 w=700e-9 m=1
	xcc01 (net12 out) prim_cpoly c=1p m=1
	mnm12 (net13 net56 vssa vssa) nmos1 l=180n w=1u m=1
	mnm11 (net56 net56 vssa vssa) nmos1 l=180n w=1u m=1
	mnb02 (net27 net27 net21 vssa) nmos1 l=180n w=1u m=1
	mnpd1 (net21 xpd vssa vssa) nmos1 l=180n w=1u m=1
	mn001 (out net13 vssa vssa) nmos1 l=180n w=1u m=1
	mnpd2 (net13 pd vssa vssa) nmos1 l=1.7e-07n w=1.8e-06u m=1
	mnc01 (net13 net69 net12 vssa) nmos1 l=180n w=1u m=1
	mpb02 (net27 net51 net158 vdda) pmos1 l=180n w=1u m=1
	mppd1 (net158 xpd vdda vdda) pmos1 l=1.8e-07n w=1.4e-06u m=1
	mps11 (net31 net158 vdda vdda) pmos1 l=2.8e-07n w=1.3e-06u m=1
	mpd11 (net56 inn net31 net31) pmos1 l=180n w=1u m=1
	mp001 (out net158 vdda vdda) pmos1 l=180n w=1u m=1
	mpd12 (net13 inp net31 net31) pmos1 l=180n w=1u m=1
	mpb01 (net158 net158 vdda vdda) pmos1 l=180n w=1u m=1
ends OPAMP1_variant959

subckt OPAMP1_variant960 inn inp out pd xpd vdda vssa
	xd1 (vssa vdda) prim_nwd AREA=6.13907e-9 PJ=476.6e-6 m=1
	xi0 (vssa net69) prim_nd AREA=6.9e-10 PJ=8.0e-06 m=1
	xi3 (net51 vdda) prim_pd AREA=790e-15 PJ=3.3e-6 m=1
	xr0 (vssa vdda net51) prim_rdiffp l=2.1e-6 w=700e-9 m=1
	xr1 (vdda vdda net69) prim_rdiffp l=2.1e-6 w=700e-9 m=1
	xcc01 (net12 out) prim_cpoly c=1p m=1
	mnm12 (net13 net56 vssa vssa) nmos1 l=180n w=1u m=1
	mnm11 (net56 net56 vssa vssa) nmos1 l=180n w=1u m=1
	mnb02 (net27 net27 net21 vssa) nmos1 l=180n w=1u m=1
	mnpd1 (net21 xpd vssa vssa) nmos1 l=180n w=1u m=1
	mn001 (out net13 vssa vssa) nmos1 l=180n w=1u m=1
	mnpd2 (net13 pd vssa vssa) nmos1 l=180n w=1u m=1
	mnc01 (net13 net69 net12 vssa) nmos1 l=3.0e-07n w=1.9e-06u m=1
	mpb02 (net27 net51 net158 vdda) pmos1 l=180n w=1u m=1
	mppd1 (net158 xpd vdda vdda) pmos1 l=180n w=1u m=1
	mps11 (net31 net158 vdda vdda) pmos1 l=180n w=1u m=1
	mpd11 (net56 inn net31 net31) pmos1 l=180n w=1u m=1
	mp001 (out net158 vdda vdda) pmos1 l=180n w=1u m=1
	mpd12 (net13 inp net31 net31) pmos1 l=180n w=1u m=1
	mpb01 (net158 net158 vdda vdda) pmos1 l=180n w=1u m=1
ends OPAMP1_variant960

subckt OPAMP1_variant961 inn inp out pd xpd vdda vssa
	xd1 (vssa vdda) prim_nwd AREA=6.13907e-9 PJ=476.6e-6 m=1
	xi0 (vssa net69) prim_nd AREA=3.4e-09 PJ=8.2e-05 m=1
	xi3 (net51 vdda) prim_pd AREA=790e-15 PJ=3.3e-6 m=1
	xr0 (vssa vdda net51) prim_rdiffp l=2.1e-6 w=700e-9 m=1
	xr1 (vdda vdda net69) prim_rdiffp l=2.1e-6 w=700e-9 m=1
	xcc01 (net12 out) prim_cpoly c=1p m=1
	mnm12 (net13 net56 vssa vssa) nmos1 l=2.7e-07n w=1.3e-06u m=1
	mnm11 (net56 net56 vssa vssa) nmos1 l=180n w=1u m=1
	mnb02 (net27 net27 net21 vssa) nmos1 l=180n w=1u m=1
	mnpd1 (net21 xpd vssa vssa) nmos1 l=180n w=1u m=1
	mn001 (out net13 vssa vssa) nmos1 l=180n w=1u m=1
	mnpd2 (net13 pd vssa vssa) nmos1 l=180n w=1u m=1
	mnc01 (net13 net69 net12 vssa) nmos1 l=180n w=1u m=1
	mpb02 (net27 net51 net158 vdda) pmos1 l=180n w=1u m=1
	mppd1 (net158 xpd vdda vdda) pmos1 l=180n w=1u m=1
	mps11 (net31 net158 vdda vdda) pmos1 l=180n w=1u m=1
	mpd11 (net56 inn net31 net31) pmos1 l=180n w=1u m=1
	mp001 (out net158 vdda vdda) pmos1 l=180n w=1u m=1
	mpd12 (net13 inp net31 net31) pmos1 l=180n w=1u m=1
	mpb01 (net158 net158 vdda vdda) pmos1 l=180n w=1u m=1
ends OPAMP1_variant961

subckt OPAMP1_variant962 inn inp out pd xpd vdda vssa
	xd1 (vssa vdda) prim_nwd AREA=6.13907e-9 PJ=476.6e-6 m=1
	xi0 (vssa net69) prim_nd AREA=5.9e-09 PJ=4.9e-05 m=1
	xi3 (net51 vdda) prim_pd AREA=9.4e-09 PJ=6.0e-05 m=1
	xr0 (vssa vdda net51) prim_rdiffp l=2.1e-6 w=700e-9 m=1
	xr1 (vdda vdda net69) prim_rdiffp l=2.1e-6 w=700e-9 m=1
	xcc01 (net12 out) prim_cpoly c=1p m=1
	mnm12 (net13 net56 vssa vssa) nmos1 l=180n w=1u m=1
	mnm11 (net56 net56 vssa vssa) nmos1 l=180n w=1u m=1
	mnb02 (net27 net27 net21 vssa) nmos1 l=180n w=1u m=1
	mnpd1 (net21 xpd vssa vssa) nmos1 l=180n w=1u m=1
	mn001 (out net13 vssa vssa) nmos1 l=1.9e-07n w=1.8e-06u m=1
	mnpd2 (net13 pd vssa vssa) nmos1 l=180n w=1u m=1
	mnc01 (net13 net69 net12 vssa) nmos1 l=180n w=1u m=1
	mpb02 (net27 net51 net158 vdda) pmos1 l=180n w=1u m=1
	mppd1 (net158 xpd vdda vdda) pmos1 l=180n w=1u m=1
	mps11 (net31 net158 vdda vdda) pmos1 l=180n w=1u m=1
	mpd11 (net56 inn net31 net31) pmos1 l=1.4e-07n w=1.4e-06u m=1
	mp001 (out net158 vdda vdda) pmos1 l=180n w=1u m=1
	mpd12 (net13 inp net31 net31) pmos1 l=180n w=1u m=1
	mpb01 (net158 net158 vdda vdda) pmos1 l=180n w=1u m=1
ends OPAMP1_variant962

subckt OPAMP1_variant963 inn inp out pd xpd vdda vssa
	xd1 (vssa vdda) prim_nwd AREA=6.13907e-9 PJ=476.6e-6 m=1
	xi0 (vssa net69) prim_nd AREA=1e-12 PJ=4e-6 m=1
	xi3 (net51 vdda) prim_pd AREA=790e-15 PJ=3.3e-6 m=1
	xr0 (vssa vdda net51) prim_rdiffp l=1.9e-07 w=5.7e-07 m=1
	xr1 (vdda vdda net69) prim_rdiffp l=2.1e-6 w=700e-9 m=1
	xcc01 (net12 out) prim_cpoly c=1p m=1
	mnm12 (net13 net56 vssa vssa) nmos1 l=1.3e-07n w=1.3e-06u m=1
	mnm11 (net56 net56 vssa vssa) nmos1 l=180n w=1u m=1
	mnb02 (net27 net27 net21 vssa) nmos1 l=180n w=1u m=1
	mnpd1 (net21 xpd vssa vssa) nmos1 l=180n w=1u m=1
	mn001 (out net13 vssa vssa) nmos1 l=180n w=1u m=1
	mnpd2 (net13 pd vssa vssa) nmos1 l=2.3e-07n w=1.9e-06u m=1
	mnc01 (net13 net69 net12 vssa) nmos1 l=1.8e-07n w=1.8e-06u m=1
	mpb02 (net27 net51 net158 vdda) pmos1 l=2.9e-07n w=6.3e-07u m=1
	mppd1 (net158 xpd vdda vdda) pmos1 l=180n w=1u m=1
	mps11 (net31 net158 vdda vdda) pmos1 l=180n w=1u m=1
	mpd11 (net56 inn net31 net31) pmos1 l=180n w=1u m=1
	mp001 (out net158 vdda vdda) pmos1 l=180n w=1u m=1
	mpd12 (net13 inp net31 net31) pmos1 l=180n w=1u m=1
	mpb01 (net158 net158 vdda vdda) pmos1 l=180n w=1u m=1
ends OPAMP1_variant963

subckt OPAMP1_variant964 inn inp out pd xpd vdda vssa
	xd1 (vssa vdda) prim_nwd AREA=6.13907e-9 PJ=476.6e-6 m=1
	xi0 (vssa net69) prim_nd AREA=1e-12 PJ=4e-6 m=1
	xi3 (net51 vdda) prim_pd AREA=4.7e-09 PJ=2.0e-06 m=1
	xr0 (vssa vdda net51) prim_rdiffp l=2.1e-6 w=700e-9 m=1
	xr1 (vdda vdda net69) prim_rdiffp l=1.6e-07 w=1.3e-06 m=1
	xcc01 (net12 out) prim_cpoly c=1p m=1
	mnm12 (net13 net56 vssa vssa) nmos1 l=180n w=1u m=1
	mnm11 (net56 net56 vssa vssa) nmos1 l=1.6e-07n w=1.5e-06u m=1
	mnb02 (net27 net27 net21 vssa) nmos1 l=180n w=1u m=1
	mnpd1 (net21 xpd vssa vssa) nmos1 l=180n w=1u m=1
	mn001 (out net13 vssa vssa) nmos1 l=180n w=1u m=1
	mnpd2 (net13 pd vssa vssa) nmos1 l=2.0e-07n w=1.8e-06u m=1
	mnc01 (net13 net69 net12 vssa) nmos1 l=180n w=1u m=1
	mpb02 (net27 net51 net158 vdda) pmos1 l=180n w=1u m=1
	mppd1 (net158 xpd vdda vdda) pmos1 l=180n w=1u m=1
	mps11 (net31 net158 vdda vdda) pmos1 l=180n w=1u m=1
	mpd11 (net56 inn net31 net31) pmos1 l=180n w=1u m=1
	mp001 (out net158 vdda vdda) pmos1 l=180n w=1u m=1
	mpd12 (net13 inp net31 net31) pmos1 l=180n w=1u m=1
	mpb01 (net158 net158 vdda vdda) pmos1 l=3.0e-07n w=1.9e-06u m=1
ends OPAMP1_variant964

subckt OPAMP1_variant965 inn inp out pd xpd vdda vssa
	xd1 (vssa vdda) prim_nwd AREA=6.13907e-9 PJ=476.6e-6 m=1
	xi0 (vssa net69) prim_nd AREA=1e-12 PJ=4e-6 m=1
	xi3 (net51 vdda) prim_pd AREA=790e-15 PJ=3.3e-6 m=1
	xr0 (vssa vdda net51) prim_rdiffp l=2.1e-6 w=700e-9 m=1
	xr1 (vdda vdda net69) prim_rdiffp l=2.2e-07 w=6.2e-07 m=1
	xcc01 (net12 out) prim_cpoly c=1p m=1
	mnm12 (net13 net56 vssa vssa) nmos1 l=180n w=1u m=1
	mnm11 (net56 net56 vssa vssa) nmos1 l=180n w=1u m=1
	mnb02 (net27 net27 net21 vssa) nmos1 l=180n w=1u m=1
	mnpd1 (net21 xpd vssa vssa) nmos1 l=180n w=1u m=1
	mn001 (out net13 vssa vssa) nmos1 l=2.8e-07n w=1.1e-06u m=1
	mnpd2 (net13 pd vssa vssa) nmos1 l=180n w=1u m=1
	mnc01 (net13 net69 net12 vssa) nmos1 l=180n w=1u m=1
	mpb02 (net27 net51 net158 vdda) pmos1 l=180n w=1u m=1
	mppd1 (net158 xpd vdda vdda) pmos1 l=180n w=1u m=1
	mps11 (net31 net158 vdda vdda) pmos1 l=180n w=1u m=1
	mpd11 (net56 inn net31 net31) pmos1 l=180n w=1u m=1
	mp001 (out net158 vdda vdda) pmos1 l=180n w=1u m=1
	mpd12 (net13 inp net31 net31) pmos1 l=180n w=1u m=1
	mpb01 (net158 net158 vdda vdda) pmos1 l=180n w=1u m=1
ends OPAMP1_variant965

subckt OPAMP1_variant966 inn inp out pd xpd vdda vssa
	xd1 (vssa vdda) prim_nwd AREA=8.3e-09 PJ=9.6e-05 m=1
	xi0 (vssa net69) prim_nd AREA=1e-12 PJ=4e-6 m=1
	xi3 (net51 vdda) prim_pd AREA=2.3e-09 PJ=1.0e-05 m=1
	xr0 (vssa vdda net51) prim_rdiffp l=2.1e-6 w=700e-9 m=1
	xr1 (vdda vdda net69) prim_rdiffp l=2.1e-6 w=700e-9 m=1
	xcc01 (net12 out) prim_cpoly c=1p m=1
	mnm12 (net13 net56 vssa vssa) nmos1 l=180n w=1u m=1
	mnm11 (net56 net56 vssa vssa) nmos1 l=180n w=1u m=1
	mnb02 (net27 net27 net21 vssa) nmos1 l=2.7e-07n w=1.5e-06u m=1
	mnpd1 (net21 xpd vssa vssa) nmos1 l=180n w=1u m=1
	mn001 (out net13 vssa vssa) nmos1 l=1.5e-07n w=2.0e-06u m=1
	mnpd2 (net13 pd vssa vssa) nmos1 l=180n w=1u m=1
	mnc01 (net13 net69 net12 vssa) nmos1 l=180n w=1u m=1
	mpb02 (net27 net51 net158 vdda) pmos1 l=180n w=1u m=1
	mppd1 (net158 xpd vdda vdda) pmos1 l=180n w=1u m=1
	mps11 (net31 net158 vdda vdda) pmos1 l=180n w=1u m=1
	mpd11 (net56 inn net31 net31) pmos1 l=180n w=1u m=1
	mp001 (out net158 vdda vdda) pmos1 l=180n w=1u m=1
	mpd12 (net13 inp net31 net31) pmos1 l=180n w=1u m=1
	mpb01 (net158 net158 vdda vdda) pmos1 l=180n w=1u m=1
ends OPAMP1_variant966

subckt OPAMP1_variant967 inn inp out pd xpd vdda vssa
	xd1 (vssa vdda) prim_nwd AREA=5.9e-09 PJ=5.4e-05 m=1
	xi0 (vssa net69) prim_nd AREA=1e-12 PJ=4e-6 m=1
	xi3 (net51 vdda) prim_pd AREA=790e-15 PJ=3.3e-6 m=1
	xr0 (vssa vdda net51) prim_rdiffp l=2.1e-6 w=700e-9 m=1
	xr1 (vdda vdda net69) prim_rdiffp l=2.1e-6 w=700e-9 m=1
	xcc01 (net12 out) prim_cpoly c=1p m=1
	mnm12 (net13 net56 vssa vssa) nmos1 l=180n w=1u m=1
	mnm11 (net56 net56 vssa vssa) nmos1 l=180n w=1u m=1
	mnb02 (net27 net27 net21 vssa) nmos1 l=180n w=1u m=1
	mnpd1 (net21 xpd vssa vssa) nmos1 l=2.7e-07n w=1.8e-06u m=1
	mn001 (out net13 vssa vssa) nmos1 l=180n w=1u m=1
	mnpd2 (net13 pd vssa vssa) nmos1 l=180n w=1u m=1
	mnc01 (net13 net69 net12 vssa) nmos1 l=180n w=1u m=1
	mpb02 (net27 net51 net158 vdda) pmos1 l=2.9e-07n w=1.9e-06u m=1
	mppd1 (net158 xpd vdda vdda) pmos1 l=1.5e-07n w=1.5e-06u m=1
	mps11 (net31 net158 vdda vdda) pmos1 l=180n w=1u m=1
	mpd11 (net56 inn net31 net31) pmos1 l=180n w=1u m=1
	mp001 (out net158 vdda vdda) pmos1 l=180n w=1u m=1
	mpd12 (net13 inp net31 net31) pmos1 l=1.7e-07n w=1.4e-06u m=1
	mpb01 (net158 net158 vdda vdda) pmos1 l=180n w=1u m=1
ends OPAMP1_variant967

subckt OPAMP1_variant968 inn inp out pd xpd vdda vssa
	xd1 (vssa vdda) prim_nwd AREA=6.13907e-9 PJ=476.6e-6 m=1
	xi0 (vssa net69) prim_nd AREA=1e-12 PJ=4e-6 m=1
	xi3 (net51 vdda) prim_pd AREA=790e-15 PJ=3.3e-6 m=1
	xr0 (vssa vdda net51) prim_rdiffp l=2.9e-07 w=6.8e-07 m=1
	xr1 (vdda vdda net69) prim_rdiffp l=2.1e-6 w=700e-9 m=1
	xcc01 (net12 out) prim_cpoly c=1p m=1
	mnm12 (net13 net56 vssa vssa) nmos1 l=180n w=1u m=1
	mnm11 (net56 net56 vssa vssa) nmos1 l=180n w=1u m=1
	mnb02 (net27 net27 net21 vssa) nmos1 l=180n w=1u m=1
	mnpd1 (net21 xpd vssa vssa) nmos1 l=180n w=1u m=1
	mn001 (out net13 vssa vssa) nmos1 l=180n w=1u m=1
	mnpd2 (net13 pd vssa vssa) nmos1 l=1.3e-07n w=1.4e-06u m=1
	mnc01 (net13 net69 net12 vssa) nmos1 l=180n w=1u m=1
	mpb02 (net27 net51 net158 vdda) pmos1 l=180n w=1u m=1
	mppd1 (net158 xpd vdda vdda) pmos1 l=180n w=1u m=1
	mps11 (net31 net158 vdda vdda) pmos1 l=180n w=1u m=1
	mpd11 (net56 inn net31 net31) pmos1 l=180n w=1u m=1
	mp001 (out net158 vdda vdda) pmos1 l=180n w=1u m=1
	mpd12 (net13 inp net31 net31) pmos1 l=180n w=1u m=1
	mpb01 (net158 net158 vdda vdda) pmos1 l=180n w=1u m=1
ends OPAMP1_variant968

subckt OPAMP1_variant969 inn inp out pd xpd vdda vssa
	xd1 (vssa vdda) prim_nwd AREA=6.13907e-9 PJ=476.6e-6 m=1
	xi0 (vssa net69) prim_nd AREA=1e-12 PJ=4e-6 m=1
	xi3 (net51 vdda) prim_pd AREA=5.0e-09 PJ=7.0e-05 m=1
	xr0 (vssa vdda net51) prim_rdiffp l=2.1e-6 w=700e-9 m=1
	xr1 (vdda vdda net69) prim_rdiffp l=2.1e-6 w=700e-9 m=1
	xcc01 (net12 out) prim_cpoly c=1p m=1
	mnm12 (net13 net56 vssa vssa) nmos1 l=2.6e-07n w=1.7e-06u m=1
	mnm11 (net56 net56 vssa vssa) nmos1 l=180n w=1u m=1
	mnb02 (net27 net27 net21 vssa) nmos1 l=180n w=1u m=1
	mnpd1 (net21 xpd vssa vssa) nmos1 l=1.8e-07n w=2.0e-06u m=1
	mn001 (out net13 vssa vssa) nmos1 l=180n w=1u m=1
	mnpd2 (net13 pd vssa vssa) nmos1 l=180n w=1u m=1
	mnc01 (net13 net69 net12 vssa) nmos1 l=180n w=1u m=1
	mpb02 (net27 net51 net158 vdda) pmos1 l=180n w=1u m=1
	mppd1 (net158 xpd vdda vdda) pmos1 l=180n w=1u m=1
	mps11 (net31 net158 vdda vdda) pmos1 l=180n w=1u m=1
	mpd11 (net56 inn net31 net31) pmos1 l=180n w=1u m=1
	mp001 (out net158 vdda vdda) pmos1 l=180n w=1u m=1
	mpd12 (net13 inp net31 net31) pmos1 l=180n w=1u m=1
	mpb01 (net158 net158 vdda vdda) pmos1 l=180n w=1u m=1
ends OPAMP1_variant969

subckt OPAMP1_variant970 inn inp out pd xpd vdda vssa
	xd1 (vssa vdda) prim_nwd AREA=6.13907e-9 PJ=476.6e-6 m=1
	xi0 (vssa net69) prim_nd AREA=1e-12 PJ=4e-6 m=1
	xi3 (net51 vdda) prim_pd AREA=790e-15 PJ=3.3e-6 m=1
	xr0 (vssa vdda net51) prim_rdiffp l=2.1e-6 w=700e-9 m=1
	xr1 (vdda vdda net69) prim_rdiffp l=2.1e-6 w=700e-9 m=1
	xcc01 (net12 out) prim_cpoly c=1p m=1
	mnm12 (net13 net56 vssa vssa) nmos1 l=2.8e-07n w=5.8e-07u m=1
	mnm11 (net56 net56 vssa vssa) nmos1 l=180n w=1u m=1
	mnb02 (net27 net27 net21 vssa) nmos1 l=3.0e-07n w=1.7e-06u m=1
	mnpd1 (net21 xpd vssa vssa) nmos1 l=180n w=1u m=1
	mn001 (out net13 vssa vssa) nmos1 l=180n w=1u m=1
	mnpd2 (net13 pd vssa vssa) nmos1 l=180n w=1u m=1
	mnc01 (net13 net69 net12 vssa) nmos1 l=1.7e-07n w=1.5e-06u m=1
	mpb02 (net27 net51 net158 vdda) pmos1 l=1.9e-07n w=1.5e-06u m=1
	mppd1 (net158 xpd vdda vdda) pmos1 l=2.4e-07n w=1.9e-06u m=1
	mps11 (net31 net158 vdda vdda) pmos1 l=180n w=1u m=1
	mpd11 (net56 inn net31 net31) pmos1 l=180n w=1u m=1
	mp001 (out net158 vdda vdda) pmos1 l=180n w=1u m=1
	mpd12 (net13 inp net31 net31) pmos1 l=180n w=1u m=1
	mpb01 (net158 net158 vdda vdda) pmos1 l=180n w=1u m=1
ends OPAMP1_variant970

subckt OPAMP1_variant971 inn inp out pd xpd vdda vssa
	xd1 (vssa vdda) prim_nwd AREA=6.13907e-9 PJ=476.6e-6 m=1
	xi0 (vssa net69) prim_nd AREA=1e-12 PJ=4e-6 m=1
	xi3 (net51 vdda) prim_pd AREA=790e-15 PJ=3.3e-6 m=1
	xr0 (vssa vdda net51) prim_rdiffp l=2.1e-6 w=700e-9 m=1
	xr1 (vdda vdda net69) prim_rdiffp l=2.1e-6 w=700e-9 m=1
	xcc01 (net12 out) prim_cpoly c=1p m=1
	mnm12 (net13 net56 vssa vssa) nmos1 l=180n w=1u m=1
	mnm11 (net56 net56 vssa vssa) nmos1 l=180n w=1u m=1
	mnb02 (net27 net27 net21 vssa) nmos1 l=1.7e-07n w=1.9e-06u m=1
	mnpd1 (net21 xpd vssa vssa) nmos1 l=180n w=1u m=1
	mn001 (out net13 vssa vssa) nmos1 l=180n w=1u m=1
	mnpd2 (net13 pd vssa vssa) nmos1 l=2.1e-07n w=5.9e-07u m=1
	mnc01 (net13 net69 net12 vssa) nmos1 l=180n w=1u m=1
	mpb02 (net27 net51 net158 vdda) pmos1 l=180n w=1u m=1
	mppd1 (net158 xpd vdda vdda) pmos1 l=180n w=1u m=1
	mps11 (net31 net158 vdda vdda) pmos1 l=180n w=1u m=1
	mpd11 (net56 inn net31 net31) pmos1 l=180n w=1u m=1
	mp001 (out net158 vdda vdda) pmos1 l=180n w=1u m=1
	mpd12 (net13 inp net31 net31) pmos1 l=2.0e-07n w=9.6e-07u m=1
	mpb01 (net158 net158 vdda vdda) pmos1 l=180n w=1u m=1
ends OPAMP1_variant971

subckt OPAMP1_variant972 inn inp out pd xpd vdda vssa
	xd1 (vssa vdda) prim_nwd AREA=2.6e-09 PJ=6.5e-05 m=1
	xi0 (vssa net69) prim_nd AREA=1e-12 PJ=4e-6 m=1
	xi3 (net51 vdda) prim_pd AREA=790e-15 PJ=3.3e-6 m=1
	xr0 (vssa vdda net51) prim_rdiffp l=1.8e-07 w=1.9e-06 m=1
	xr1 (vdda vdda net69) prim_rdiffp l=2.1e-6 w=700e-9 m=1
	xcc01 (net12 out) prim_cpoly c=1p m=1
	mnm12 (net13 net56 vssa vssa) nmos1 l=180n w=1u m=1
	mnm11 (net56 net56 vssa vssa) nmos1 l=180n w=1u m=1
	mnb02 (net27 net27 net21 vssa) nmos1 l=180n w=1u m=1
	mnpd1 (net21 xpd vssa vssa) nmos1 l=2.1e-07n w=1.7e-06u m=1
	mn001 (out net13 vssa vssa) nmos1 l=180n w=1u m=1
	mnpd2 (net13 pd vssa vssa) nmos1 l=180n w=1u m=1
	mnc01 (net13 net69 net12 vssa) nmos1 l=180n w=1u m=1
	mpb02 (net27 net51 net158 vdda) pmos1 l=180n w=1u m=1
	mppd1 (net158 xpd vdda vdda) pmos1 l=180n w=1u m=1
	mps11 (net31 net158 vdda vdda) pmos1 l=180n w=1u m=1
	mpd11 (net56 inn net31 net31) pmos1 l=180n w=1u m=1
	mp001 (out net158 vdda vdda) pmos1 l=180n w=1u m=1
	mpd12 (net13 inp net31 net31) pmos1 l=180n w=1u m=1
	mpb01 (net158 net158 vdda vdda) pmos1 l=180n w=1u m=1
ends OPAMP1_variant972

subckt OPAMP1_variant973 inn inp out pd xpd vdda vssa
	xd1 (vssa vdda) prim_nwd AREA=6.13907e-9 PJ=476.6e-6 m=1
	xi0 (vssa net69) prim_nd AREA=1e-12 PJ=4e-6 m=1
	xi3 (net51 vdda) prim_pd AREA=790e-15 PJ=3.3e-6 m=1
	xr0 (vssa vdda net51) prim_rdiffp l=2.1e-6 w=700e-9 m=1
	xr1 (vdda vdda net69) prim_rdiffp l=2.1e-6 w=700e-9 m=1
	xcc01 (net12 out) prim_cpoly c=1p m=1
	mnm12 (net13 net56 vssa vssa) nmos1 l=2.1e-07n w=1.5e-06u m=1
	mnm11 (net56 net56 vssa vssa) nmos1 l=180n w=1u m=1
	mnb02 (net27 net27 net21 vssa) nmos1 l=180n w=1u m=1
	mnpd1 (net21 xpd vssa vssa) nmos1 l=180n w=1u m=1
	mn001 (out net13 vssa vssa) nmos1 l=180n w=1u m=1
	mnpd2 (net13 pd vssa vssa) nmos1 l=180n w=1u m=1
	mnc01 (net13 net69 net12 vssa) nmos1 l=180n w=1u m=1
	mpb02 (net27 net51 net158 vdda) pmos1 l=180n w=1u m=1
	mppd1 (net158 xpd vdda vdda) pmos1 l=2.1e-07n w=1.9e-06u m=1
	mps11 (net31 net158 vdda vdda) pmos1 l=1.3e-07n w=1.6e-06u m=1
	mpd11 (net56 inn net31 net31) pmos1 l=180n w=1u m=1
	mp001 (out net158 vdda vdda) pmos1 l=180n w=1u m=1
	mpd12 (net13 inp net31 net31) pmos1 l=180n w=1u m=1
	mpb01 (net158 net158 vdda vdda) pmos1 l=180n w=1u m=1
ends OPAMP1_variant973

subckt OPAMP1_variant974 inn inp out pd xpd vdda vssa
	xd1 (vssa vdda) prim_nwd AREA=6.13907e-9 PJ=476.6e-6 m=1
	xi0 (vssa net69) prim_nd AREA=1e-12 PJ=4e-6 m=1
	xi3 (net51 vdda) prim_pd AREA=790e-15 PJ=3.3e-6 m=1
	xr0 (vssa vdda net51) prim_rdiffp l=2.1e-6 w=700e-9 m=1
	xr1 (vdda vdda net69) prim_rdiffp l=2.1e-6 w=700e-9 m=1
	xcc01 (net12 out) prim_cpoly c=1.3e-12p m=1
	mnm12 (net13 net56 vssa vssa) nmos1 l=180n w=1u m=1
	mnm11 (net56 net56 vssa vssa) nmos1 l=180n w=1u m=1
	mnb02 (net27 net27 net21 vssa) nmos1 l=180n w=1u m=1
	mnpd1 (net21 xpd vssa vssa) nmos1 l=180n w=1u m=1
	mn001 (out net13 vssa vssa) nmos1 l=180n w=1u m=1
	mnpd2 (net13 pd vssa vssa) nmos1 l=180n w=1u m=1
	mnc01 (net13 net69 net12 vssa) nmos1 l=1.6e-07n w=1.5e-06u m=1
	mpb02 (net27 net51 net158 vdda) pmos1 l=180n w=1u m=1
	mppd1 (net158 xpd vdda vdda) pmos1 l=180n w=1u m=1
	mps11 (net31 net158 vdda vdda) pmos1 l=180n w=1u m=1
	mpd11 (net56 inn net31 net31) pmos1 l=180n w=1u m=1
	mp001 (out net158 vdda vdda) pmos1 l=180n w=1u m=1
	mpd12 (net13 inp net31 net31) pmos1 l=180n w=1u m=1
	mpb01 (net158 net158 vdda vdda) pmos1 l=180n w=1u m=1
ends OPAMP1_variant974

subckt OPAMP1_variant975 inn inp out pd xpd vdda vssa
	xd1 (vssa vdda) prim_nwd AREA=7.3e-09 PJ=2.7e-05 m=1
	xi0 (vssa net69) prim_nd AREA=1e-12 PJ=4e-6 m=1
	xi3 (net51 vdda) prim_pd AREA=3.5e-09 PJ=6.5e-05 m=1
	xr0 (vssa vdda net51) prim_rdiffp l=2.1e-6 w=700e-9 m=1
	xr1 (vdda vdda net69) prim_rdiffp l=2.3e-07 w=9.1e-07 m=1
	xcc01 (net12 out) prim_cpoly c=1p m=1
	mnm12 (net13 net56 vssa vssa) nmos1 l=180n w=1u m=1
	mnm11 (net56 net56 vssa vssa) nmos1 l=180n w=1u m=1
	mnb02 (net27 net27 net21 vssa) nmos1 l=180n w=1u m=1
	mnpd1 (net21 xpd vssa vssa) nmos1 l=180n w=1u m=1
	mn001 (out net13 vssa vssa) nmos1 l=1.3e-07n w=2.0e-06u m=1
	mnpd2 (net13 pd vssa vssa) nmos1 l=180n w=1u m=1
	mnc01 (net13 net69 net12 vssa) nmos1 l=180n w=1u m=1
	mpb02 (net27 net51 net158 vdda) pmos1 l=180n w=1u m=1
	mppd1 (net158 xpd vdda vdda) pmos1 l=180n w=1u m=1
	mps11 (net31 net158 vdda vdda) pmos1 l=180n w=1u m=1
	mpd11 (net56 inn net31 net31) pmos1 l=180n w=1u m=1
	mp001 (out net158 vdda vdda) pmos1 l=180n w=1u m=1
	mpd12 (net13 inp net31 net31) pmos1 l=180n w=1u m=1
	mpb01 (net158 net158 vdda vdda) pmos1 l=180n w=1u m=1
ends OPAMP1_variant975

subckt OPAMP1_variant976 inn inp out pd xpd vdda vssa
	xd1 (vssa vdda) prim_nwd AREA=6.13907e-9 PJ=476.6e-6 m=1
	xi0 (vssa net69) prim_nd AREA=1.1e-09 PJ=8.9e-06 m=1
	xi3 (net51 vdda) prim_pd AREA=790e-15 PJ=3.3e-6 m=1
	xr0 (vssa vdda net51) prim_rdiffp l=2.1e-6 w=700e-9 m=1
	xr1 (vdda vdda net69) prim_rdiffp l=2.7e-07 w=5.3e-07 m=1
	xcc01 (net12 out) prim_cpoly c=1p m=1
	mnm12 (net13 net56 vssa vssa) nmos1 l=180n w=1u m=1
	mnm11 (net56 net56 vssa vssa) nmos1 l=180n w=1u m=1
	mnb02 (net27 net27 net21 vssa) nmos1 l=180n w=1u m=1
	mnpd1 (net21 xpd vssa vssa) nmos1 l=180n w=1u m=1
	mn001 (out net13 vssa vssa) nmos1 l=180n w=1u m=1
	mnpd2 (net13 pd vssa vssa) nmos1 l=180n w=1u m=1
	mnc01 (net13 net69 net12 vssa) nmos1 l=180n w=1u m=1
	mpb02 (net27 net51 net158 vdda) pmos1 l=1.6e-07n w=9.6e-07u m=1
	mppd1 (net158 xpd vdda vdda) pmos1 l=2.4e-07n w=7.8e-07u m=1
	mps11 (net31 net158 vdda vdda) pmos1 l=180n w=1u m=1
	mpd11 (net56 inn net31 net31) pmos1 l=180n w=1u m=1
	mp001 (out net158 vdda vdda) pmos1 l=180n w=1u m=1
	mpd12 (net13 inp net31 net31) pmos1 l=180n w=1u m=1
	mpb01 (net158 net158 vdda vdda) pmos1 l=180n w=1u m=1
ends OPAMP1_variant976

subckt OPAMP1_variant977 inn inp out pd xpd vdda vssa
	xd1 (vssa vdda) prim_nwd AREA=6.13907e-9 PJ=476.6e-6 m=1
	xi0 (vssa net69) prim_nd AREA=1e-12 PJ=4e-6 m=1
	xi3 (net51 vdda) prim_pd AREA=790e-15 PJ=3.3e-6 m=1
	xr0 (vssa vdda net51) prim_rdiffp l=2.1e-6 w=700e-9 m=1
	xr1 (vdda vdda net69) prim_rdiffp l=2.1e-6 w=700e-9 m=1
	xcc01 (net12 out) prim_cpoly c=1p m=1
	mnm12 (net13 net56 vssa vssa) nmos1 l=1.2e-07n w=6.4e-07u m=1
	mnm11 (net56 net56 vssa vssa) nmos1 l=180n w=1u m=1
	mnb02 (net27 net27 net21 vssa) nmos1 l=2.1e-07n w=1.6e-06u m=1
	mnpd1 (net21 xpd vssa vssa) nmos1 l=180n w=1u m=1
	mn001 (out net13 vssa vssa) nmos1 l=180n w=1u m=1
	mnpd2 (net13 pd vssa vssa) nmos1 l=1.9e-07n w=9.7e-07u m=1
	mnc01 (net13 net69 net12 vssa) nmos1 l=2.4e-07n w=1.7e-06u m=1
	mpb02 (net27 net51 net158 vdda) pmos1 l=180n w=1u m=1
	mppd1 (net158 xpd vdda vdda) pmos1 l=180n w=1u m=1
	mps11 (net31 net158 vdda vdda) pmos1 l=180n w=1u m=1
	mpd11 (net56 inn net31 net31) pmos1 l=180n w=1u m=1
	mp001 (out net158 vdda vdda) pmos1 l=180n w=1u m=1
	mpd12 (net13 inp net31 net31) pmos1 l=2.4e-07n w=1.1e-06u m=1
	mpb01 (net158 net158 vdda vdda) pmos1 l=180n w=1u m=1
ends OPAMP1_variant977

subckt OPAMP1_variant978 inn inp out pd xpd vdda vssa
	xd1 (vssa vdda) prim_nwd AREA=6.13907e-9 PJ=476.6e-6 m=1
	xi0 (vssa net69) prim_nd AREA=5.8e-09 PJ=4.0e-05 m=1
	xi3 (net51 vdda) prim_pd AREA=790e-15 PJ=3.3e-6 m=1
	xr0 (vssa vdda net51) prim_rdiffp l=2.1e-6 w=700e-9 m=1
	xr1 (vdda vdda net69) prim_rdiffp l=2.1e-6 w=700e-9 m=1
	xcc01 (net12 out) prim_cpoly c=1p m=1
	mnm12 (net13 net56 vssa vssa) nmos1 l=180n w=1u m=1
	mnm11 (net56 net56 vssa vssa) nmos1 l=180n w=1u m=1
	mnb02 (net27 net27 net21 vssa) nmos1 l=180n w=1u m=1
	mnpd1 (net21 xpd vssa vssa) nmos1 l=180n w=1u m=1
	mn001 (out net13 vssa vssa) nmos1 l=180n w=1u m=1
	mnpd2 (net13 pd vssa vssa) nmos1 l=180n w=1u m=1
	mnc01 (net13 net69 net12 vssa) nmos1 l=180n w=1u m=1
	mpb02 (net27 net51 net158 vdda) pmos1 l=180n w=1u m=1
	mppd1 (net158 xpd vdda vdda) pmos1 l=2.4e-07n w=1.2e-06u m=1
	mps11 (net31 net158 vdda vdda) pmos1 l=180n w=1u m=1
	mpd11 (net56 inn net31 net31) pmos1 l=180n w=1u m=1
	mp001 (out net158 vdda vdda) pmos1 l=2.3e-07n w=2.0e-06u m=1
	mpd12 (net13 inp net31 net31) pmos1 l=180n w=1u m=1
	mpb01 (net158 net158 vdda vdda) pmos1 l=180n w=1u m=1
ends OPAMP1_variant978

subckt OPAMP1_variant979 inn inp out pd xpd vdda vssa
	xd1 (vssa vdda) prim_nwd AREA=6.13907e-9 PJ=476.6e-6 m=1
	xi0 (vssa net69) prim_nd AREA=1e-12 PJ=4e-6 m=1
	xi3 (net51 vdda) prim_pd AREA=790e-15 PJ=3.3e-6 m=1
	xr0 (vssa vdda net51) prim_rdiffp l=2.1e-6 w=700e-9 m=1
	xr1 (vdda vdda net69) prim_rdiffp l=2.1e-6 w=700e-9 m=1
	xcc01 (net12 out) prim_cpoly c=1p m=1
	mnm12 (net13 net56 vssa vssa) nmos1 l=180n w=1u m=1
	mnm11 (net56 net56 vssa vssa) nmos1 l=180n w=1u m=1
	mnb02 (net27 net27 net21 vssa) nmos1 l=180n w=1u m=1
	mnpd1 (net21 xpd vssa vssa) nmos1 l=180n w=1u m=1
	mn001 (out net13 vssa vssa) nmos1 l=180n w=1u m=1
	mnpd2 (net13 pd vssa vssa) nmos1 l=180n w=1u m=1
	mnc01 (net13 net69 net12 vssa) nmos1 l=180n w=1u m=1
	mpb02 (net27 net51 net158 vdda) pmos1 l=180n w=1u m=1
	mppd1 (net158 xpd vdda vdda) pmos1 l=180n w=1u m=1
	mps11 (net31 net158 vdda vdda) pmos1 l=2.4e-07n w=9.8e-07u m=1
	mpd11 (net56 inn net31 net31) pmos1 l=2.9e-07n w=1.1e-06u m=1
	mp001 (out net158 vdda vdda) pmos1 l=180n w=1u m=1
	mpd12 (net13 inp net31 net31) pmos1 l=180n w=1u m=1
	mpb01 (net158 net158 vdda vdda) pmos1 l=180n w=1u m=1
ends OPAMP1_variant979

subckt OPAMP1_variant980 inn inp out pd xpd vdda vssa
	xd1 (vssa vdda) prim_nwd AREA=6.13907e-9 PJ=476.6e-6 m=1
	xi0 (vssa net69) prim_nd AREA=1e-12 PJ=4e-6 m=1
	xi3 (net51 vdda) prim_pd AREA=790e-15 PJ=3.3e-6 m=1
	xr0 (vssa vdda net51) prim_rdiffp l=2.1e-6 w=700e-9 m=1
	xr1 (vdda vdda net69) prim_rdiffp l=2.1e-6 w=700e-9 m=1
	xcc01 (net12 out) prim_cpoly c=1p m=1
	mnm12 (net13 net56 vssa vssa) nmos1 l=2.1e-07n w=1.6e-06u m=1
	mnm11 (net56 net56 vssa vssa) nmos1 l=180n w=1u m=1
	mnb02 (net27 net27 net21 vssa) nmos1 l=180n w=1u m=1
	mnpd1 (net21 xpd vssa vssa) nmos1 l=180n w=1u m=1
	mn001 (out net13 vssa vssa) nmos1 l=2.2e-07n w=1.8e-06u m=1
	mnpd2 (net13 pd vssa vssa) nmos1 l=180n w=1u m=1
	mnc01 (net13 net69 net12 vssa) nmos1 l=180n w=1u m=1
	mpb02 (net27 net51 net158 vdda) pmos1 l=180n w=1u m=1
	mppd1 (net158 xpd vdda vdda) pmos1 l=180n w=1u m=1
	mps11 (net31 net158 vdda vdda) pmos1 l=180n w=1u m=1
	mpd11 (net56 inn net31 net31) pmos1 l=180n w=1u m=1
	mp001 (out net158 vdda vdda) pmos1 l=180n w=1u m=1
	mpd12 (net13 inp net31 net31) pmos1 l=180n w=1u m=1
	mpb01 (net158 net158 vdda vdda) pmos1 l=180n w=1u m=1
ends OPAMP1_variant980

subckt OPAMP1_variant981 inn inp out pd xpd vdda vssa
	xd1 (vssa vdda) prim_nwd AREA=6.13907e-9 PJ=476.6e-6 m=1
	xi0 (vssa net69) prim_nd AREA=1e-12 PJ=4e-6 m=1
	xi3 (net51 vdda) prim_pd AREA=790e-15 PJ=3.3e-6 m=1
	xr0 (vssa vdda net51) prim_rdiffp l=1.0e-07 w=1.3e-06 m=1
	xr1 (vdda vdda net69) prim_rdiffp l=2.1e-6 w=700e-9 m=1
	xcc01 (net12 out) prim_cpoly c=1.0e-12p m=1
	mnm12 (net13 net56 vssa vssa) nmos1 l=2.7e-07n w=9.5e-07u m=1
	mnm11 (net56 net56 vssa vssa) nmos1 l=180n w=1u m=1
	mnb02 (net27 net27 net21 vssa) nmos1 l=180n w=1u m=1
	mnpd1 (net21 xpd vssa vssa) nmos1 l=180n w=1u m=1
	mn001 (out net13 vssa vssa) nmos1 l=180n w=1u m=1
	mnpd2 (net13 pd vssa vssa) nmos1 l=180n w=1u m=1
	mnc01 (net13 net69 net12 vssa) nmos1 l=1.4e-07n w=1.3e-06u m=1
	mpb02 (net27 net51 net158 vdda) pmos1 l=180n w=1u m=1
	mppd1 (net158 xpd vdda vdda) pmos1 l=180n w=1u m=1
	mps11 (net31 net158 vdda vdda) pmos1 l=1.1e-07n w=1.7e-06u m=1
	mpd11 (net56 inn net31 net31) pmos1 l=180n w=1u m=1
	mp001 (out net158 vdda vdda) pmos1 l=180n w=1u m=1
	mpd12 (net13 inp net31 net31) pmos1 l=180n w=1u m=1
	mpb01 (net158 net158 vdda vdda) pmos1 l=180n w=1u m=1
ends OPAMP1_variant981

subckt OPAMP1_variant982 inn inp out pd xpd vdda vssa
	xd1 (vssa vdda) prim_nwd AREA=6.13907e-9 PJ=476.6e-6 m=1
	xi0 (vssa net69) prim_nd AREA=1e-12 PJ=4e-6 m=1
	xi3 (net51 vdda) prim_pd AREA=790e-15 PJ=3.3e-6 m=1
	xr0 (vssa vdda net51) prim_rdiffp l=2.1e-6 w=700e-9 m=1
	xr1 (vdda vdda net69) prim_rdiffp l=2.1e-6 w=700e-9 m=1
	xcc01 (net12 out) prim_cpoly c=1p m=1
	mnm12 (net13 net56 vssa vssa) nmos1 l=2.2e-07n w=1.3e-06u m=1
	mnm11 (net56 net56 vssa vssa) nmos1 l=180n w=1u m=1
	mnb02 (net27 net27 net21 vssa) nmos1 l=180n w=1u m=1
	mnpd1 (net21 xpd vssa vssa) nmos1 l=180n w=1u m=1
	mn001 (out net13 vssa vssa) nmos1 l=180n w=1u m=1
	mnpd2 (net13 pd vssa vssa) nmos1 l=180n w=1u m=1
	mnc01 (net13 net69 net12 vssa) nmos1 l=180n w=1u m=1
	mpb02 (net27 net51 net158 vdda) pmos1 l=180n w=1u m=1
	mppd1 (net158 xpd vdda vdda) pmos1 l=180n w=1u m=1
	mps11 (net31 net158 vdda vdda) pmos1 l=180n w=1u m=1
	mpd11 (net56 inn net31 net31) pmos1 l=180n w=1u m=1
	mp001 (out net158 vdda vdda) pmos1 l=180n w=1u m=1
	mpd12 (net13 inp net31 net31) pmos1 l=2.1e-07n w=6.7e-07u m=1
	mpb01 (net158 net158 vdda vdda) pmos1 l=180n w=1u m=1
ends OPAMP1_variant982

subckt OPAMP1_variant983 inn inp out pd xpd vdda vssa
	xd1 (vssa vdda) prim_nwd AREA=6.13907e-9 PJ=476.6e-6 m=1
	xi0 (vssa net69) prim_nd AREA=1e-12 PJ=4e-6 m=1
	xi3 (net51 vdda) prim_pd AREA=790e-15 PJ=3.3e-6 m=1
	xr0 (vssa vdda net51) prim_rdiffp l=2.1e-6 w=700e-9 m=1
	xr1 (vdda vdda net69) prim_rdiffp l=2.1e-6 w=700e-9 m=1
	xcc01 (net12 out) prim_cpoly c=1p m=1
	mnm12 (net13 net56 vssa vssa) nmos1 l=3.0e-07n w=5.1e-07u m=1
	mnm11 (net56 net56 vssa vssa) nmos1 l=180n w=1u m=1
	mnb02 (net27 net27 net21 vssa) nmos1 l=180n w=1u m=1
	mnpd1 (net21 xpd vssa vssa) nmos1 l=180n w=1u m=1
	mn001 (out net13 vssa vssa) nmos1 l=2.7e-07n w=1.9e-06u m=1
	mnpd2 (net13 pd vssa vssa) nmos1 l=180n w=1u m=1
	mnc01 (net13 net69 net12 vssa) nmos1 l=180n w=1u m=1
	mpb02 (net27 net51 net158 vdda) pmos1 l=180n w=1u m=1
	mppd1 (net158 xpd vdda vdda) pmos1 l=1.8e-07n w=1.2e-06u m=1
	mps11 (net31 net158 vdda vdda) pmos1 l=180n w=1u m=1
	mpd11 (net56 inn net31 net31) pmos1 l=180n w=1u m=1
	mp001 (out net158 vdda vdda) pmos1 l=180n w=1u m=1
	mpd12 (net13 inp net31 net31) pmos1 l=180n w=1u m=1
	mpb01 (net158 net158 vdda vdda) pmos1 l=180n w=1u m=1
ends OPAMP1_variant983

subckt OPAMP1_variant984 inn inp out pd xpd vdda vssa
	xd1 (vssa vdda) prim_nwd AREA=6.13907e-9 PJ=476.6e-6 m=1
	xi0 (vssa net69) prim_nd AREA=1e-12 PJ=4e-6 m=1
	xi3 (net51 vdda) prim_pd AREA=790e-15 PJ=3.3e-6 m=1
	xr0 (vssa vdda net51) prim_rdiffp l=2.1e-6 w=700e-9 m=1
	xr1 (vdda vdda net69) prim_rdiffp l=2.1e-6 w=700e-9 m=1
	xcc01 (net12 out) prim_cpoly c=1p m=1
	mnm12 (net13 net56 vssa vssa) nmos1 l=180n w=1u m=1
	mnm11 (net56 net56 vssa vssa) nmos1 l=180n w=1u m=1
	mnb02 (net27 net27 net21 vssa) nmos1 l=180n w=1u m=1
	mnpd1 (net21 xpd vssa vssa) nmos1 l=180n w=1u m=1
	mn001 (out net13 vssa vssa) nmos1 l=1.5e-07n w=2.0e-06u m=1
	mnpd2 (net13 pd vssa vssa) nmos1 l=180n w=1u m=1
	mnc01 (net13 net69 net12 vssa) nmos1 l=180n w=1u m=1
	mpb02 (net27 net51 net158 vdda) pmos1 l=1.7e-07n w=1.2e-06u m=1
	mppd1 (net158 xpd vdda vdda) pmos1 l=180n w=1u m=1
	mps11 (net31 net158 vdda vdda) pmos1 l=180n w=1u m=1
	mpd11 (net56 inn net31 net31) pmos1 l=180n w=1u m=1
	mp001 (out net158 vdda vdda) pmos1 l=180n w=1u m=1
	mpd12 (net13 inp net31 net31) pmos1 l=2.8e-07n w=9.7e-07u m=1
	mpb01 (net158 net158 vdda vdda) pmos1 l=180n w=1u m=1
ends OPAMP1_variant984

subckt OPAMP1_variant985 inn inp out pd xpd vdda vssa
	xd1 (vssa vdda) prim_nwd AREA=6.13907e-9 PJ=476.6e-6 m=1
	xi0 (vssa net69) prim_nd AREA=1e-12 PJ=4e-6 m=1
	xi3 (net51 vdda) prim_pd AREA=790e-15 PJ=3.3e-6 m=1
	xr0 (vssa vdda net51) prim_rdiffp l=2.1e-6 w=700e-9 m=1
	xr1 (vdda vdda net69) prim_rdiffp l=3.0e-07 w=5.7e-07 m=1
	xcc01 (net12 out) prim_cpoly c=1p m=1
	mnm12 (net13 net56 vssa vssa) nmos1 l=1.7e-07n w=1.1e-06u m=1
	mnm11 (net56 net56 vssa vssa) nmos1 l=180n w=1u m=1
	mnb02 (net27 net27 net21 vssa) nmos1 l=180n w=1u m=1
	mnpd1 (net21 xpd vssa vssa) nmos1 l=180n w=1u m=1
	mn001 (out net13 vssa vssa) nmos1 l=180n w=1u m=1
	mnpd2 (net13 pd vssa vssa) nmos1 l=180n w=1u m=1
	mnc01 (net13 net69 net12 vssa) nmos1 l=180n w=1u m=1
	mpb02 (net27 net51 net158 vdda) pmos1 l=180n w=1u m=1
	mppd1 (net158 xpd vdda vdda) pmos1 l=180n w=1u m=1
	mps11 (net31 net158 vdda vdda) pmos1 l=2.1e-07n w=1.3e-06u m=1
	mpd11 (net56 inn net31 net31) pmos1 l=180n w=1u m=1
	mp001 (out net158 vdda vdda) pmos1 l=1.7e-07n w=9.4e-07u m=1
	mpd12 (net13 inp net31 net31) pmos1 l=2.4e-07n w=1.8e-06u m=1
	mpb01 (net158 net158 vdda vdda) pmos1 l=180n w=1u m=1
ends OPAMP1_variant985

subckt OPAMP1_variant986 inn inp out pd xpd vdda vssa
	xd1 (vssa vdda) prim_nwd AREA=6.13907e-9 PJ=476.6e-6 m=1
	xi0 (vssa net69) prim_nd AREA=1e-12 PJ=4e-6 m=1
	xi3 (net51 vdda) prim_pd AREA=790e-15 PJ=3.3e-6 m=1
	xr0 (vssa vdda net51) prim_rdiffp l=1.3e-07 w=9.7e-07 m=1
	xr1 (vdda vdda net69) prim_rdiffp l=2.1e-6 w=700e-9 m=1
	xcc01 (net12 out) prim_cpoly c=1p m=1
	mnm12 (net13 net56 vssa vssa) nmos1 l=2.2e-07n w=1.1e-06u m=1
	mnm11 (net56 net56 vssa vssa) nmos1 l=180n w=1u m=1
	mnb02 (net27 net27 net21 vssa) nmos1 l=180n w=1u m=1
	mnpd1 (net21 xpd vssa vssa) nmos1 l=180n w=1u m=1
	mn001 (out net13 vssa vssa) nmos1 l=180n w=1u m=1
	mnpd2 (net13 pd vssa vssa) nmos1 l=180n w=1u m=1
	mnc01 (net13 net69 net12 vssa) nmos1 l=180n w=1u m=1
	mpb02 (net27 net51 net158 vdda) pmos1 l=2.6e-07n w=1.6e-06u m=1
	mppd1 (net158 xpd vdda vdda) pmos1 l=180n w=1u m=1
	mps11 (net31 net158 vdda vdda) pmos1 l=180n w=1u m=1
	mpd11 (net56 inn net31 net31) pmos1 l=180n w=1u m=1
	mp001 (out net158 vdda vdda) pmos1 l=2.0e-07n w=1.3e-06u m=1
	mpd12 (net13 inp net31 net31) pmos1 l=2.2e-07n w=1.0e-06u m=1
	mpb01 (net158 net158 vdda vdda) pmos1 l=180n w=1u m=1
ends OPAMP1_variant986

subckt OPAMP1_variant987 inn inp out pd xpd vdda vssa
	xd1 (vssa vdda) prim_nwd AREA=6.13907e-9 PJ=476.6e-6 m=1
	xi0 (vssa net69) prim_nd AREA=5.5e-09 PJ=5.7e-06 m=1
	xi3 (net51 vdda) prim_pd AREA=790e-15 PJ=3.3e-6 m=1
	xr0 (vssa vdda net51) prim_rdiffp l=2.1e-6 w=700e-9 m=1
	xr1 (vdda vdda net69) prim_rdiffp l=2.1e-6 w=700e-9 m=1
	xcc01 (net12 out) prim_cpoly c=1.9e-12p m=1
	mnm12 (net13 net56 vssa vssa) nmos1 l=180n w=1u m=1
	mnm11 (net56 net56 vssa vssa) nmos1 l=2.4e-07n w=7.8e-07u m=1
	mnb02 (net27 net27 net21 vssa) nmos1 l=180n w=1u m=1
	mnpd1 (net21 xpd vssa vssa) nmos1 l=180n w=1u m=1
	mn001 (out net13 vssa vssa) nmos1 l=180n w=1u m=1
	mnpd2 (net13 pd vssa vssa) nmos1 l=3.0e-07n w=1.8e-06u m=1
	mnc01 (net13 net69 net12 vssa) nmos1 l=1.3e-07n w=5.2e-07u m=1
	mpb02 (net27 net51 net158 vdda) pmos1 l=180n w=1u m=1
	mppd1 (net158 xpd vdda vdda) pmos1 l=180n w=1u m=1
	mps11 (net31 net158 vdda vdda) pmos1 l=180n w=1u m=1
	mpd11 (net56 inn net31 net31) pmos1 l=180n w=1u m=1
	mp001 (out net158 vdda vdda) pmos1 l=180n w=1u m=1
	mpd12 (net13 inp net31 net31) pmos1 l=180n w=1u m=1
	mpb01 (net158 net158 vdda vdda) pmos1 l=180n w=1u m=1
ends OPAMP1_variant987

subckt OPAMP1_variant988 inn inp out pd xpd vdda vssa
	xd1 (vssa vdda) prim_nwd AREA=6.13907e-9 PJ=476.6e-6 m=1
	xi0 (vssa net69) prim_nd AREA=1e-12 PJ=4e-6 m=1
	xi3 (net51 vdda) prim_pd AREA=790e-15 PJ=3.3e-6 m=1
	xr0 (vssa vdda net51) prim_rdiffp l=2.1e-6 w=700e-9 m=1
	xr1 (vdda vdda net69) prim_rdiffp l=2.1e-6 w=700e-9 m=1
	xcc01 (net12 out) prim_cpoly c=1p m=1
	mnm12 (net13 net56 vssa vssa) nmos1 l=180n w=1u m=1
	mnm11 (net56 net56 vssa vssa) nmos1 l=180n w=1u m=1
	mnb02 (net27 net27 net21 vssa) nmos1 l=1.3e-07n w=1.9e-06u m=1
	mnpd1 (net21 xpd vssa vssa) nmos1 l=180n w=1u m=1
	mn001 (out net13 vssa vssa) nmos1 l=180n w=1u m=1
	mnpd2 (net13 pd vssa vssa) nmos1 l=180n w=1u m=1
	mnc01 (net13 net69 net12 vssa) nmos1 l=180n w=1u m=1
	mpb02 (net27 net51 net158 vdda) pmos1 l=180n w=1u m=1
	mppd1 (net158 xpd vdda vdda) pmos1 l=1.4e-07n w=1.3e-06u m=1
	mps11 (net31 net158 vdda vdda) pmos1 l=180n w=1u m=1
	mpd11 (net56 inn net31 net31) pmos1 l=180n w=1u m=1
	mp001 (out net158 vdda vdda) pmos1 l=180n w=1u m=1
	mpd12 (net13 inp net31 net31) pmos1 l=180n w=1u m=1
	mpb01 (net158 net158 vdda vdda) pmos1 l=180n w=1u m=1
ends OPAMP1_variant988

subckt OPAMP1_variant989 inn inp out pd xpd vdda vssa
	xd1 (vssa vdda) prim_nwd AREA=6.13907e-9 PJ=476.6e-6 m=1
	xi0 (vssa net69) prim_nd AREA=1e-12 PJ=4e-6 m=1
	xi3 (net51 vdda) prim_pd AREA=790e-15 PJ=3.3e-6 m=1
	xr0 (vssa vdda net51) prim_rdiffp l=2.1e-6 w=700e-9 m=1
	xr1 (vdda vdda net69) prim_rdiffp l=2.2e-07 w=1.5e-06 m=1
	xcc01 (net12 out) prim_cpoly c=1p m=1
	mnm12 (net13 net56 vssa vssa) nmos1 l=2.7e-07n w=1.1e-06u m=1
	mnm11 (net56 net56 vssa vssa) nmos1 l=180n w=1u m=1
	mnb02 (net27 net27 net21 vssa) nmos1 l=180n w=1u m=1
	mnpd1 (net21 xpd vssa vssa) nmos1 l=180n w=1u m=1
	mn001 (out net13 vssa vssa) nmos1 l=180n w=1u m=1
	mnpd2 (net13 pd vssa vssa) nmos1 l=180n w=1u m=1
	mnc01 (net13 net69 net12 vssa) nmos1 l=180n w=1u m=1
	mpb02 (net27 net51 net158 vdda) pmos1 l=180n w=1u m=1
	mppd1 (net158 xpd vdda vdda) pmos1 l=180n w=1u m=1
	mps11 (net31 net158 vdda vdda) pmos1 l=3.0e-07n w=7.7e-07u m=1
	mpd11 (net56 inn net31 net31) pmos1 l=1.8e-07n w=1.7e-06u m=1
	mp001 (out net158 vdda vdda) pmos1 l=2.1e-07n w=1.4e-06u m=1
	mpd12 (net13 inp net31 net31) pmos1 l=180n w=1u m=1
	mpb01 (net158 net158 vdda vdda) pmos1 l=180n w=1u m=1
ends OPAMP1_variant989

subckt OPAMP1_variant990 inn inp out pd xpd vdda vssa
	xd1 (vssa vdda) prim_nwd AREA=6.13907e-9 PJ=476.6e-6 m=1
	xi0 (vssa net69) prim_nd AREA=4.2e-10 PJ=8.6e-05 m=1
	xi3 (net51 vdda) prim_pd AREA=790e-15 PJ=3.3e-6 m=1
	xr0 (vssa vdda net51) prim_rdiffp l=2.1e-6 w=700e-9 m=1
	xr1 (vdda vdda net69) prim_rdiffp l=2.1e-6 w=700e-9 m=1
	xcc01 (net12 out) prim_cpoly c=1p m=1
	mnm12 (net13 net56 vssa vssa) nmos1 l=1.1e-07n w=1.8e-06u m=1
	mnm11 (net56 net56 vssa vssa) nmos1 l=180n w=1u m=1
	mnb02 (net27 net27 net21 vssa) nmos1 l=180n w=1u m=1
	mnpd1 (net21 xpd vssa vssa) nmos1 l=180n w=1u m=1
	mn001 (out net13 vssa vssa) nmos1 l=180n w=1u m=1
	mnpd2 (net13 pd vssa vssa) nmos1 l=180n w=1u m=1
	mnc01 (net13 net69 net12 vssa) nmos1 l=180n w=1u m=1
	mpb02 (net27 net51 net158 vdda) pmos1 l=180n w=1u m=1
	mppd1 (net158 xpd vdda vdda) pmos1 l=2.7e-07n w=9.6e-07u m=1
	mps11 (net31 net158 vdda vdda) pmos1 l=180n w=1u m=1
	mpd11 (net56 inn net31 net31) pmos1 l=180n w=1u m=1
	mp001 (out net158 vdda vdda) pmos1 l=2.1e-07n w=8.3e-07u m=1
	mpd12 (net13 inp net31 net31) pmos1 l=180n w=1u m=1
	mpb01 (net158 net158 vdda vdda) pmos1 l=1.9e-07n w=5.6e-07u m=1
ends OPAMP1_variant990

subckt OPAMP1_variant991 inn inp out pd xpd vdda vssa
	xd1 (vssa vdda) prim_nwd AREA=6.13907e-9 PJ=476.6e-6 m=1
	xi0 (vssa net69) prim_nd AREA=1e-12 PJ=4e-6 m=1
	xi3 (net51 vdda) prim_pd AREA=790e-15 PJ=3.3e-6 m=1
	xr0 (vssa vdda net51) prim_rdiffp l=2.1e-6 w=700e-9 m=1
	xr1 (vdda vdda net69) prim_rdiffp l=2.1e-6 w=700e-9 m=1
	xcc01 (net12 out) prim_cpoly c=1p m=1
	mnm12 (net13 net56 vssa vssa) nmos1 l=180n w=1u m=1
	mnm11 (net56 net56 vssa vssa) nmos1 l=1.9e-07n w=1.8e-06u m=1
	mnb02 (net27 net27 net21 vssa) nmos1 l=180n w=1u m=1
	mnpd1 (net21 xpd vssa vssa) nmos1 l=2.5e-07n w=1.2e-06u m=1
	mn001 (out net13 vssa vssa) nmos1 l=180n w=1u m=1
	mnpd2 (net13 pd vssa vssa) nmos1 l=180n w=1u m=1
	mnc01 (net13 net69 net12 vssa) nmos1 l=180n w=1u m=1
	mpb02 (net27 net51 net158 vdda) pmos1 l=180n w=1u m=1
	mppd1 (net158 xpd vdda vdda) pmos1 l=180n w=1u m=1
	mps11 (net31 net158 vdda vdda) pmos1 l=180n w=1u m=1
	mpd11 (net56 inn net31 net31) pmos1 l=180n w=1u m=1
	mp001 (out net158 vdda vdda) pmos1 l=180n w=1u m=1
	mpd12 (net13 inp net31 net31) pmos1 l=2.0e-07n w=1.7e-06u m=1
	mpb01 (net158 net158 vdda vdda) pmos1 l=180n w=1u m=1
ends OPAMP1_variant991

subckt OPAMP1_variant992 inn inp out pd xpd vdda vssa
	xd1 (vssa vdda) prim_nwd AREA=6.13907e-9 PJ=476.6e-6 m=1
	xi0 (vssa net69) prim_nd AREA=1e-12 PJ=4e-6 m=1
	xi3 (net51 vdda) prim_pd AREA=790e-15 PJ=3.3e-6 m=1
	xr0 (vssa vdda net51) prim_rdiffp l=2.1e-6 w=700e-9 m=1
	xr1 (vdda vdda net69) prim_rdiffp l=2.1e-6 w=700e-9 m=1
	xcc01 (net12 out) prim_cpoly c=1p m=1
	mnm12 (net13 net56 vssa vssa) nmos1 l=1.1e-07n w=1.0e-06u m=1
	mnm11 (net56 net56 vssa vssa) nmos1 l=180n w=1u m=1
	mnb02 (net27 net27 net21 vssa) nmos1 l=180n w=1u m=1
	mnpd1 (net21 xpd vssa vssa) nmos1 l=180n w=1u m=1
	mn001 (out net13 vssa vssa) nmos1 l=2.8e-07n w=1.8e-06u m=1
	mnpd2 (net13 pd vssa vssa) nmos1 l=180n w=1u m=1
	mnc01 (net13 net69 net12 vssa) nmos1 l=180n w=1u m=1
	mpb02 (net27 net51 net158 vdda) pmos1 l=180n w=1u m=1
	mppd1 (net158 xpd vdda vdda) pmos1 l=180n w=1u m=1
	mps11 (net31 net158 vdda vdda) pmos1 l=180n w=1u m=1
	mpd11 (net56 inn net31 net31) pmos1 l=180n w=1u m=1
	mp001 (out net158 vdda vdda) pmos1 l=180n w=1u m=1
	mpd12 (net13 inp net31 net31) pmos1 l=180n w=1u m=1
	mpb01 (net158 net158 vdda vdda) pmos1 l=180n w=1u m=1
ends OPAMP1_variant992

subckt OPAMP1_variant993 inn inp out pd xpd vdda vssa
	xd1 (vssa vdda) prim_nwd AREA=3.4e-09 PJ=6.6e-05 m=1
	xi0 (vssa net69) prim_nd AREA=1e-12 PJ=4e-6 m=1
	xi3 (net51 vdda) prim_pd AREA=790e-15 PJ=3.3e-6 m=1
	xr0 (vssa vdda net51) prim_rdiffp l=2.1e-6 w=700e-9 m=1
	xr1 (vdda vdda net69) prim_rdiffp l=2.1e-6 w=700e-9 m=1
	xcc01 (net12 out) prim_cpoly c=1p m=1
	mnm12 (net13 net56 vssa vssa) nmos1 l=2.8e-07n w=1.6e-06u m=1
	mnm11 (net56 net56 vssa vssa) nmos1 l=180n w=1u m=1
	mnb02 (net27 net27 net21 vssa) nmos1 l=180n w=1u m=1
	mnpd1 (net21 xpd vssa vssa) nmos1 l=180n w=1u m=1
	mn001 (out net13 vssa vssa) nmos1 l=180n w=1u m=1
	mnpd2 (net13 pd vssa vssa) nmos1 l=180n w=1u m=1
	mnc01 (net13 net69 net12 vssa) nmos1 l=180n w=1u m=1
	mpb02 (net27 net51 net158 vdda) pmos1 l=180n w=1u m=1
	mppd1 (net158 xpd vdda vdda) pmos1 l=180n w=1u m=1
	mps11 (net31 net158 vdda vdda) pmos1 l=2.5e-07n w=1.5e-06u m=1
	mpd11 (net56 inn net31 net31) pmos1 l=180n w=1u m=1
	mp001 (out net158 vdda vdda) pmos1 l=180n w=1u m=1
	mpd12 (net13 inp net31 net31) pmos1 l=180n w=1u m=1
	mpb01 (net158 net158 vdda vdda) pmos1 l=180n w=1u m=1
ends OPAMP1_variant993

subckt OPAMP1_variant994 inn inp out pd xpd vdda vssa
	xd1 (vssa vdda) prim_nwd AREA=6.13907e-9 PJ=476.6e-6 m=1
	xi0 (vssa net69) prim_nd AREA=6.9e-09 PJ=4.9e-06 m=1
	xi3 (net51 vdda) prim_pd AREA=790e-15 PJ=3.3e-6 m=1
	xr0 (vssa vdda net51) prim_rdiffp l=2.1e-6 w=700e-9 m=1
	xr1 (vdda vdda net69) prim_rdiffp l=2.1e-6 w=700e-9 m=1
	xcc01 (net12 out) prim_cpoly c=1p m=1
	mnm12 (net13 net56 vssa vssa) nmos1 l=180n w=1u m=1
	mnm11 (net56 net56 vssa vssa) nmos1 l=180n w=1u m=1
	mnb02 (net27 net27 net21 vssa) nmos1 l=180n w=1u m=1
	mnpd1 (net21 xpd vssa vssa) nmos1 l=180n w=1u m=1
	mn001 (out net13 vssa vssa) nmos1 l=180n w=1u m=1
	mnpd2 (net13 pd vssa vssa) nmos1 l=180n w=1u m=1
	mnc01 (net13 net69 net12 vssa) nmos1 l=180n w=1u m=1
	mpb02 (net27 net51 net158 vdda) pmos1 l=180n w=1u m=1
	mppd1 (net158 xpd vdda vdda) pmos1 l=180n w=1u m=1
	mps11 (net31 net158 vdda vdda) pmos1 l=180n w=1u m=1
	mpd11 (net56 inn net31 net31) pmos1 l=1.5e-07n w=1.7e-06u m=1
	mp001 (out net158 vdda vdda) pmos1 l=180n w=1u m=1
	mpd12 (net13 inp net31 net31) pmos1 l=180n w=1u m=1
	mpb01 (net158 net158 vdda vdda) pmos1 l=180n w=1u m=1
ends OPAMP1_variant994

subckt OPAMP1_variant995 inn inp out pd xpd vdda vssa
	xd1 (vssa vdda) prim_nwd AREA=9.5e-09 PJ=9.0e-05 m=1
	xi0 (vssa net69) prim_nd AREA=1e-12 PJ=4e-6 m=1
	xi3 (net51 vdda) prim_pd AREA=790e-15 PJ=3.3e-6 m=1
	xr0 (vssa vdda net51) prim_rdiffp l=2.1e-6 w=700e-9 m=1
	xr1 (vdda vdda net69) prim_rdiffp l=2.1e-6 w=700e-9 m=1
	xcc01 (net12 out) prim_cpoly c=1p m=1
	mnm12 (net13 net56 vssa vssa) nmos1 l=180n w=1u m=1
	mnm11 (net56 net56 vssa vssa) nmos1 l=180n w=1u m=1
	mnb02 (net27 net27 net21 vssa) nmos1 l=2.9e-07n w=5.9e-07u m=1
	mnpd1 (net21 xpd vssa vssa) nmos1 l=180n w=1u m=1
	mn001 (out net13 vssa vssa) nmos1 l=180n w=1u m=1
	mnpd2 (net13 pd vssa vssa) nmos1 l=180n w=1u m=1
	mnc01 (net13 net69 net12 vssa) nmos1 l=180n w=1u m=1
	mpb02 (net27 net51 net158 vdda) pmos1 l=180n w=1u m=1
	mppd1 (net158 xpd vdda vdda) pmos1 l=1.4e-07n w=1.5e-06u m=1
	mps11 (net31 net158 vdda vdda) pmos1 l=1.7e-07n w=8.7e-07u m=1
	mpd11 (net56 inn net31 net31) pmos1 l=180n w=1u m=1
	mp001 (out net158 vdda vdda) pmos1 l=1.1e-07n w=1.5e-06u m=1
	mpd12 (net13 inp net31 net31) pmos1 l=180n w=1u m=1
	mpb01 (net158 net158 vdda vdda) pmos1 l=180n w=1u m=1
ends OPAMP1_variant995

subckt OPAMP1_variant996 inn inp out pd xpd vdda vssa
	xd1 (vssa vdda) prim_nwd AREA=6.13907e-9 PJ=476.6e-6 m=1
	xi0 (vssa net69) prim_nd AREA=1e-12 PJ=4e-6 m=1
	xi3 (net51 vdda) prim_pd AREA=790e-15 PJ=3.3e-6 m=1
	xr0 (vssa vdda net51) prim_rdiffp l=2.1e-6 w=700e-9 m=1
	xr1 (vdda vdda net69) prim_rdiffp l=2.1e-6 w=700e-9 m=1
	xcc01 (net12 out) prim_cpoly c=1p m=1
	mnm12 (net13 net56 vssa vssa) nmos1 l=180n w=1u m=1
	mnm11 (net56 net56 vssa vssa) nmos1 l=180n w=1u m=1
	mnb02 (net27 net27 net21 vssa) nmos1 l=2.8e-07n w=1.1e-06u m=1
	mnpd1 (net21 xpd vssa vssa) nmos1 l=1.6e-07n w=7.8e-07u m=1
	mn001 (out net13 vssa vssa) nmos1 l=180n w=1u m=1
	mnpd2 (net13 pd vssa vssa) nmos1 l=180n w=1u m=1
	mnc01 (net13 net69 net12 vssa) nmos1 l=180n w=1u m=1
	mpb02 (net27 net51 net158 vdda) pmos1 l=180n w=1u m=1
	mppd1 (net158 xpd vdda vdda) pmos1 l=180n w=1u m=1
	mps11 (net31 net158 vdda vdda) pmos1 l=1.9e-07n w=7.6e-07u m=1
	mpd11 (net56 inn net31 net31) pmos1 l=1.2e-07n w=5.1e-07u m=1
	mp001 (out net158 vdda vdda) pmos1 l=2.0e-07n w=1.6e-06u m=1
	mpd12 (net13 inp net31 net31) pmos1 l=180n w=1u m=1
	mpb01 (net158 net158 vdda vdda) pmos1 l=180n w=1u m=1
ends OPAMP1_variant996

subckt OPAMP1_variant997 inn inp out pd xpd vdda vssa
	xd1 (vssa vdda) prim_nwd AREA=6.13907e-9 PJ=476.6e-6 m=1
	xi0 (vssa net69) prim_nd AREA=1e-12 PJ=4e-6 m=1
	xi3 (net51 vdda) prim_pd AREA=5.2e-09 PJ=9.6e-05 m=1
	xr0 (vssa vdda net51) prim_rdiffp l=2.6e-07 w=1.7e-06 m=1
	xr1 (vdda vdda net69) prim_rdiffp l=2.1e-6 w=700e-9 m=1
	xcc01 (net12 out) prim_cpoly c=1p m=1
	mnm12 (net13 net56 vssa vssa) nmos1 l=180n w=1u m=1
	mnm11 (net56 net56 vssa vssa) nmos1 l=180n w=1u m=1
	mnb02 (net27 net27 net21 vssa) nmos1 l=180n w=1u m=1
	mnpd1 (net21 xpd vssa vssa) nmos1 l=1.1e-07n w=1.5e-06u m=1
	mn001 (out net13 vssa vssa) nmos1 l=180n w=1u m=1
	mnpd2 (net13 pd vssa vssa) nmos1 l=180n w=1u m=1
	mnc01 (net13 net69 net12 vssa) nmos1 l=180n w=1u m=1
	mpb02 (net27 net51 net158 vdda) pmos1 l=180n w=1u m=1
	mppd1 (net158 xpd vdda vdda) pmos1 l=180n w=1u m=1
	mps11 (net31 net158 vdda vdda) pmos1 l=180n w=1u m=1
	mpd11 (net56 inn net31 net31) pmos1 l=1.2e-07n w=5.2e-07u m=1
	mp001 (out net158 vdda vdda) pmos1 l=180n w=1u m=1
	mpd12 (net13 inp net31 net31) pmos1 l=2.4e-07n w=9.7e-07u m=1
	mpb01 (net158 net158 vdda vdda) pmos1 l=180n w=1u m=1
ends OPAMP1_variant997

subckt OPAMP1_variant998 inn inp out pd xpd vdda vssa
	xd1 (vssa vdda) prim_nwd AREA=6.13907e-9 PJ=476.6e-6 m=1
	xi0 (vssa net69) prim_nd AREA=1e-12 PJ=4e-6 m=1
	xi3 (net51 vdda) prim_pd AREA=790e-15 PJ=3.3e-6 m=1
	xr0 (vssa vdda net51) prim_rdiffp l=1.9e-07 w=1.9e-06 m=1
	xr1 (vdda vdda net69) prim_rdiffp l=2.1e-6 w=700e-9 m=1
	xcc01 (net12 out) prim_cpoly c=1p m=1
	mnm12 (net13 net56 vssa vssa) nmos1 l=180n w=1u m=1
	mnm11 (net56 net56 vssa vssa) nmos1 l=1.4e-07n w=1.2e-06u m=1
	mnb02 (net27 net27 net21 vssa) nmos1 l=2.5e-07n w=6.7e-07u m=1
	mnpd1 (net21 xpd vssa vssa) nmos1 l=2.0e-07n w=1.7e-06u m=1
	mn001 (out net13 vssa vssa) nmos1 l=180n w=1u m=1
	mnpd2 (net13 pd vssa vssa) nmos1 l=180n w=1u m=1
	mnc01 (net13 net69 net12 vssa) nmos1 l=180n w=1u m=1
	mpb02 (net27 net51 net158 vdda) pmos1 l=180n w=1u m=1
	mppd1 (net158 xpd vdda vdda) pmos1 l=180n w=1u m=1
	mps11 (net31 net158 vdda vdda) pmos1 l=180n w=1u m=1
	mpd11 (net56 inn net31 net31) pmos1 l=180n w=1u m=1
	mp001 (out net158 vdda vdda) pmos1 l=180n w=1u m=1
	mpd12 (net13 inp net31 net31) pmos1 l=180n w=1u m=1
	mpb01 (net158 net158 vdda vdda) pmos1 l=2.1e-07n w=1.7e-06u m=1
ends OPAMP1_variant998

subckt OPAMP1_variant999 inn inp out pd xpd vdda vssa
	xd1 (vssa vdda) prim_nwd AREA=6.13907e-9 PJ=476.6e-6 m=1
	xi0 (vssa net69) prim_nd AREA=1e-12 PJ=4e-6 m=1
	xi3 (net51 vdda) prim_pd AREA=790e-15 PJ=3.3e-6 m=1
	xr0 (vssa vdda net51) prim_rdiffp l=2.1e-6 w=700e-9 m=1
	xr1 (vdda vdda net69) prim_rdiffp l=1.1e-07 w=1.2e-06 m=1
	xcc01 (net12 out) prim_cpoly c=1p m=1
	mnm12 (net13 net56 vssa vssa) nmos1 l=180n w=1u m=1
	mnm11 (net56 net56 vssa vssa) nmos1 l=3.0e-07n w=1.1e-06u m=1
	mnb02 (net27 net27 net21 vssa) nmos1 l=180n w=1u m=1
	mnpd1 (net21 xpd vssa vssa) nmos1 l=180n w=1u m=1
	mn001 (out net13 vssa vssa) nmos1 l=180n w=1u m=1
	mnpd2 (net13 pd vssa vssa) nmos1 l=180n w=1u m=1
	mnc01 (net13 net69 net12 vssa) nmos1 l=180n w=1u m=1
	mpb02 (net27 net51 net158 vdda) pmos1 l=180n w=1u m=1
	mppd1 (net158 xpd vdda vdda) pmos1 l=180n w=1u m=1
	mps11 (net31 net158 vdda vdda) pmos1 l=180n w=1u m=1
	mpd11 (net56 inn net31 net31) pmos1 l=180n w=1u m=1
	mp001 (out net158 vdda vdda) pmos1 l=180n w=1u m=1
	mpd12 (net13 inp net31 net31) pmos1 l=180n w=1u m=1
	mpb01 (net158 net158 vdda vdda) pmos1 l=2.6e-07n w=1.7e-06u m=1
ends OPAMP1_variant999

subckt OPAMP1_variant1000 inn inp out pd xpd vdda vssa
	xd1 (vssa vdda) prim_nwd AREA=6.13907e-9 PJ=476.6e-6 m=1
	xi0 (vssa net69) prim_nd AREA=8.4e-09 PJ=9.8e-05 m=1
	xi3 (net51 vdda) prim_pd AREA=790e-15 PJ=3.3e-6 m=1
	xr0 (vssa vdda net51) prim_rdiffp l=2.1e-6 w=700e-9 m=1
	xr1 (vdda vdda net69) prim_rdiffp l=2.1e-6 w=700e-9 m=1
	xcc01 (net12 out) prim_cpoly c=1p m=1
	mnm12 (net13 net56 vssa vssa) nmos1 l=1.0e-07n w=1.8e-06u m=1
	mnm11 (net56 net56 vssa vssa) nmos1 l=180n w=1u m=1
	mnb02 (net27 net27 net21 vssa) nmos1 l=180n w=1u m=1
	mnpd1 (net21 xpd vssa vssa) nmos1 l=180n w=1u m=1
	mn001 (out net13 vssa vssa) nmos1 l=2.8e-07n w=1.7e-06u m=1
	mnpd2 (net13 pd vssa vssa) nmos1 l=180n w=1u m=1
	mnc01 (net13 net69 net12 vssa) nmos1 l=180n w=1u m=1
	mpb02 (net27 net51 net158 vdda) pmos1 l=180n w=1u m=1
	mppd1 (net158 xpd vdda vdda) pmos1 l=180n w=1u m=1
	mps11 (net31 net158 vdda vdda) pmos1 l=180n w=1u m=1
	mpd11 (net56 inn net31 net31) pmos1 l=180n w=1u m=1
	mp001 (out net158 vdda vdda) pmos1 l=1.0e-07n w=1.7e-06u m=1
	mpd12 (net13 inp net31 net31) pmos1 l=180n w=1u m=1
	mpb01 (net158 net158 vdda vdda) pmos1 l=180n w=1u m=1
ends OPAMP1_variant1000
