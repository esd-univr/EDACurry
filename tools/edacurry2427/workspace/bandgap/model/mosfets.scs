* Disclaimer:
* THIS FILE IS PROVIDED AS IS AND WITH:
* (A) NO WARRANTY OF ANY KIND, express, implied or statutory, including any implied warranties of merchantability, fitness for a particular purpose and noninfringement, which  Infineon disclaims to the maximum extent permitted by applicable law; and
* (B) NO INDEMNIFICATION FOR INFRINGEMENT OF INTELLECTUAL PROPERTY RIGHTS.
* (C) LIMITATION OF LIABILITY: IN NO EVENT SHALL INFINEON BE LIABLE FOR ANY DIRECT, INDIRECT, SPECIAL, INCIDENTAL, OR CONSEQUENTIAL DAMAGES (INCLUDING LOST PROFITS OR SAVINGS) WHATSOEVER, WHETHER BASED ON CONTRACT, TORT OR ANY OTHER LEGAL THEORY, EVEN IF ADVISED OF THE POSSIBILITY OF SUCH DAMAGES.
* © 2020 Infineon Technologies AG. All rights reserved.

* Note:
* The CMOS transistor models used, were freely available models downloaded from: http://ptm.asu.edu.
* The bipolar transistor models are from: The Development of Bipolar Log-Domain Filters in a Standard CMOS Process, G. D. Duerden, G. W. Roberts, M. J. Deen, 2001

* Release:
* 	version 3.0

* simulator lang = spice
***********************************************************************
* modelcard preg
***********************************************************************

.model preg pmos
+level = 49

+lint = 2.e-08 tox = 3.3e-09
+vth0 = -0.3499 rdsw = 400

+lmin=1.3e-7 lmax=3.0e-7 wmin=1.3e-7 wmax=1.0e-4 tref=27.0 version =3.1
+xj= 4.5000000e-08         nch= 6.8500000e+18
+lln= 0.00                 lwn= 0.00                  wln= 0.00
+wwn= 0.00                 ll= 0.00
+lw= 0.00                  lwl= 0.00                  wint= 0.00
+wl= 0.00                  ww= 0.00                   wwl= 0.00
+mobmod=  1                binunit= 2                 xl=  0
+xw=  0                    binflag=  0
+dwg= 0.00                 dwb= 0.00

+k1= 0.4087000             k2= 0.00
+k3= 0.00                  dvt0= 5.0000000            dvt1= 0.2600000
+dvt2= -1.0000000e-02      dvt0w= 0.00                dvt1w= 0.00
+dvt2w= 0.00               nlx= 1.6500000e-07         w0= 0.00
+k3b= 0.00                 ngate= 5.0000000e+20

+vsat= 1.0500000e+05       ua= -1.4000000e-09         ub= 1.9499999e-18
+uc= -2.9999999e-11        prwb= 0.00
+prwg= 0.00                wr= 1.0000000              u0= 5.2000000e-03
+a0= 2.1199999             keta= 3.0300001e-02        a1= 0.00
+a2= 0.4000000             ags= 0.1000000             b0= 0.00
+b1= 0.00

+voff= -9.10000000e-02     nfactor= 0.1250000         cit= 2.7999999e-03
+cdsc= 0.00                cdscb= 0.00                cdscd= 0.00
+eta0= 80.0000000          etab= 0.00                 dsub= 1.8500000

+pclm= 2.5000000           pdiblc1= 4.8000000e-02     pdiblc2= 5.0000000e-05
+pdiblcb= 0.1432509        drout= 9.0000000e-02       pscbe1= 1.0000000e-20
+pscbe2= 1.0000000e-20     pvag= -6.0000000e-02       delta= 1.0100000e-02
+alpha0= 0.00              beta0= 30.0000000

+kt1= -0.3400000           kt2= -5.2700000e-02        at= 0.00
+ute= -1.2300000           ua1= -8.6300000e-10        ub1= 2.0000001e-18
+uc1= 0.00                 kt1l= 4.0000000e-09        prt= 0.00

+cj= 0.0015                mj= 0.7175511              pb= 1.24859
+cjsw= 2e-10               mjsw= 0.3706993            php= 0.7731149
+cta= 9.290391e-04         ctp= 7.456211e-04          pta= 1.527748e-03
+ptp= 1.56325e-03          js=2.50e-08               jsw=4.00e-13
+n=1.0                     xti=3.0                   cgdo=2.75e-10
+cgso=2.75e-10             cgbo=0.0e+00              capmod= 2
+nqsmod= 0                 elm= 5                    xpart= 1
+cgsl= 1.1155e-10          cgdl= 1.1155e-10          ckappa= 0.8912
+cf= 1.113e-10             clc= 5.475e-08            cle= 6.46
+dlc= 2e-08                dwc= 0                    vfbcv= -1

***********************************************************************
* modelcard nreg
***********************************************************************

.model nreg nmos
+level = 49

+lint = 2.5e-08 tox = 3.3e-09
+vth0 = 0.332 rdsw = 200

+lmin=1.3e-7 lmax=3.0e-7 wmin=1.3e-7 wmax=1.0e-4 tref=27.0 version =3.1
+xj= 4.5000000e-08          nch= 5.6000000e+17
+lln= 1.0000000            lwn= 0.00                  wln= 0.00
+wwn= 1.0000000            ll= 0.00
+lw= 0.00                  lwl= 0.00                  wint= 0.00
+wl= 0.00                  ww= 0.00                   wwl= 0.00
+mobmod= 1                 binunit= 2                 xl= 0
+xw= 0                     binflag=  0
+dwg= 0.00                 dwb= 0.00

+k1= 0.3661500              k2= 0.00
+k3= 0.00                  dvt0= 8.7500000            dvt1= 0.7000000
+dvt2= 5.0000000e-02       dvt0w= 0.00                dvt1w= 0.00
+dvt2w= 0.00               nlx= 3.5500000e-07         w0= 0.00
+k3b= 0.00                 ngate= 5.0000000e+20

+vsat= 1.3500000e+05       ua= -1.8000000e-09         ub= 2.2000000e-18
+uc= -2.9999999e-11        prwb= 0.00
+prwg= 0.00                wr= 1.0000000              u0= 1.3400000e-02
+a0= 2.1199999             keta= 4.0000000e-02        a1= 0.00
+a2= 0.9900000             ags= -0.1000000            b0= 0.00
+b1= 0.00

+voff= -7.9800000e-02      nfactor= 1.1000000         cit= 0.00
+cdsc= 0.00                cdscb= 0.00                cdscd= 0.00
+eta0= 4.0000000e-02       etab= 0.00                 dsub= 0.5200000

+pclm= 0.1000000           pdiblc1= 1.2000000e-02     pdiblc2= 7.5000000e-03
+pdiblcb= -1.3500000e-02   drout= 0.2800000           pscbe1= 8.6600000e+08
+pscbe2= 1.0000000e-20     pvag= -0.2800000           delta= 1.0100000e-02
+alpha0= 0.00              beta0= 30.0000000

+kt1= -0.3400000           kt2= -5.2700000e-02        at= 0.00
+ute= -1.2300000           ua1= -8.6300000e-10        ub1= 2.0000001e-18
+uc1= 0.00                 kt1l= 4.0000000e-09        prt= 0.00

+cj= 0.0015                mj= 0.7175511              pb= 1.24859
+cjsw= 2e-10               mjsw= 0.3706993            php= 0.7731149
+cta= 9.290391e-04         ctp= 7.456211e-04          pta= 1.527748e-03
+ptp= 1.56325e-03          js=2.50e-08                jsw=4.00e-13
+n=1.0                     xti=3.0                    cgdo=2.75e-10
+cgso=2.75e-10             cgbo=0.0e+00               capmod= 2
+nqsmod= 0                 elm= 5                     xpart= 1
+cgsl= 1.1155e-10          cgdl= 1.1155e-10           ckappa= 0.8912
+cf= 1.113e-10             clc= 5.475e-08             cle= 6.46
+dlc= 2e-08                dwc= 0                     vfbcv= -1

***********************************************************************
* modelcard pana
***********************************************************************

* Customized PTM 130nm PMOS
* Leff 400nm, Vth=-0.4, Vdd=2.5, Tox=4nm, Rdsw=240, 10%, 30mV

.model  pana  pmos  level = 54

+version = 4.0    binunit = 1    paramchk= 1    mobmod  = 0
+capmod  = 2      igcmod  = 1    igbmod  = 1    geomod  = 1
+diomod  = 1      rdsmod  = 0    rbodymod= 1    rgatemod= 1
+permod  = 1      acnqsmod= 0    trnqsmod= 0

* parameters related to the technology node
+tnom = 27    epsrox = 3.9
+eta0 = 0.0092    nfactor = 1.5    wint = 5e-09
+cgso = 2.4e-10    cgdo = 2.4e-10    xl = -6e-08

* parameters customized by the user
+toxe = 4.75e-09    toxp = 4e-09    toxm = 4.75e-09    toxref = 4.75e-09
+dtox = 7.5e-10    lint = -1.65e-07
+DLCIG = 1.65e-07
+DLCIGD = 1.65e-07
+vth0 = -0.436    k1 = 0.571    u0 = 0.01287    vsat = 70000
+rdsw = 240    ndep = 5.2e+17    xj = 3.2e-07

*secondary parameters
+ll      = 0            wl      = 0            lln     = 1            wln     = 1
+lw      = 0            ww      = 0            lwn     = 1            wwn     = 1
+lwl     = 0            wwl     = 0            xpart   = 0
+k2      = -0.01        k3      = 0
+k3b     = 0            w0      = 2.5e-006     dvt0    = 1            dvt1    = 2
+dvt2    = -0.032       dvt0w   = 0            dvt1w   = 0            dvt2w   = 0
+dsub    = 0.1          minv    = 0.05         voffl   = 0            dvtp0   = 1e-009
+dvtp1   = 0.05         lpe0    = 0            lpeb    = 0
+ngate   = 2e+020       nsd     = 2e+020       phin    = 0
+cdsc    = 0.000        cdscb   = 0            cdscd   = 0            cit     = 0
+voff    = -0.126       etab    = 0
+vfb     = 0.55         ua      = 2.0e-009     ub      = 0.5e-018
+uc      = 0            a0      = 1.0          ags     = 1e-020
+a1      = 0            a2      = 1            b0      = -1e-020      b1      = 0
+keta    = -0.047       dwg     = 0            dwb     = 0            pclm    = 0.12
+pdiblc1 = 0.001        pdiblc2 = 0.001        pdiblcb = 3.4e-008     drout   = 0.56
+pvag    = 1e-020       delta   = 0.01         pscbe1  = 8.14e+008    pscbe2  = 9.58e-007
+fprout  = 0.2          pdits   = 0.08         pditsd  = 0.23         pditsl  = 2.3e+006
+rsh     = 5            rsw     = 85           rdw     = 85
+rdswmin = 0            rdwmin  = 0            rswmin  = 0            prwg    = 3.22e-008
+prwb    = 6.8e-011     wr      = 1            alpha0  = 0.074        alpha1  = 0.005
+beta0   = 30           agidl   = 0.0002       bgidl   = 2.1e+009     cgidl   = 0.0002
+egidl   = 0.8

+aigbacc = 0.012        bigbacc = 0.0028       cigbacc = 0.002
+nigbacc = 1            aigbinv = 0.014        bigbinv = 0.004        cigbinv = 0.004
+eigbinv = 1.1          nigbinv = 3            aigc    = 0.69         bigc    = 0.0012
+cigc    = 0.0008       aigsd   = 0.0087       bigsd   = 0.0012       cigsd   = 0.0008
+nigc    = 1            poxedge = 1            pigcd   = 1            ntox    = 1

+xrcrg1  = 12           xrcrg2  = 5
+cgbo    = 2.56e-011    cgdl    = 2.653e-10
+cgsl    = 2.653e-10    ckappas = 0.03         ckappad = 0.03         acde    = 1
+moin    = 15           noff    = 0.9          voffcv  = 0.02

+kt1     = -0.11        kt1l    = 0            kt2     = 0.022        ute     = -1.5
+ua1     = 4.31e-009    ub1     = 7.61e-018    uc1     = -5.6e-011    prt     = 0
+at      = 33000

+fnoimod = 1            tnoimod = 0

+jss     = 0.0001       jsws    = 1e-011       jswgs   = 1e-010       njs     = 1
+ijthsfwd= 0.01         ijthsrev= 0.001        bvs     = 10           xjbvs   = 1
+jsd     = 0.0001       jswd    = 1e-011       jswgd   = 1e-010       njd     = 1
+ijthdfwd= 0.01         ijthdrev= 0.001        bvd     = 10           xjbvd   = 1
+pbs     = 1            cjs     = 0.0005       mjs     = 0.5          pbsws   = 1
+cjsws   = 5e-010       mjsws   = 0.33         pbswgs  = 1            cjswgs  = 3e-010
+mjswgs  = 0.33         pbd     = 1            cjd     = 0.0005       mjd     = 0.5
+pbswd   = 1            cjswd   = 5e-010       mjswd   = 0.33         pbswgd  = 1
+cjswgd  = 5e-010       mjswgd  = 0.33         tpb     = 0.005        tcj     = 0.001
+tpbsw   = 0.005        tcjsw   = 0.001        tpbswg  = 0.005        tcjswg  = 0.001
+xtis    = 3            xtid    = 3

+dmcg    = 0e-006       dmci    = 0e-006       dmdg    = 0e-006       dmcgt   = 0e-007
+dwj     = 0.0e-008     xgw     = 0e-007       xgl     = 0e-008

+rshg    = 0.4          gbmin   = 1e-010       rbpb    = 5            rbpd    = 15
+rbps    = 15           rbdb    = 15           rbsb    = 15           ngcon   = 1

***********************************************************************
* modelcard nana
***********************************************************************

* Customized PTM 130nm NMOS
* Leff 400nm, Vth=0.4, Vdd=2.5, Tox=4nm, Rdsw=200, 10%, 30mV

.model  nana  nmos  level = 54

+version = 4.0    binunit = 1    paramchk= 1    mobmod  = 0
+capmod  = 2      igcmod  = 1    igbmod  = 1    geomod  = 1
+diomod  = 1      rdsmod  = 0    rbodymod= 1    rgatemod= 1
+permod  = 1      acnqsmod= 0    trnqsmod= 0

* parameters related to the technology node
+tnom = 27    epsrox = 3.9
+eta0 = 0.0092    nfactor = 1.5    wint = 5e-09
+cgso = 2.4e-10    cgdo = 2.4e-10    xl = -6e-08

* parameters customized by the user
+toxe = 4.65e-09    toxp = 4e-09    toxm = 4.65e-09    toxref = 4.65e-09
+dtox = 6.5e-10    lint = -1.65e-07
+DLCIG = 1.65e-07
+DLCIGD = 1.65e-07
+vth0 = 0.507    k1 = 0.635    u0 = 0.07427    vsat = 100370
+rdsw = 200    ndep = 6.7e+17    xj = 3.2e-07

* secondary parameters
+ll      = 0            wl      = 0            lln     = 1            wln     = 1
+lw      = 0            ww      = 0            lwn     = 1            wwn     = 1
+lwl     = 0            wwl     = 0            xpart   = 0
+k2      = 0.01         k3      = 0
+k3b     = 0            w0      = 2.5e-006     dvt0    = 1            dvt1    = 2
+dvt2    = -0.032       dvt0w   = 0            dvt1w   = 0            dvt2w   = 0
+dsub    = 0.1          minv    = 0.05         voffl   = 0            dvtp0   = 1.0e-009
+dvtp1   = 0.1          lpe0    = 0            lpeb    = 0
+ngate   = 2e+020       nsd     = 2e+020       phin    = 0
+cdsc    = 0.000        cdscb   = 0            cdscd   = 0            cit     = 0
+voff    = -0.13        etab    = 0
+vfb     = -0.55        ua      = 6e-010       ub      = 1.2e-018
+uc      = 0            a0      = 1.0          ags     = 1e-020
+a1      = 0            a2      = 1.0          b0      = 0            b1      = 0
+keta    = 0.04         dwg     = 0            dwb     = 0            pclm    = 0.04
+pdiblc1 = 0.001        pdiblc2 = 0.001        pdiblcb = -0.005       drout   = 0.5
+pvag    = 1e-020       delta   = 0.01         pscbe1  = 8.14e+008    pscbe2  = 1e-007
+fprout  = 0.2          pdits   = 0.08         pditsd  = 0.23         pditsl  = 2.3e+006
+rsh     = 5            rsw     = 85           rdw     = 85
+rdswmin = 0            rdwmin  = 0            rswmin  = 0            prwg    = 0
+prwb    = 6.8e-011     wr      = 1            alpha0  = 0.074        alpha1  = 0.005
+beta0   = 30           agidl   = 0.0002       bgidl   = 2.1e+009     cgidl   = 0.0002
+egidl   = 0.8

+aigbacc = 0.012        bigbacc = 0.0028       cigbacc = 0.002
+nigbacc = 1            aigbinv = 0.014        bigbinv = 0.004        cigbinv = 0.004
+eigbinv = 1.1          nigbinv = 3            aigc    = 0.012        bigc    = 0.0028
+cigc    = 0.002        aigsd   = 0.012        bigsd   = 0.0028       cigsd   = 0.002
+nigc    = 1            poxedge = 1            pigcd   = 1            ntox    = 1

+xrcrg1  = 12           xrcrg2  = 5
+cgbo    = 2.56e-011    cgdl    = 2.653e-10
+cgsl    = 2.653e-10    ckappas = 0.03         ckappad = 0.03         acde    = 1
+moin    = 15           noff    = 0.9          voffcv  = 0.02

+kt1     = -0.11        kt1l    = 0            kt2     = 0.022        ute     = -1.5
+ua1     = 4.31e-009    ub1     = 7.61e-018    uc1     = -5.6e-011    prt     = 0
+at      = 33000

+fnoimod = 1            tnoimod = 0

+jss     = 0.0001       jsws    = 1e-011       jswgs   = 1e-010       njs     = 1
+ijthsfwd= 0.01         ijthsrev= 0.001        bvs     = 10           xjbvs   = 1
+jsd     = 0.0001       jswd    = 1e-011       jswgd   = 1e-010       njd     = 1
+ijthdfwd= 0.01         ijthdrev= 0.001        bvd     = 10           xjbvd   = 1
+pbs     = 1            cjs     = 0.0005       mjs     = 0.5          pbsws   = 1
+cjsws   = 5e-010       mjsws   = 0.33         pbswgs  = 1            cjswgs  = 3e-010
+mjswgs  = 0.33         pbd     = 1            cjd     = 0.0005       mjd     = 0.5
+pbswd   = 1            cjswd   = 5e-010       mjswd   = 0.33         pbswgd  = 1
+cjswgd  = 5e-010       mjswgd  = 0.33         tpb     = 0.005        tcj     = 0.001
+tpbsw   = 0.005        tcjsw   = 0.001        tpbswg  = 0.005        tcjswg  = 0.001
+xtis    = 3            xtid    = 3

+dmcg    = 0e-006       dmci    = 0e-006       dmdg    = 0e-006       dmcgt   = 0e-007
+dwj     = 0.0e-008     xgw     = 0e-007       xgl     = 0e-008

+rshg    = 0.4          gbmin   = 1e-010       rbpb    = 5            rbpd    = 15
+rbps    = 15           rbdb    = 15           rbsb    = 15           ngcon   = 1

***********************************************************************
* modelcard s9mp0a
***********************************************************************

.model s9mp0a pmos level = 54
+version = 4.0    binunit = 1    paramchk= 1    mobmod  = 0
+capmod  = 2      igcmod  = 1    igbmod  = 1    geomod  = 1
+diomod  = 1      rdsmod  = 0    rbodymod= 1    rgatemod= 1
+permod  = 1      acnqsmod= 0    trnqsmod= 0

* parameters related to the technology node
+tnom = 27    epsrox = 3.9
+eta0 = 0.0092    nfactor = 1.5    wint = 5e-09
+cgso = 2.4e-10    cgdo = 2.4e-10    xl = -6e-08

* parameters customized by the user
+toxe = 2.35e-09    toxp = 1.6e-09    toxm = 2.35e-09    toxref = 2.35e-09
+dtox = 7.5e-10    lint = 1.05e-08
+vth0 = -0.337    k1 = 0.433    u0 = 0.00796    vsat = 70000
+rdsw = 240    ndep = 1.22e+18    xj = 3.92e-08

*secondary parameters
+ll      = 0            wl      = 0            lln     = 1            wln     = 1
+lw      = 0            ww      = 0            lwn     = 1            wwn     = 1
+lwl     = 0            wwl     = 0            xpart   = 0
+k2      = -0.01        k3      = 0
+k3b     = 0            w0      = 2.5e-006     dvt0    = 1            dvt1    = 2
+dvt2    = -0.032       dvt0w   = 0            dvt1w   = 0            dvt2w   = 0
+dsub    = 0.1          minv    = 0.05         voffl   = 0            dvtp0   = 1e-009
+dvtp1   = 0.05         lpe0    = 0            lpeb    = 0
+ngate   = 2e+020       nsd     = 2e+020       phin    = 0
+cdsc    = 0.000        cdscb   = 0            cdscd   = 0            cit     = 0
+voff    = -0.126       etab    = 0
+vfb     = 0.55         ua      = 2.0e-009     ub      = 0.5e-018
+uc      = 0            a0      = 1.0          ags     = 1e-020
+a1      = 0            a2      = 1            b0      = -1e-020      b1      = 0
+keta    = -0.047       dwg     = 0            dwb     = 0            pclm    = 0.12
+pdiblc1 = 0.001        pdiblc2 = 0.001        pdiblcb = 3.4e-008     drout   = 0.56
+pvag    = 1e-020       delta   = 0.01         pscbe1  = 8.14e+008    pscbe2  = 9.58e-007
+fprout  = 0.2          pdits   = 0.08         pditsd  = 0.23         pditsl  = 2.3e+006
+rsh     = 5            rsw     = 85           rdw     = 85
+rdswmin = 0            rdwmin  = 0            rswmin  = 0            prwg    = 3.22e-008
+prwb    = 6.8e-011     wr      = 1            alpha0  = 0.074        alpha1  = 0.005
+beta0   = 30           agidl   = 0.0002       bgidl   = 2.1e+009     cgidl   = 0.0002
+egidl   = 0.8

+aigbacc = 0.012        bigbacc = 0.0028       cigbacc = 0.002
+nigbacc = 1            aigbinv = 0.014        bigbinv = 0.004        cigbinv = 0.004
+eigbinv = 1.1          nigbinv = 3            aigc    = 0.69         bigc    = 0.0012
+cigc    = 0.0008       aigsd   = 0.0087       bigsd   = 0.0012       cigsd   = 0.0008
+nigc    = 1            poxedge = 1            pigcd   = 1            ntox    = 1

+xrcrg1  = 12           xrcrg2  = 5
+cgbo    = 2.56e-011    cgdl    = 2.653e-10
+cgsl    = 2.653e-10    ckappas = 0.03         ckappad = 0.03         acde    = 1
+moin    = 15           noff    = 0.9          voffcv  = 0.02

+kt1     = -0.11        kt1l    = 0            kt2     = 0.022        ute     = -1.5
+ua1     = 4.31e-009    ub1     = 7.61e-018    uc1     = -5.6e-011    prt     = 0
+at      = 33000

+fnoimod = 1            tnoimod = 0

+jss     = 0.0001       jsws    = 1e-011       jswgs   = 1e-010       njs     = 1
+ijthsfwd= 0.01         ijthsrev= 0.001        bvs     = 10           xjbvs   = 1
+jsd     = 0.0001       jswd    = 1e-011       jswgd   = 1e-010       njd     = 1
+ijthdfwd= 0.01         ijthdrev= 0.001        bvd     = 10           xjbvd   = 1
+pbs     = 1            cjs     = 0.0005       mjs     = 0.5          pbsws   = 1
+cjsws   = 5e-010       mjsws   = 0.33         pbswgs  = 1            cjswgs  = 3e-010
+mjswgs  = 0.33         pbd     = 1            cjd     = 0.0005       mjd     = 0.5
+pbswd   = 1            cjswd   = 5e-010       mjswd   = 0.33         pbswgd  = 1
+cjswgd  = 5e-010       mjswgd  = 0.33         tpb     = 0.005        tcj     = 0.001
+tpbsw   = 0.005        tcjsw   = 0.001        tpbswg  = 0.005        tcjswg  = 0.001
+xtis    = 3            xtid    = 3

+dmcg    = 0e-006       dmci    = 0e-006       dmdg    = 0e-006       dmcgt   = 0e-007
+dwj     = 0.0e-008     xgw     = 0e-007       xgl     = 0e-008

+rshg    = 0.4          gbmin   = 1e-010       rbpb    = 5            rbpd    = 15
+rbps    = 15           rbdb    = 15           rbsb    = 15           ngcon   = 1

***********************************************************************
* modelcard s9mn0a
***********************************************************************

.model s9mn0a nmos level = 54
+version = 4.0    binunit = 1    paramchk= 1    mobmod  = 0
+capmod  = 2      igcmod  = 1    igbmod  = 1    geomod  = 1
+diomod  = 1      rdsmod  = 0    rbodymod= 1    rgatemod= 1
+permod  = 1      acnqsmod= 0    trnqsmod= 0

* parameters related to the technology node
+tnom = 27    epsrox = 3.9
+eta0 = 0.0092    nfactor = 1.5    wint = 5e-09
+cgso = 2.4e-10    cgdo = 2.4e-10    xl = -6e-08

* parameters customized by the user
+toxe = 2.25e-09    toxp = 1.6e-09    toxm = 2.25e-09    toxref = 2.25e-09
+dtox = 6.5e-10    lint = 1.05e-08
+vth0 = 0.388    k1 = 0.474    u0 = 0.05852    vsat = 100370
+rdsw = 200    ndep = 1.6e+18    xj = 3.92e-08

* secondary parameters
+ll      = 0            wl      = 0            lln     = 1            wln     = 1
+lw      = 0            ww      = 0            lwn     = 1            wwn     = 1
+lwl     = 0            wwl     = 0            xpart   = 0
+k2      = 0.01         k3      = 0
+k3b     = 0            w0      = 2.5e-006     dvt0    = 1            dvt1    = 2
+dvt2    = -0.032       dvt0w   = 0            dvt1w   = 0            dvt2w   = 0
+dsub    = 0.1          minv    = 0.05         voffl   = 0            dvtp0   = 1.0e-009
+dvtp1   = 0.1          lpe0    = 0            lpeb    = 0
+ngate   = 2e+020       nsd     = 2e+020       phin    = 0
+cdsc    = 0.000        cdscb   = 0            cdscd   = 0            cit     = 0
+voff    = -0.13        etab    = 0
+vfb     = -0.55        ua      = 6e-010       ub      = 1.2e-018
+uc      = 0            a0      = 1.0          ags     = 1e-020
+a1      = 0            a2      = 1.0          b0      = 0            b1      = 0
+keta    = 0.04         dwg     = 0            dwb     = 0            pclm    = 0.04
+pdiblc1 = 0.001        pdiblc2 = 0.001        pdiblcb = -0.005       drout   = 0.5
+pvag    = 1e-020       delta   = 0.01         pscbe1  = 8.14e+008    pscbe2  = 1e-007
+fprout  = 0.2          pdits   = 0.08         pditsd  = 0.23         pditsl  = 2.3e+006
+rsh     = 5            rsw     = 85           rdw     = 85
+rdswmin = 0            rdwmin  = 0            rswmin  = 0            prwg    = 0
+prwb    = 6.8e-011     wr      = 1            alpha0  = 0.074        alpha1  = 0.005
+beta0   = 30           agidl   = 0.0002       bgidl   = 2.1e+009     cgidl   = 0.0002
+egidl   = 0.8

+aigbacc = 0.012        bigbacc = 0.0028       cigbacc = 0.002
+nigbacc = 1            aigbinv = 0.014        bigbinv = 0.004        cigbinv = 0.004
+eigbinv = 1.1          nigbinv = 3            aigc    = 0.012        bigc    = 0.0028
+cigc    = 0.002        aigsd   = 0.012        bigsd   = 0.0028       cigsd   = 0.002
+nigc    = 1            poxedge = 1            pigcd   = 1            ntox    = 1

+xrcrg1  = 12           xrcrg2  = 5
+cgbo    = 2.56e-011    cgdl    = 2.653e-10
+cgsl    = 2.653e-10    ckappas = 0.03         ckappad = 0.03         acde    = 1
+moin    = 15           noff    = 0.9          voffcv  = 0.02

+kt1     = -0.11        kt1l    = 0            kt2     = 0.022        ute     = -1.5
+ua1     = 4.31e-009    ub1     = 7.61e-018    uc1     = -5.6e-011    prt     = 0
+at      = 33000

+fnoimod = 1            tnoimod = 0

+jss     = 0.0001       jsws    = 1e-011       jswgs   = 1e-010       njs     = 1
+ijthsfwd= 0.01         ijthsrev= 0.001        bvs     = 10           xjbvs   = 1
+jsd     = 0.0001       jswd    = 1e-011       jswgd   = 1e-010       njd     = 1
+ijthdfwd= 0.01         ijthdrev= 0.001        bvd     = 10           xjbvd   = 1
+pbs     = 1            cjs     = 0.0005       mjs     = 0.5          pbsws   = 1
+cjsws   = 5e-010       mjsws   = 0.33         pbswgs  = 1            cjswgs  = 3e-010
+mjswgs  = 0.33         pbd     = 1            cjd     = 0.0005       mjd     = 0.5
+pbswd   = 1            cjswd   = 5e-010       mjswd   = 0.33         pbswgd  = 1
+cjswgd  = 5e-010       mjswgd  = 0.33         tpb     = 0.005        tcj     = 0.001
+tpbsw   = 0.005        tcjsw   = 0.001        tpbswg  = 0.005        tcjswg  = 0.001
+xtis    = 3            xtid    = 3

+dmcg    = 0e-006       dmci    = 0e-006       dmdg    = 0e-006       dmcgt   = 0e-007
+dwj     = 0.0e-008     xgw     = 0e-007       xgl     = 0e-008

+rshg    = 0.4          gbmin   = 1e-010       rbpb    = 5            rbpd    = 15
+rbps    = 15           rbdb    = 15           rbsb    = 15           ngcon   = 1

***********************************************************************
* modelcard nmoddg
***********************************************************************

.model nmoddg nmos
+level = 49

+lint = 2.5e-08 tox = 3.3e-09
+vth0 = 0.332 rdsw = 200

+lmin=1.3e-7 lmax=3.0e-7 wmin=1.3e-7 wmax=1.0e-4 tref=27.0 version =3.1
+xj= 4.5000000e-08          nch= 5.6000000e+17
+lln= 1.0000000            lwn= 0.00                  wln= 0.00
+wwn= 1.0000000            ll= 0.00
+lw= 0.00                  lwl= 0.00                  wint= 0.00
+wl= 0.00                  ww= 0.00                   wwl= 0.00
+mobmod= 1                 binunit= 2                 xl= 0
+xw= 0                     binflag=  0
+dwg= 0.00                 dwb= 0.00

+k1= 0.3661500              k2= 0.00
+k3= 0.00                  dvt0= 8.7500000            dvt1= 0.7000000
+dvt2= 5.0000000e-02       dvt0w= 0.00                dvt1w= 0.00
+dvt2w= 0.00               nlx= 3.5500000e-07         w0= 0.00
+k3b= 0.00                 ngate= 5.0000000e+20

+vsat= 1.3500000e+05       ua= -1.8000000e-09         ub= 2.2000000e-18
+uc= -2.9999999e-11        prwb= 0.00
+prwg= 0.00                wr= 1.0000000              u0= 1.3400000e-02
+a0= 2.1199999             keta= 4.0000000e-02        a1= 0.00
+a2= 0.9900000             ags= -0.1000000            b0= 0.00
+b1= 0.00

+voff= -7.9800000e-02      nfactor= 1.1000000         cit= 0.00
+cdsc= 0.00                cdscb= 0.00                cdscd= 0.00
+eta0= 4.0000000e-02       etab= 0.00                 dsub= 0.5200000

+pclm= 0.1000000           pdiblc1= 1.2000000e-02     pdiblc2= 7.5000000e-03
+pdiblcb= -1.3500000e-02   drout= 0.2800000           pscbe1= 8.6600000e+08
+pscbe2= 1.0000000e-20     pvag= -0.2800000           delta= 1.0100000e-02
+alpha0= 0.00              beta0= 30.0000000

+kt1= -0.3400000           kt2= -5.2700000e-02        at= 0.00
+ute= -1.2300000           ua1= -8.6300000e-10        ub1= 2.0000001e-18
+uc1= 0.00                 kt1l= 4.0000000e-09        prt= 0.00

+cj= 0.0015                mj= 0.7175511              pb= 1.24859
+cjsw= 2e-10               mjsw= 0.3706993            php= 0.7731149
+cta= 9.290391e-04         ctp= 7.456211e-04          pta= 1.527748e-03
+ptp= 1.56325e-03          js=2.50e-08                jsw=4.00e-13
+n=1.0                     xti=3.0                    cgdo=2.75e-10
+cgso=2.75e-10             cgbo=0.0e+00               capmod= 2
+nqsmod= 0                 elm= 5                     xpart= 1
+cgsl= 1.1155e-10          cgdl= 1.1155e-10           ckappa= 0.8912
+cf= 1.113e-10             clc= 5.475e-08             cle= 6.46
+dlc= 2e-08                dwc= 0                     vfbcv= -1
