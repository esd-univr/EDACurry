* Disclaimer:
* THIS FILE IS PROVIDED AS IS AND WITH:
* (A) NO WARRANTY OF ANY KIND, express, implied or statutory, including any implied warranties of merchantability, fitness for a particular purpose and noninfringement, which  Infineon disclaims to the maximum extent permitted by applicable law; and
* (B) NO INDEMNIFICATION FOR INFRINGEMENT OF INTELLECTUAL PROPERTY RIGHTS.
* (C) LIMITATION OF LIABILITY: IN NO EVENT SHALL INFINEON BE LIABLE FOR ANY DIRECT, INDIRECT, SPECIAL, INCIDENTAL, OR CONSEQUENTIAL DAMAGES (INCLUDING LOST PROFITS OR SAVINGS) WHATSOEVER, WHETHER BASED ON CONTRACT, TORT OR ANY OTHER LEGAL THEORY, EVEN IF ADVISED OF THE POSSIBILITY OF SUCH DAMAGES.
* © 2020 Infineon Technologies AG. All rights reserved.

* Note:
* The CMOS transistor models used, were freely available models downloaded from: http://ptm.asu.edu.
* The bipolar transistor models are from: The Development of Bipolar Log-Domain Filters in a Standard CMOS Process, G. D. Duerden, G. W. Roberts, M. J. Deen, 2001

* Release:
* 	version 2.0

* simulator lang = spice
.model latpnp pnp
+ is=1.8e-15 bf=120 rb=500 re=50 vaf=5  var=3 nf=1.25 ikf=3e-5 tf=100e-12
+ cje=2.5e-15 vje=0.9 mje=0.55 cjc=25e-15 vjc=0.9 mjc=0.55

.model verpnp pnp
+ is=1e-17 bf=15 rb=500 re=50 vaf=40 var=3 nf=1.1 ikf=3e-5 tf=800e-12
+ cje=1.2e-15 vje=0.9 mje=0.55 cjc=10e-15 vjc=0.9 mjc=0.35
